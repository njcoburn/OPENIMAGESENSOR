* RC from verified GDS; capacitive-only nodes eliminated at zero net charge.
.subckt array_pex COL0 COL1 COL2 GND VRESET VDD RST0 ROW0 RST1 ROW1 RST2 ROW2
X0 n255 n210 n329 n182 nfet_03v3 ad=0.44p pd=2.88u as=0.44p ps=2.88u w=1u l=0.5u
D0 n187 n330 diode_nd2ps_03v3 pj=80u area=0.4n
X1 n258 n216 n302 n182 nfet_03v3 ad=0.44p pd=2.88u as=0.44p ps=2.88u w=1u l=0.5u
X2 n307 n199 n5 n178 nfet_03v3 ad=0.44p pd=2.88u as=0.44p ps=2.88u w=1u l=0.5u
D1 n187 n303 diode_nd2ps_03v3 pj=80u area=0.4n
X3 n241 n322 n315 n177 nfet_03v3 ad=0.44p pd=2.88u as=0.44p ps=2.88u w=1u l=0.5u
D2 n176 n267 diode_nd2ps_03v3 pj=80u area=0.4n
X4 n334 n193 n4 n178 nfet_03v3 ad=0.44p pd=2.88u as=0.44p ps=2.88u w=1u l=0.5u
X5 n236 n313 n306 n185 nfet_03v3 ad=0.44p pd=2.88u as=0.44p ps=2.88u w=1u l=0.5u
X6 n252 n222 n275 n182 nfet_03v3 ad=0.44p pd=2.88u as=0.44p ps=2.88u w=1u l=0.5u
X7 n257 n217 n311 n181 nfet_03v3 ad=0.44p pd=2.88u as=0.44p ps=2.88u w=1u l=0.5u
X8 n280 n205 n3 n178 nfet_03v3 ad=0.44p pd=2.88u as=0.44p ps=2.88u w=1u l=0.5u
X9 n235 n286 n279 n185 nfet_03v3 ad=0.44p pd=2.88u as=0.44p ps=2.88u w=1u l=0.5u
D3 n176 n321 diode_nd2ps_03v3 pj=80u area=0.4n
X10 n298 n198 n11 n179 nfet_03v3 ad=0.44p pd=2.88u as=0.44p ps=2.88u w=1u l=0.5u
X11 n325 n192 n10 n179 nfet_03v3 ad=0.44p pd=2.88u as=0.44p ps=2.88u w=1u l=0.5u
X12 n256 n209 n320 n183 nfet_03v3 ad=0.44p pd=2.88u as=0.44p ps=2.88u w=1u l=0.5u
X13 n251 n223 n284 n181 nfet_03v3 ad=0.44p pd=2.88u as=0.44p ps=2.88u w=1u l=0.5u
D4 n176 n294 diode_nd2ps_03v3 pj=80u area=0.4n
X14 n239 n340 n333 n185 nfet_03v3 ad=0.44p pd=2.88u as=0.44p ps=2.88u w=1u l=0.5u
X15 n237 n304 n297 n184 nfet_03v3 ad=0.44p pd=2.88u as=0.44p ps=2.88u w=1u l=0.5u
X16 n289 n197 n17 n180 nfet_03v3 ad=0.44p pd=2.88u as=0.44p ps=2.88u w=1u l=0.5u
X17 n238 n295 n288 n177 nfet_03v3 ad=0.44p pd=2.88u as=0.44p ps=2.88u w=1u l=0.5u
D5 n186 n285 diode_nd2ps_03v3 pj=80u area=0.4n
X18 n271 n204 n9 n179 nfet_03v3 ad=0.44p pd=2.88u as=0.44p ps=2.88u w=1u l=0.5u
X19 n259 n215 n293 n183 nfet_03v3 ad=0.44p pd=2.88u as=0.44p ps=2.88u w=1u l=0.5u
D6 n186 n339 diode_nd2ps_03v3 pj=80u area=0.4n
X20 n234 n277 n270 n184 nfet_03v3 ad=0.44p pd=2.88u as=0.44p ps=2.88u w=1u l=0.5u
D7 n187 n276 diode_nd2ps_03v3 pj=80u area=0.4n
X21 n262 n203 n15 n180 nfet_03v3 ad=0.44p pd=2.88u as=0.44p ps=2.88u w=1u l=0.5u
D8 n186 n312 diode_nd2ps_03v3 pj=80u area=0.4n
X22 n240 n331 n324 n184 nfet_03v3 ad=0.44p pd=2.88u as=0.44p ps=2.88u w=1u l=0.5u
X23 n233 n268 n261 n177 nfet_03v3 ad=0.44p pd=2.88u as=0.44p ps=2.88u w=1u l=0.5u
X24 n254 n211 n338 n181 nfet_03v3 ad=0.44p pd=2.88u as=0.44p ps=2.88u w=1u l=0.5u
X25 n253 n221 n266 n183 nfet_03v3 ad=0.44p pd=2.88u as=0.44p ps=2.88u w=1u l=0.5u
X26 n316 n191 n16 n180 nfet_03v3 ad=0.44p pd=2.88u as=0.44p ps=2.88u w=1u l=0.5u
R0 n189 n191 55.567
R1 n190 n193 37.612
R2 n189 n192 37.612
R3 n190 n189 17.9555
R4 ROW0 n190 8.978
R5 n207 n209 54.892
R6 n208 n211 36.937
R7 n207 n210 36.937
R8 n208 n207 17.9555
R9 RST0 n208 2.228
R10 n195 n197 55.567
R11 n196 n199 37.612
R12 n195 n198 37.612
R13 n196 n195 17.9555
R14 ROW1 n196 8.978
R15 n213 n215 54.892
R16 n214 n217 36.937
R17 n213 n216 36.937
R18 n214 n213 17.9555
R19 RST1 n214 2.228
R20 n13 n15 49.9572
R21 n14 n16 38.7523
R22 n13 n17 38.7523
R23 n14 n13 11.2055
R24 COL2 n14 9.203
R25 n7 n9 49.9572
R26 n8 n10 38.7523
R27 n7 n11 38.7523
R28 n8 n7 11.2055
R29 COL1 n8 9.203
R30 n1 n3 49.9572
R31 n2 n4 38.7523
R32 n1 n5 38.7523
R33 n2 n1 11.2055
R34 COL0 n2 9.203
R35 n201 n203 55.567
R36 n202 n205 37.612
R37 n201 n204 37.612
R38 n202 n201 17.9555
R39 ROW2 n202 8.978
R40 n225 n233 43.0272
R41 n227 n238 43.0272
R42 n230 n241 43.0272
R43 n225 n234 25.0723
R44 n226 n235 25.0723
R45 n227 n237 25.0723
R46 n228 n236 25.0723
R47 n230 n240 25.0723
R48 n231 n239 25.0723
R49 n229 n226 22.8605
R50 n226 n225 17.9555
R51 n228 n227 17.9555
R52 n231 n230 17.9555
R53 n229 n228 11.6555
R54 n232 n231 11.6555
R55 n232 n229 11.2055
R56 VDD n232 8.528
R57 n243 n253 42.3522
R58 n245 n259 42.3522
R59 n248 n256 42.3522
R60 n243 n252 24.3972
R61 n244 n251 24.3972
R62 n245 n258 24.3972
R63 n246 n257 24.3972
R64 n248 n255 24.3972
R65 n249 n254 24.3972
R66 n247 n244 20.1605
R67 n244 n243 17.9555
R68 n246 n245 17.9555
R69 n249 n248 17.9555
R70 n250 n247 11.2055
R71 n247 n246 8.9555
R72 n250 n249 8.9555
R73 VRESET n250 7.853
R74 n219 n221 54.892
R75 n220 n223 36.937
R76 n219 n222 36.937
R77 n220 n219 17.9555
R78 RST2 n220 2.228
R79 n49 n64 385.217
R80 n126 n111 385.217
R81 n150 n139 382.974
R82 n149 n139 382.974
R83 n155 n150 382.974
R84 n155 n149 382.974
R85 n148 n141 382.974
R86 n141 n140 382.974
R87 n142 n140 382.974
R88 n148 n142 382.974
R89 n120 n114 382.974
R90 n114 n113 382.974
R91 n115 n113 382.974
R92 n120 n115 382.974
R93 n58 n53 382.974
R94 n53 n31 382.974
R95 n59 n31 382.974
R96 n59 n58 382.974
R97 n156 n137 382.974
R98 n137 n135 382.974
R99 n157 n135 382.974
R100 n157 n156 382.974
R101 n27 n122 382.974
R102 n122 n112 382.974
R103 n123 n112 382.974
R104 n27 n123 382.974
R105 n92 n85 382.974
R106 n85 n84 382.974
R107 n86 n84 382.974
R108 n92 n86 382.974
R109 n29 n108 382.974
R110 n30 n108 382.974
R111 n30 n109 382.974
R112 n29 n109 382.974
R113 n93 n75 382.974
R114 n94 n75 382.974
R115 n57 n94 382.974
R116 n57 n93 382.974
R117 n80 n99 257.524
R118 n74 n132 257.524
R119 n100 n97 257.524
R120 n43 n101 257.524
R121 n175 n127 257.524
R122 n169 n129 257.524
R123 n186 n154 223.999
R124 n186 n64 223.999
R125 n187 n103 223.999
R126 n187 n111 223.999
R127 n176 n133 223.999
R128 n176 n138 223.999
R129 n67 n154 171.683
R130 n36 n103 171.683
R131 n163 n133 171.683
R132 n181 n88 31.3901
R133 n80 n181 31.3901
R134 n185 n99 31.3901
R135 n74 n185 31.3901
R136 n178 n132 31.3901
R137 n67 n178 31.3901
R138 n49 n182 31.3901
R139 n182 n97 31.3901
R140 n184 n100 31.3901
R141 n43 n184 31.3901
R142 n179 n101 31.3901
R143 n36 n179 31.3901
R144 n183 n126 31.3901
R145 n175 n183 31.3901
R146 n177 n127 31.3901
R147 n169 n177 31.3901
R148 n180 n129 31.3901
R149 n163 n180 31.3901
R150 n166 n131 27.8893
R151 n145 n128 27.8893
R152 n160 n159 27.8893
R153 n62 n61 21.8592
R154 n117 n102 21.8592
R155 n89 n143 21.8592
R156 n24 n23 21.8592
R157 n33 n32 21.8592
R158 n54 n52 21.8592
R159 n78 n18 21.2855
R160 n171 n170 17.4557
R161 n173 n172 17.4557
R162 n38 n37 17.4557
R163 n40 n39 17.4557
R164 n48 n165 17.4557
R165 n65 n63 17.4557
R166 n73 n19 17.4557
R167 n82 n81 17.4557
R168 n130 n125 17.4557
R169 n22 n21 17.4557
R170 n104 n98 17.4557
R171 n45 n44 17.4557
R172 n47 n46 17.4557
R173 n69 n68 17.4557
R174 n72 n71 17.4557
R175 n70 n110 17.4557
R176 n162 n128 17.4557
R177 n161 n160 17.4557
R178 n166 n164 17.4557
R179 n168 n167 17.4557
R180 n174 n105 17.4557
R181 n35 n34 17.4557
R182 n41 n96 17.4557
R183 n51 n50 17.4557
R184 n66 n121 17.4557
R185 n77 n76 17.4557
R186 n79 n78 17.4557
R187 n83 n18 11.2055
R188 n83 n82 10.0805
R189 n70 n18 10.0805
R190 n153 n151 7.5083
R191 n153 n152 7.5083
R192 n147 n144 7.5083
R193 n147 n146 7.5083
R194 n42 n20 7.5083
R195 n60 n42 7.5083
R196 n119 n116 7.5083
R197 n119 n118 7.5083
R198 n136 n134 7.5083
R199 n158 n136 7.5083
R200 n91 n87 7.5083
R201 n91 n90 7.5083
R202 n26 n124 7.5083
R203 n26 n25 7.5083
R204 n28 n106 7.5083
R205 n28 n107 7.5083
R206 n56 n55 7.5083
R207 n56 n95 7.5083
R208 n151 n131 7.4669
R209 n152 n131 7.4669
R210 n145 n144 7.4669
R211 n146 n145 7.4669
R212 n61 n20 7.4669
R213 n61 n60 7.4669
R214 n117 n116 7.4669
R215 n118 n117 7.4669
R216 n159 n134 7.4669
R217 n159 n158 7.4669
R218 n89 n87 7.4669
R219 n90 n89 7.4669
R220 n24 n124 7.4669
R221 n25 n24 7.4669
R222 n32 n106 7.4669
R223 n32 n107 7.4669
R224 n54 n95 7.4669
R225 n55 n54 7.4669
R226 n52 n121 6.0305
R227 n34 n33 6.0305
R228 n38 n102 6.0305
R229 n63 n62 6.0305
R230 n23 n98 6.0305
R231 n69 n143 6.0305
R232 n52 n51 5.1305
R233 n33 n105 5.1305
R234 n172 n102 5.1305
R235 n62 n165 5.1305
R236 n23 n22 5.1305
R237 n46 n143 5.1305
R238 GND n83 4.478
R239 n78 n77 3.3305
R240 n77 n121 3.3305
R241 n51 n96 3.3305
R242 n34 n96 3.3305
R243 n167 n105 3.3305
R244 n167 n166 3.3305
R245 n171 n128 3.3305
R246 n172 n171 3.3305
R247 n39 n38 3.3305
R248 n39 n165 3.3305
R249 n63 n19 3.3305
R250 n82 n19 3.3305
R251 n160 n125 3.3305
R252 n22 n125 3.3305
R253 n45 n98 3.3305
R254 n46 n45 3.3305
R255 n71 n69 3.3305
R256 n71 n70 3.3305
R257 n162 n129 2.54855
R258 n81 n80 2.54855
R259 n74 n73 2.54855
R260 n67 n65 2.54855
R261 n48 n97 2.54855
R262 n43 n40 2.54855
R263 n37 n36 2.54855
R264 n175 n173 2.54855
R265 n170 n169 2.54855
R266 n163 n162 2.54855
R267 n170 n127 2.54855
R268 n173 n126 2.54855
R269 n37 n101 2.54855
R270 n40 n100 2.54855
R271 n49 n48 2.54855
R272 n65 n132 2.54855
R273 n73 n99 2.54855
R274 n81 n88 2.54855
R275 n161 n129 2.54855
R276 n80 n110 2.54855
R277 n74 n72 2.54855
R278 n68 n67 2.54855
R279 n47 n97 2.54855
R280 n44 n43 2.54855
R281 n36 n104 2.54855
R282 n21 n175 2.54855
R283 n169 n130 2.54855
R284 n163 n161 2.54855
R285 n130 n127 2.54855
R286 n21 n126 2.54855
R287 n104 n101 2.54855
R288 n44 n100 2.54855
R289 n49 n47 2.54855
R290 n68 n132 2.54855
R291 n72 n99 2.54855
R292 n110 n88 2.54855
R293 n164 n129 2.54855
R294 n164 n163 2.54855
R295 n168 n127 2.54855
R296 n169 n168 2.54855
R297 n174 n126 2.54855
R298 n175 n174 2.54855
R299 n35 n101 2.54855
R300 n36 n35 2.54855
R301 n41 n100 2.54855
R302 n43 n41 2.54855
R303 n50 n49 2.54855
R304 n50 n97 2.54855
R305 n66 n132 2.54855
R306 n67 n66 2.54855
R307 n76 n99 2.54855
R308 n76 n74 2.54855
R309 n79 n88 2.54855
R310 n80 n79 2.54855
R311 n176 n139 0.12143
R312 n139 n131 0.12143
R313 n149 n138 0.12143
R314 n151 n149 0.12143
R315 n176 n155 0.12143
R316 n155 n153 0.12143
R317 n150 n133 0.12143
R318 n152 n150 0.12143
R319 n186 n57 0.12143
R320 n57 n56 0.12143
R321 n186 n75 0.12143
R322 n54 n75 0.12143
R323 n94 n154 0.12143
R324 n55 n94 0.12143
R325 n93 n64 0.12143
R326 n95 n93 0.12143
R327 n30 n187 0.12143
R328 n32 n30 0.12143
R329 n109 n103 0.12143
R330 n109 n107 0.12143
R331 n111 n108 0.12143
R332 n108 n106 0.12143
R333 n187 n29 0.12143
R334 n29 n28 0.12143
R335 n186 n84 0.12143
R336 n89 n84 0.12143
R337 n86 n154 0.12143
R338 n90 n86 0.12143
R339 n85 n64 0.12143
R340 n87 n85 0.12143
R341 n186 n92 0.12143
R342 n92 n91 0.12143
R343 n187 n112 0.12143
R344 n24 n112 0.12143
R345 n123 n103 0.12143
R346 n25 n123 0.12143
R347 n122 n111 0.12143
R348 n124 n122 0.12143
R349 n187 n27 0.12143
R350 n27 n26 0.12143
R351 n176 n135 0.12143
R352 n159 n135 0.12143
R353 n157 n133 0.12143
R354 n158 n157 0.12143
R355 n138 n137 0.12143
R356 n137 n134 0.12143
R357 n156 n176 0.12143
R358 n156 n136 0.12143
R359 n186 n31 0.12143
R360 n61 n31 0.12143
R361 n59 n154 0.12143
R362 n60 n59 0.12143
R363 n64 n53 0.12143
R364 n53 n20 0.12143
R365 n58 n186 0.12143
R366 n58 n42 0.12143
R367 n187 n113 0.12143
R368 n117 n113 0.12143
R369 n115 n103 0.12143
R370 n118 n115 0.12143
R371 n114 n111 0.12143
R372 n116 n114 0.12143
R373 n187 n120 0.12143
R374 n120 n119 0.12143
R375 n176 n140 0.12143
R376 n145 n140 0.12143
R377 n142 n133 0.12143
R378 n146 n142 0.12143
R379 n141 n138 0.12143
R380 n144 n141 0.12143
R381 n176 n148 0.12143
R382 n148 n147 0.12143
R383 n314 n316 4.7885
R384 n314 n315 4.7885
R385 n319 n317 29.0165
R386 n319 n318 24.199
R387 n317 n319 20.9142
R388 n318 n322 11.3885
R389 n317 n321 6.3005
R390 n317 n320 4.7885
R391 n318 n317 0.2925
R392 n323 n325 4.7885
R393 n323 n324 4.7885
R394 n328 n326 29.0165
R395 n328 n327 24.199
R396 n326 n328 20.9142
R397 n327 n331 11.3885
R398 n326 n330 6.3005
R399 n326 n329 4.7885
R400 n327 n326 0.2925
R401 n332 n334 4.7885
R402 n332 n333 4.7885
R403 n337 n335 29.0165
R404 n337 n336 24.199
R405 n335 n337 20.9142
R406 n336 n340 11.3885
R407 n335 n339 6.3005
R408 n335 n338 4.7885
R409 n336 n335 0.2925
R410 n287 n289 4.7885
R411 n287 n288 4.7885
R412 n292 n290 29.0165
R413 n292 n291 24.199
R414 n290 n292 20.9142
R415 n291 n295 11.3885
R416 n290 n294 6.3005
R417 n290 n293 4.7885
R418 n291 n290 0.2925
R419 n296 n298 4.7885
R420 n296 n297 4.7885
R421 n301 n299 29.0165
R422 n301 n300 24.199
R423 n299 n301 20.9142
R424 n300 n304 11.3885
R425 n299 n303 6.3005
R426 n299 n302 4.7885
R427 n300 n299 0.2925
R428 n305 n307 4.7885
R429 n305 n306 4.7885
R430 n310 n308 29.0165
R431 n310 n309 24.199
R432 n308 n310 20.9142
R433 n309 n313 11.3885
R434 n308 n312 6.3005
R435 n308 n311 4.7885
R436 n309 n308 0.2925
R437 n260 n262 4.7885
R438 n260 n261 4.7885
R439 n265 n263 29.0165
R440 n265 n264 24.199
R441 n263 n265 20.9142
R442 n264 n268 11.3885
R443 n263 n267 6.3005
R444 n263 n266 4.7885
R445 n264 n263 0.2925
R446 n269 n271 4.7885
R447 n269 n270 4.7885
R448 n274 n272 29.0165
R449 n274 n273 24.199
R450 n272 n274 20.9142
R451 n273 n277 11.3885
R452 n272 n276 6.3005
R453 n272 n275 4.7885
R454 n273 n272 0.2925
R455 n278 n280 4.7885
R456 n278 n279 4.7885
R457 n283 n281 29.0165
R458 n283 n282 24.199
R459 n281 n283 20.9142
R460 n282 n286 11.3885
R461 n281 n285 6.3005
R462 n281 n284 4.7885
R463 n282 n281 0.2925
Cpex0 COL0 COL1 0.053404307553f
Cpex1 COL0 ROW0 1.41894296014f
Cpex2 COL0 ROW1 1.48591837032f
Cpex3 COL0 ROW2 1.39047861044f
Cpex4 COL0 RST0 0.562647260857f
Cpex5 COL0 RST1 0.603942548567f
Cpex6 COL0 RST2 0.539306742945f
Cpex7 COL0 VDD 8.23691196895f
Cpex8 COL0 VRESET 2.58890634677f
Cpex9 COL0 n269 0.0105069849942f
Cpex10 COL0 n272 0.0613113149228f
Cpex11 COL0 n278 0.562970459441f
Cpex12 COL0 n281 1.5266620869f
Cpex13 COL0 n296 0.0115063150399f
Cpex14 COL0 n299 0.0646745340347f
Cpex15 COL0 n305 0.611553478536f
Cpex16 COL0 n308 1.55702140097f
Cpex17 COL0 n323 0.0107029825434f
Cpex18 COL0 n326 0.0596013963985f
Cpex19 COL0 n332 0.579368369606f
Cpex20 COL0 n335 1.33910515691f
Cpex21 COL0 GND 46.4532544764f
Cpex22 n1 GND 31.1563f
Cpex23 n2 GND 19.7985f
Cpex24 n3 GND 8.37723f
Cpex25 n4 GND 5.45355f
Cpex26 n5 GND 5.45355f
Cpex27 COL1 COL2 0.0498534203216f
Cpex28 COL1 ROW0 1.4518222926f
Cpex29 COL1 ROW1 1.51052341202f
Cpex30 COL1 ROW2 1.42144558642f
Cpex31 COL1 RST0 0.570378567435f
Cpex32 COL1 RST1 0.598321207126f
Cpex33 COL1 RST2 0.542151141873f
Cpex34 COL1 VDD 8.22343312378f
Cpex35 COL1 VRESET 2.58204157524f
Cpex36 COL1 n260 0.00977520029122f
Cpex37 COL1 n263 0.056179772176f
Cpex38 COL1 n269 0.574987057177f
Cpex39 COL1 n272 1.57947465157f
Cpex40 COL1 n278 0.000224839549397f
Cpex41 COL1 n281 0.00152808560669f
Cpex42 COL1 n287 0.010571607394f
Cpex43 COL1 n290 0.058465260957f
Cpex44 COL1 n296 0.62263698754f
Cpex45 COL1 n299 1.61411849982f
Cpex46 COL1 n305 0.000238564677299f
Cpex47 COL1 n308 0.00162098967307f
Cpex48 COL1 n314 0.00994971070949f
Cpex49 COL1 n317 0.0539076597219f
Cpex50 COL1 n323 0.595479260127f
Cpex51 COL1 n326 1.3924982174f
Cpex52 COL1 n332 0.00024093169446f
Cpex53 COL1 n335 0.000270130214086f
Cpex54 COL1 GND 45.8728492987f
Cpex55 n7 GND 31.7673f
Cpex56 n8 GND 20.1867f
Cpex57 n9 GND 8.54151f
Cpex58 n10 GND 5.5605f
Cpex59 n11 GND 5.5605f
Cpex60 COL2 ROW0 1.25003057659f
Cpex61 COL2 ROW1 1.28185343166f
Cpex62 COL2 ROW2 1.22560152538f
Cpex63 COL2 RST0 0.525000489795f
Cpex64 COL2 RST1 0.545078983942f
Cpex65 COL2 RST2 0.498138581757f
Cpex66 COL2 VDD 8.08760708f
Cpex67 COL2 VRESET 2.44643934715f
Cpex68 COL2 n260 0.58254724663f
Cpex69 COL2 n263 1.46962165934f
Cpex70 COL2 n269 0.000230176757956f
Cpex71 COL2 n272 0.0017411433271f
Cpex72 COL2 n287 0.623816430362f
Cpex73 COL2 n290 1.4916366447f
Cpex74 COL2 n296 0.00024886635278f
Cpex75 COL2 n299 0.00184503819705f
Cpex76 COL2 n314 0.60487452717f
Cpex77 COL2 n317 1.29628264072f
Cpex78 COL2 n323 0.0002523754573f
Cpex79 COL2 n326 0.000286196432742f
Cpex80 COL2 GND 46.5015754595f
Cpex81 n13 GND 31.1561f
Cpex82 n14 GND 19.7983f
Cpex83 n15 GND 8.37717f
Cpex84 n16 GND 5.45352f
Cpex85 n17 GND 5.45352f
Cpex86 ROW0 ROW1 0.000415975201278f
Cpex87 ROW0 RST0 7.98919780494f
Cpex88 ROW0 RST1 0.000492846947944f
Cpex89 ROW0 VDD 1.93434958308f
Cpex90 ROW0 VRESET 8.31004847187f
Cpex91 ROW0 n287 0.000567537910694f
Cpex92 ROW0 n290 0.0116299486079f
Cpex93 ROW0 n296 0.000511182321772f
Cpex94 ROW0 n299 0.0118215920467f
Cpex95 ROW0 n305 0.000518242879555f
Cpex96 ROW0 n308 0.0117551848185f
Cpex97 ROW0 n314 1.00193210135f
Cpex98 ROW0 n317 0.323163798852f
Cpex99 ROW0 n323 1.10163945678f
Cpex100 ROW0 n326 0.292113941868f
Cpex101 ROW0 n332 1.06711159653f
Cpex102 ROW0 n335 0.283633485304f
Cpex103 ROW0 GND 26.4572576134f
Cpex104 n189 GND 25.6775f
Cpex105 n190 GND 18.0765f
Cpex106 n191 GND 2.91998f
Cpex107 n192 GND 1.4525f
Cpex108 n193 GND 1.4525f
Cpex109 ROW1 ROW2 0.000394025458038f
Cpex110 ROW1 RST0 0.0001570917299f
Cpex111 ROW1 RST1 6.19862998928f
Cpex112 ROW1 RST2 0.000450341408066f
Cpex113 ROW1 VDD 1.85997580545f
Cpex114 ROW1 VRESET 6.40070445905f
Cpex115 ROW1 n260 0.000517871027258f
Cpex116 ROW1 n263 0.0113531533081f
Cpex117 ROW1 n269 0.000452352876195f
Cpex118 ROW1 n272 0.0115253833664f
Cpex119 ROW1 n278 0.000464294949431f
Cpex120 ROW1 n281 0.0114810164676f
Cpex121 ROW1 n287 0.987171461015f
Cpex122 ROW1 n290 0.316177776547f
Cpex123 ROW1 n296 1.12297806485f
Cpex124 ROW1 n299 0.3060142587f
Cpex125 ROW1 n305 1.08104805279f
Cpex126 ROW1 n308 0.29222273227f
Cpex127 ROW1 n314 3.46251471566e-05f
Cpex128 ROW1 n317 1.37248926864e-05f
Cpex129 ROW1 n323 2.9290694982e-05f
Cpex130 ROW1 n326 1.16446264588e-05f
Cpex131 ROW1 n332 3.07426763917e-05f
Cpex132 ROW1 n335 1.22196883561e-05f
Cpex133 ROW1 GND 26.7285051085f
Cpex134 n195 GND 26.1983f
Cpex135 n196 GND 18.4431f
Cpex136 n197 GND 2.97921f
Cpex137 n198 GND 1.48196f
Cpex138 n199 GND 1.48196f
Cpex139 ROW2 RST1 0.000149773854363f
Cpex140 ROW2 RST2 7.55387258397f
Cpex141 ROW2 VDD 1.75503874692f
Cpex142 ROW2 VRESET 7.77308935384f
Cpex143 ROW2 n260 0.945342922602f
Cpex144 ROW2 n263 0.294684969799f
Cpex145 ROW2 n269 1.05246986601f
Cpex146 ROW2 n272 0.272303010456f
Cpex147 ROW2 n278 1.01874091344f
Cpex148 ROW2 n281 0.265303645636f
Cpex149 ROW2 n287 3.33279512908e-05f
Cpex150 ROW2 n290 1.31461698605e-05f
Cpex151 ROW2 n296 2.82958505282e-05f
Cpex152 ROW2 n299 1.10240135496e-05f
Cpex153 ROW2 n305 3.00702017785e-05f
Cpex154 ROW2 n308 1.17612798947e-05f
Cpex155 ROW2 GND 25.8914247139f
Cpex156 n201 GND 24.6377f
Cpex157 n202 GND 17.3445f
Cpex158 n203 GND 2.80174f
Cpex159 n204 GND 1.39368f
Cpex160 n205 GND 1.39368f
Cpex161 RST0 RST1 0.000273291811791f
Cpex162 RST0 VDD 1.21958383623f
Cpex163 RST0 VRESET 3.68778346663f
Cpex164 RST0 n287 0.000256299770431f
Cpex165 RST0 n290 0.00534829030867f
Cpex166 RST0 n296 0.000231210383418f
Cpex167 RST0 n299 0.0055773360842f
Cpex168 RST0 n305 0.000231978702393f
Cpex169 RST0 n308 0.00551308613087f
Cpex170 RST0 n314 2.42673755871f
Cpex171 RST0 n317 0.941396118355f
Cpex172 RST0 n323 2.36857328403f
Cpex173 RST0 n326 1.0091166128f
Cpex174 RST0 n332 2.35571749044f
Cpex175 RST0 n335 0.980932298567f
Cpex176 RST0 GND 23.6647376457f
Cpex177 n207 GND 27.1759f
Cpex178 n208 GND 19.033f
Cpex179 n209 GND 0.51822f
Cpex180 n210 GND 1.74727f
Cpex181 n211 GND 1.74727f
Cpex182 RST1 RST2 0.000266885721419f
Cpex183 RST1 VDD 1.22674534716f
Cpex184 RST1 VRESET 3.69630425031f
Cpex185 RST1 n260 0.000242030187808f
Cpex186 RST1 n263 0.00539881918485f
Cpex187 RST1 n269 0.00021176366769f
Cpex188 RST1 n272 0.00562798785061f
Cpex189 RST1 n278 0.000215567534154f
Cpex190 RST1 n281 0.00557396106196f
Cpex191 RST1 n287 1.88873748353f
Cpex192 RST1 n290 0.927693291718f
Cpex193 RST1 n296 1.87039722174f
Cpex194 RST1 n299 1.03054248276f
Cpex195 RST1 n305 1.85380324009f
Cpex196 RST1 n308 0.994982874661f
Cpex197 RST1 n314 3.24509467731e-05f
Cpex198 RST1 n317 1.73819351299e-05f
Cpex199 RST1 n323 3.27895023046e-05f
Cpex200 RST1 n326 1.87247975071e-05f
Cpex201 RST1 n332 3.15459009868e-05f
Cpex202 RST1 n335 1.76577090461e-05f
Cpex203 RST1 GND 23.667376929f
Cpex204 n213 GND 27.8697f
Cpex205 n214 GND 19.5189f
Cpex206 n215 GND 0.53145f
Cpex207 n216 GND 1.79188f
Cpex208 n217 GND 1.79188f
Cpex209 RST2 VDD 1.130309925f
Cpex210 RST2 VRESET 3.51290376476f
Cpex211 RST2 n260 2.27897702559f
Cpex212 RST2 n263 0.891220992676f
Cpex213 RST2 n269 2.23448126768f
Cpex214 RST2 n272 0.967821549109f
Cpex215 RST2 n278 2.22306748351f
Cpex216 RST2 n281 0.939514962893f
Cpex217 RST2 n287 3.11291659613e-05f
Cpex218 RST2 n290 1.72736792856e-05f
Cpex219 RST2 n296 3.15590381956e-05f
Cpex220 RST2 n299 1.87788813285e-05f
Cpex221 RST2 n305 3.0515842278e-05f
Cpex222 RST2 n308 1.77523190506e-05f
Cpex223 RST2 GND 23.1644557007f
Cpex224 n219 GND 26.2582f
Cpex225 n220 GND 18.3903f
Cpex226 n221 GND 0.50072f
Cpex227 n222 GND 1.68827f
Cpex228 n223 GND 1.68827f
Cpex229 VDD VRESET 29.244070354f
Cpex230 VDD n260 0.49666010815f
Cpex231 VDD n263 0.692991194795f
Cpex232 VDD n269 0.508405076634f
Cpex233 VDD n272 0.785576400352f
Cpex234 VDD n278 0.507899372214f
Cpex235 VDD n281 0.823722630007f
Cpex236 VDD n287 0.521110233197f
Cpex237 VDD n290 0.728247548323f
Cpex238 VDD n296 0.538729138657f
Cpex239 VDD n299 0.845304085556f
Cpex240 VDD n305 0.533918367354f
Cpex241 VDD n308 0.878722797084f
Cpex242 VDD n314 0.521641071447f
Cpex243 VDD n317 0.663665963799f
Cpex244 VDD n323 0.529775965499f
Cpex245 VDD n326 0.751739903239f
Cpex246 VDD n332 0.529543441025f
Cpex247 VDD n335 0.785162244296f
Cpex248 VDD GND 96.9109784004f
Cpex249 n225 GND 25.1342f
Cpex250 n226 GND 22.9237f
Cpex251 n227 GND 25.1342f
Cpex252 n228 GND 19.6314f
Cpex253 n229 GND 17.4879f
Cpex254 n230 GND 25.1342f
Cpex255 n231 GND 19.6314f
Cpex256 n232 GND 12.68f
Cpex257 n233 GND 3.86778f
Cpex258 n234 GND 2.85581f
Cpex259 n235 GND 2.85581f
Cpex260 n236 GND 2.85581f
Cpex261 n237 GND 2.85581f
Cpex262 n238 GND 3.86778f
Cpex263 n239 GND 2.85581f
Cpex264 n240 GND 2.85581f
Cpex265 n241 GND 3.86778f
Cpex266 VRESET n260 0.349923986248f
Cpex267 VRESET n263 0.457448044621f
Cpex268 VRESET n269 0.345147956775f
Cpex269 VRESET n272 0.45716940561f
Cpex270 VRESET n278 0.338089002374f
Cpex271 VRESET n281 0.466979764425f
Cpex272 VRESET n287 0.373526912844f
Cpex273 VRESET n290 0.481871142536f
Cpex274 VRESET n296 0.383028061646f
Cpex275 VRESET n299 0.488948397518f
Cpex276 VRESET n305 0.37118120612f
Cpex277 VRESET n308 0.495788495477f
Cpex278 VRESET n314 0.386047797349f
Cpex279 VRESET n317 0.45850109604f
Cpex280 VRESET n323 0.375349431502f
Cpex281 VRESET n326 0.452981579284f
Cpex282 VRESET n332 0.367176745576f
Cpex283 VRESET n335 0.460438760078f
Cpex284 VRESET GND 93.4584446449f
Cpex285 n243 GND 25.4906f
Cpex286 n244 GND 23.035f
Cpex287 n245 GND 25.4906f
Cpex288 n246 GND 19.9524f
Cpex289 n247 GND 17.1595f
Cpex290 n248 GND 25.4906f
Cpex291 n249 GND 19.9524f
Cpex292 n250 GND 12.7256f
Cpex293 n251 GND 2.95906f
Cpex294 n252 GND 2.95906f
Cpex295 n253 GND 2.23311f
Cpex296 n254 GND 2.95906f
Cpex297 n255 GND 2.95906f
Cpex298 n256 GND 2.23311f
Cpex299 n257 GND 2.95906f
Cpex300 n258 GND 2.95906f
Cpex301 n259 GND 2.23311f
Cpex302 n260 n263 2.85790210964f
Cpex303 n260 n269 0.000880096965677f
Cpex304 n260 n272 0.00217371488835f
Cpex305 n260 n287 0.000125353562603f
Cpex306 n260 n290 5.37227433165e-05f
Cpex307 n260 n296 2.02517447287e-06f
Cpex308 n260 n299 2.23449886517e-06f
Cpex309 n260 GND 25.5786466515f
Cpex310 n261 GND 0.88993f
Cpex311 n262 GND 0.88993f
Cpex312 n263 n269 0.00221967549156f
Cpex313 n263 n272 0.0167647264109f
Cpex314 n263 n287 0.00280809480389f
Cpex315 n263 n290 0.00152781859952f
Cpex316 n263 n296 1.10183190433e-05f
Cpex317 n263 n299 1.05757466208e-05f
Cpex318 n263 GND 16.6263381896f
Cpex319 n264 GND 0.07757f
Cpex320 n265 GND 1.38787f
Cpex321 n266 GND 0.01425f
Cpex322 n267 GND 17.0693f
Cpex323 n268 GND 0.02092f
Cpex324 n269 n272 2.88419978624f
Cpex325 n269 n278 0.000878240540009f
Cpex326 n269 n281 0.00200838347865f
Cpex327 n269 n296 0.000108381103451f
Cpex328 n269 n299 4.54499698506e-05f
Cpex329 n269 n305 1.78506126479e-06f
Cpex330 n269 n308 1.92687278452e-06f
Cpex331 n269 GND 24.7440748516f
Cpex332 n270 GND 0.84812f
Cpex333 n271 GND 0.84812f
Cpex334 n272 n278 0.0022029819326f
Cpex335 n272 n281 0.0147394732902f
Cpex336 n272 n287 6.38077470714e-05f
Cpex337 n272 n290 7.13702081794e-05f
Cpex338 n272 n296 0.00275020829496f
Cpex339 n272 n299 0.00150654585574f
Cpex340 n272 n305 9.40139389705e-06f
Cpex341 n272 n308 8.96028670954e-06f
Cpex342 n272 GND 16.7163688759f
Cpex343 n273 GND 0.0767f
Cpex344 n274 GND 1.3723f
Cpex345 n275 GND 0.01409f
Cpex346 n276 GND 16.8778f
Cpex347 n277 GND 0.02068f
Cpex348 n278 n281 2.86494857897f
Cpex349 n278 n305 0.000114742715473f
Cpex350 n278 n308 4.81043040366e-05f
Cpex351 n278 GND 24.6052270207f
Cpex352 n279 GND 0.84436f
Cpex353 n280 GND 0.84436f
Cpex354 n281 n296 5.62678940193e-05f
Cpex355 n281 n299 6.42474982429e-05f
Cpex356 n281 n305 0.00275932092337f
Cpex357 n281 n308 0.00150962014724f
Cpex358 n281 GND 16.4766197145f
Cpex359 n282 GND 0.07447f
Cpex360 n283 GND 1.33246f
Cpex361 n284 GND 0.01368f
Cpex362 n285 GND 16.3879f
Cpex363 n286 GND 0.02008f
Cpex364 n287 n290 2.48479117577f
Cpex365 n287 n296 0.0010259290241f
Cpex366 n287 n299 0.00239184227393f
Cpex367 n287 n314 0.000132773614177f
Cpex368 n287 n317 5.64866496946e-05f
Cpex369 n287 n323 2.08670670115e-06f
Cpex370 n287 n326 2.13285218166e-06f
Cpex371 n287 GND 26.5086222757f
Cpex372 n288 GND 0.93184f
Cpex373 n289 GND 0.93184f
Cpex374 n290 n296 0.00249209720061f
Cpex375 n290 n299 0.0177510108203f
Cpex376 n290 n314 0.00279106795619f
Cpex377 n290 n317 0.00148993936726f
Cpex378 n290 n323 1.163465003e-05f
Cpex379 n290 n326 1.03480730148e-05f
Cpex380 n290 GND 16.5893595739f
Cpex381 n291 GND 0.08675f
Cpex382 n292 GND 1.55211f
Cpex383 n293 GND 0.01594f
Cpex384 n294 GND 19.0894f
Cpex385 n295 GND 0.02339f
Cpex386 n296 n299 2.5571303549f
Cpex387 n296 n305 0.00100840879319f
Cpex388 n296 n308 0.00221592934404f
Cpex389 n296 n323 0.000117293136461f
Cpex390 n296 n326 4.94156132792e-05f
Cpex391 n296 n332 1.86342611113e-06f
Cpex392 n296 n335 1.90612137862e-06f
Cpex393 n296 GND 25.9553647849f
Cpex394 n297 GND 0.90216f
Cpex395 n298 GND 0.90216f
Cpex396 n299 n305 0.00246619255705f
Cpex397 n299 n308 0.0158164673131f
Cpex398 n299 n314 6.2193062398e-05f
Cpex399 n299 n317 6.47468177884e-05f
Cpex400 n299 n323 0.00272558821678f
Cpex401 n299 n326 0.00146154470772f
Cpex402 n299 n332 1.00458522323e-05f
Cpex403 n299 n335 9.06524466475e-06f
Cpex404 n299 GND 16.7532946903f
Cpex405 n300 GND 0.08662f
Cpex406 n301 GND 1.54992f
Cpex407 n302 GND 0.01591f
Cpex408 n303 GND 19.0624f
Cpex409 n304 GND 0.02336f
Cpex410 n305 n308 2.53010209866f
Cpex411 n305 n332 0.000123072817769f
Cpex412 n305 n335 5.16103540491e-05f
Cpex413 n305 GND 25.7767002186f
Cpex414 n306 GND 0.89712f
Cpex415 n307 GND 0.89712f
Cpex416 n308 n323 5.48129114933e-05f
Cpex417 n308 n326 5.74641783967e-05f
Cpex418 n308 n332 0.00273310186873f
Cpex419 n308 n335 0.00147040423605f
Cpex420 n308 GND 16.4972490484f
Cpex421 n309 GND 0.08437f
Cpex422 n310 GND 1.50958f
Cpex423 n311 GND 0.0155f
Cpex424 n312 GND 18.5663f
Cpex425 n313 GND 0.02275f
Cpex426 n314 n317 3.02498009133f
Cpex427 n314 n323 0.000953092958277f
Cpex428 n314 n326 0.00226433383747f
Cpex429 n314 GND 26.5858287465f
Cpex430 n315 GND 0.93323f
Cpex431 n316 GND 0.93323f
Cpex432 n317 n323 0.00238702049617f
Cpex433 n317 n326 0.0171173926317f
Cpex434 n317 GND 16.876142664f
Cpex435 n318 GND 0.07972f
Cpex436 n319 GND 1.42632f
Cpex437 n320 GND 0.01465f
Cpex438 n321 GND 17.5423f
Cpex439 n322 GND 0.0215f
Cpex440 n323 n326 3.02504842459f
Cpex441 n323 n332 0.000923363877277f
Cpex442 n323 n335 0.00209978565068f
Cpex443 n323 GND 25.7233719932f
Cpex444 n324 GND 0.8886f
Cpex445 n325 GND 0.8886f
Cpex446 n326 n332 0.00229446611419f
Cpex447 n326 n335 0.015187705441f
Cpex448 n326 GND 16.9394306085f
Cpex449 n327 GND 0.07835f
Cpex450 n328 GND 1.40185f
Cpex451 n329 GND 0.01439f
Cpex452 n330 GND 17.2413f
Cpex453 n331 GND 0.02113f
Cpex454 n332 n335 3.00437626132f
Cpex455 n332 GND 25.5232469588f
Cpex456 n333 GND 0.88306f
Cpex457 n334 GND 0.88306f
Cpex458 n335 GND 16.697803939f
Cpex459 n336 GND 0.07617f
Cpex460 n337 GND 1.36295f
Cpex461 n338 GND 0.01399f
Cpex462 n339 GND 16.7628f
Cpex463 n340 GND 0.02054f
.ends array_pex
