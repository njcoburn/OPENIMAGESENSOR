* Same extracted capacitance with ideal wires.
.subckt array_c COL0 COL1 COL2 GND VRESET VDD RST0 ROW0 RST1 ROW1 RST2 ROW2
X0 VRESET RST0 s01 GND nfet_03v3 ad=0.44p pd=2.88u as=0.44p ps=2.88u w=1u l=0.5u
D0 GND s01 diode_nd2ps_03v3 pj=80u area=0.4n
X1 VRESET RST1 s11 GND nfet_03v3 ad=0.44p pd=2.88u as=0.44p ps=2.88u w=1u l=0.5u
X2 f10 ROW1 COL0 GND nfet_03v3 ad=0.44p pd=2.88u as=0.44p ps=2.88u w=1u l=0.5u
D1 GND s11 diode_nd2ps_03v3 pj=80u area=0.4n
X3 VDD s02 f02 GND nfet_03v3 ad=0.44p pd=2.88u as=0.44p ps=2.88u w=1u l=0.5u
D2 GND s22 diode_nd2ps_03v3 pj=80u area=0.4n
X4 f00 ROW0 COL0 GND nfet_03v3 ad=0.44p pd=2.88u as=0.44p ps=2.88u w=1u l=0.5u
X5 VDD s10 f10 GND nfet_03v3 ad=0.44p pd=2.88u as=0.44p ps=2.88u w=1u l=0.5u
X6 VRESET RST2 s21 GND nfet_03v3 ad=0.44p pd=2.88u as=0.44p ps=2.88u w=1u l=0.5u
X7 VRESET RST1 s10 GND nfet_03v3 ad=0.44p pd=2.88u as=0.44p ps=2.88u w=1u l=0.5u
X8 f20 ROW2 COL0 GND nfet_03v3 ad=0.44p pd=2.88u as=0.44p ps=2.88u w=1u l=0.5u
X9 VDD s20 f20 GND nfet_03v3 ad=0.44p pd=2.88u as=0.44p ps=2.88u w=1u l=0.5u
D3 GND s02 diode_nd2ps_03v3 pj=80u area=0.4n
X10 f11 ROW1 COL1 GND nfet_03v3 ad=0.44p pd=2.88u as=0.44p ps=2.88u w=1u l=0.5u
X11 f01 ROW0 COL1 GND nfet_03v3 ad=0.44p pd=2.88u as=0.44p ps=2.88u w=1u l=0.5u
X12 VRESET RST0 s02 GND nfet_03v3 ad=0.44p pd=2.88u as=0.44p ps=2.88u w=1u l=0.5u
X13 VRESET RST2 s20 GND nfet_03v3 ad=0.44p pd=2.88u as=0.44p ps=2.88u w=1u l=0.5u
D4 GND s12 diode_nd2ps_03v3 pj=80u area=0.4n
X14 VDD s00 f00 GND nfet_03v3 ad=0.44p pd=2.88u as=0.44p ps=2.88u w=1u l=0.5u
X15 VDD s11 f11 GND nfet_03v3 ad=0.44p pd=2.88u as=0.44p ps=2.88u w=1u l=0.5u
X16 f12 ROW1 COL2 GND nfet_03v3 ad=0.44p pd=2.88u as=0.44p ps=2.88u w=1u l=0.5u
X17 VDD s12 f12 GND nfet_03v3 ad=0.44p pd=2.88u as=0.44p ps=2.88u w=1u l=0.5u
D5 GND s20 diode_nd2ps_03v3 pj=80u area=0.4n
X18 f21 ROW2 COL1 GND nfet_03v3 ad=0.44p pd=2.88u as=0.44p ps=2.88u w=1u l=0.5u
X19 VRESET RST1 s12 GND nfet_03v3 ad=0.44p pd=2.88u as=0.44p ps=2.88u w=1u l=0.5u
D6 GND s00 diode_nd2ps_03v3 pj=80u area=0.4n
X20 VDD s21 f21 GND nfet_03v3 ad=0.44p pd=2.88u as=0.44p ps=2.88u w=1u l=0.5u
D7 GND s21 diode_nd2ps_03v3 pj=80u area=0.4n
X21 f22 ROW2 COL2 GND nfet_03v3 ad=0.44p pd=2.88u as=0.44p ps=2.88u w=1u l=0.5u
D8 GND s10 diode_nd2ps_03v3 pj=80u area=0.4n
X22 VDD s01 f01 GND nfet_03v3 ad=0.44p pd=2.88u as=0.44p ps=2.88u w=1u l=0.5u
X23 VDD s22 f22 GND nfet_03v3 ad=0.44p pd=2.88u as=0.44p ps=2.88u w=1u l=0.5u
X24 VRESET RST0 s00 GND nfet_03v3 ad=0.44p pd=2.88u as=0.44p ps=2.88u w=1u l=0.5u
X25 VRESET RST2 s22 GND nfet_03v3 ad=0.44p pd=2.88u as=0.44p ps=2.88u w=1u l=0.5u
X26 f02 ROW0 COL2 GND nfet_03v3 ad=0.44p pd=2.88u as=0.44p ps=2.88u w=1u l=0.5u
Cpex0 COL0 COL1 0.053404307553f
Cpex1 COL0 ROW0 1.41894296014f
Cpex2 COL0 ROW1 1.48591837032f
Cpex3 COL0 ROW2 1.39047861044f
Cpex4 COL0 RST0 0.562647260857f
Cpex5 COL0 RST1 0.603942548567f
Cpex6 COL0 RST2 0.539306742945f
Cpex7 COL0 VDD 8.23691196895f
Cpex8 COL0 VRESET 2.58890634677f
Cpex9 COL0 f21 0.0105069849942f
Cpex10 COL0 s21 0.0613113149228f
Cpex11 COL0 f20 0.562970459441f
Cpex12 COL0 s20 1.5266620869f
Cpex13 COL0 f11 0.0115063150399f
Cpex14 COL0 s11 0.0646745340347f
Cpex15 COL0 f10 0.611553478536f
Cpex16 COL0 s10 1.55702140097f
Cpex17 COL0 f01 0.0107029825434f
Cpex18 COL0 s01 0.0596013963985f
Cpex19 COL0 f00 0.579368369606f
Cpex20 COL0 s00 1.33910515691f
Cpex21 COL0 GND 46.4532544764f
Cpex22 COL0 GND 31.1563f
Cpex23 COL0 GND 19.7985f
Cpex24 COL0 GND 8.37723f
Cpex25 COL0 GND 5.45355f
Cpex26 COL0 GND 5.45355f
Cpex27 COL1 COL2 0.0498534203216f
Cpex28 COL1 ROW0 1.4518222926f
Cpex29 COL1 ROW1 1.51052341202f
Cpex30 COL1 ROW2 1.42144558642f
Cpex31 COL1 RST0 0.570378567435f
Cpex32 COL1 RST1 0.598321207126f
Cpex33 COL1 RST2 0.542151141873f
Cpex34 COL1 VDD 8.22343312378f
Cpex35 COL1 VRESET 2.58204157524f
Cpex36 COL1 f22 0.00977520029122f
Cpex37 COL1 s22 0.056179772176f
Cpex38 COL1 f21 0.574987057177f
Cpex39 COL1 s21 1.57947465157f
Cpex40 COL1 f20 0.000224839549397f
Cpex41 COL1 s20 0.00152808560669f
Cpex42 COL1 f12 0.010571607394f
Cpex43 COL1 s12 0.058465260957f
Cpex44 COL1 f11 0.62263698754f
Cpex45 COL1 s11 1.61411849982f
Cpex46 COL1 f10 0.000238564677299f
Cpex47 COL1 s10 0.00162098967307f
Cpex48 COL1 f02 0.00994971070949f
Cpex49 COL1 s02 0.0539076597219f
Cpex50 COL1 f01 0.595479260127f
Cpex51 COL1 s01 1.3924982174f
Cpex52 COL1 f00 0.00024093169446f
Cpex53 COL1 s00 0.000270130214086f
Cpex54 COL1 GND 45.8728492987f
Cpex55 COL1 GND 31.7673f
Cpex56 COL1 GND 20.1867f
Cpex57 COL1 GND 8.54151f
Cpex58 COL1 GND 5.5605f
Cpex59 COL1 GND 5.5605f
Cpex60 COL2 ROW0 1.25003057659f
Cpex61 COL2 ROW1 1.28185343166f
Cpex62 COL2 ROW2 1.22560152538f
Cpex63 COL2 RST0 0.525000489795f
Cpex64 COL2 RST1 0.545078983942f
Cpex65 COL2 RST2 0.498138581757f
Cpex66 COL2 VDD 8.08760708f
Cpex67 COL2 VRESET 2.44643934715f
Cpex68 COL2 f22 0.58254724663f
Cpex69 COL2 s22 1.46962165934f
Cpex70 COL2 f21 0.000230176757956f
Cpex71 COL2 s21 0.0017411433271f
Cpex72 COL2 f12 0.623816430362f
Cpex73 COL2 s12 1.4916366447f
Cpex74 COL2 f11 0.00024886635278f
Cpex75 COL2 s11 0.00184503819705f
Cpex76 COL2 f02 0.60487452717f
Cpex77 COL2 s02 1.29628264072f
Cpex78 COL2 f01 0.0002523754573f
Cpex79 COL2 s01 0.000286196432742f
Cpex80 COL2 GND 46.5015754595f
Cpex81 COL2 GND 31.1561f
Cpex82 COL2 GND 19.7983f
Cpex83 COL2 GND 8.37717f
Cpex84 COL2 GND 5.45352f
Cpex85 COL2 GND 5.45352f
Cpex86 ROW0 ROW1 0.000415975201278f
Cpex87 ROW0 RST0 7.98919780494f
Cpex88 ROW0 RST1 0.000492846947944f
Cpex89 ROW0 VDD 1.93434958308f
Cpex90 ROW0 VRESET 8.31004847187f
Cpex91 ROW0 f12 0.000567537910694f
Cpex92 ROW0 s12 0.0116299486079f
Cpex93 ROW0 f11 0.000511182321772f
Cpex94 ROW0 s11 0.0118215920467f
Cpex95 ROW0 f10 0.000518242879555f
Cpex96 ROW0 s10 0.0117551848185f
Cpex97 ROW0 f02 1.00193210135f
Cpex98 ROW0 s02 0.323163798852f
Cpex99 ROW0 f01 1.10163945678f
Cpex100 ROW0 s01 0.292113941868f
Cpex101 ROW0 f00 1.06711159653f
Cpex102 ROW0 s00 0.283633485304f
Cpex103 ROW0 GND 26.4572576134f
Cpex104 ROW0 GND 25.6775f
Cpex105 ROW0 GND 18.0765f
Cpex106 ROW0 GND 2.91998f
Cpex107 ROW0 GND 1.4525f
Cpex108 ROW0 GND 1.4525f
Cpex109 ROW1 ROW2 0.000394025458038f
Cpex110 ROW1 RST0 0.0001570917299f
Cpex111 ROW1 RST1 6.19862998928f
Cpex112 ROW1 RST2 0.000450341408066f
Cpex113 ROW1 VDD 1.85997580545f
Cpex114 ROW1 VRESET 6.40070445905f
Cpex115 ROW1 f22 0.000517871027258f
Cpex116 ROW1 s22 0.0113531533081f
Cpex117 ROW1 f21 0.000452352876195f
Cpex118 ROW1 s21 0.0115253833664f
Cpex119 ROW1 f20 0.000464294949431f
Cpex120 ROW1 s20 0.0114810164676f
Cpex121 ROW1 f12 0.987171461015f
Cpex122 ROW1 s12 0.316177776547f
Cpex123 ROW1 f11 1.12297806485f
Cpex124 ROW1 s11 0.3060142587f
Cpex125 ROW1 f10 1.08104805279f
Cpex126 ROW1 s10 0.29222273227f
Cpex127 ROW1 f02 3.46251471566e-05f
Cpex128 ROW1 s02 1.37248926864e-05f
Cpex129 ROW1 f01 2.9290694982e-05f
Cpex130 ROW1 s01 1.16446264588e-05f
Cpex131 ROW1 f00 3.07426763917e-05f
Cpex132 ROW1 s00 1.22196883561e-05f
Cpex133 ROW1 GND 26.7285051085f
Cpex134 ROW1 GND 26.1983f
Cpex135 ROW1 GND 18.4431f
Cpex136 ROW1 GND 2.97921f
Cpex137 ROW1 GND 1.48196f
Cpex138 ROW1 GND 1.48196f
Cpex139 ROW2 RST1 0.000149773854363f
Cpex140 ROW2 RST2 7.55387258397f
Cpex141 ROW2 VDD 1.75503874692f
Cpex142 ROW2 VRESET 7.77308935384f
Cpex143 ROW2 f22 0.945342922602f
Cpex144 ROW2 s22 0.294684969799f
Cpex145 ROW2 f21 1.05246986601f
Cpex146 ROW2 s21 0.272303010456f
Cpex147 ROW2 f20 1.01874091344f
Cpex148 ROW2 s20 0.265303645636f
Cpex149 ROW2 f12 3.33279512908e-05f
Cpex150 ROW2 s12 1.31461698605e-05f
Cpex151 ROW2 f11 2.82958505282e-05f
Cpex152 ROW2 s11 1.10240135496e-05f
Cpex153 ROW2 f10 3.00702017785e-05f
Cpex154 ROW2 s10 1.17612798947e-05f
Cpex155 ROW2 GND 25.8914247139f
Cpex156 ROW2 GND 24.6377f
Cpex157 ROW2 GND 17.3445f
Cpex158 ROW2 GND 2.80174f
Cpex159 ROW2 GND 1.39368f
Cpex160 ROW2 GND 1.39368f
Cpex161 RST0 RST1 0.000273291811791f
Cpex162 RST0 VDD 1.21958383623f
Cpex163 RST0 VRESET 3.68778346663f
Cpex164 RST0 f12 0.000256299770431f
Cpex165 RST0 s12 0.00534829030867f
Cpex166 RST0 f11 0.000231210383418f
Cpex167 RST0 s11 0.0055773360842f
Cpex168 RST0 f10 0.000231978702393f
Cpex169 RST0 s10 0.00551308613087f
Cpex170 RST0 f02 2.42673755871f
Cpex171 RST0 s02 0.941396118355f
Cpex172 RST0 f01 2.36857328403f
Cpex173 RST0 s01 1.0091166128f
Cpex174 RST0 f00 2.35571749044f
Cpex175 RST0 s00 0.980932298567f
Cpex176 RST0 GND 23.6647376457f
Cpex177 RST0 GND 27.1759f
Cpex178 RST0 GND 19.033f
Cpex179 RST0 GND 0.51822f
Cpex180 RST0 GND 1.74727f
Cpex181 RST0 GND 1.74727f
Cpex182 RST1 RST2 0.000266885721419f
Cpex183 RST1 VDD 1.22674534716f
Cpex184 RST1 VRESET 3.69630425031f
Cpex185 RST1 f22 0.000242030187808f
Cpex186 RST1 s22 0.00539881918485f
Cpex187 RST1 f21 0.00021176366769f
Cpex188 RST1 s21 0.00562798785061f
Cpex189 RST1 f20 0.000215567534154f
Cpex190 RST1 s20 0.00557396106196f
Cpex191 RST1 f12 1.88873748353f
Cpex192 RST1 s12 0.927693291718f
Cpex193 RST1 f11 1.87039722174f
Cpex194 RST1 s11 1.03054248276f
Cpex195 RST1 f10 1.85380324009f
Cpex196 RST1 s10 0.994982874661f
Cpex197 RST1 f02 3.24509467731e-05f
Cpex198 RST1 s02 1.73819351299e-05f
Cpex199 RST1 f01 3.27895023046e-05f
Cpex200 RST1 s01 1.87247975071e-05f
Cpex201 RST1 f00 3.15459009868e-05f
Cpex202 RST1 s00 1.76577090461e-05f
Cpex203 RST1 GND 23.667376929f
Cpex204 RST1 GND 27.8697f
Cpex205 RST1 GND 19.5189f
Cpex206 RST1 GND 0.53145f
Cpex207 RST1 GND 1.79188f
Cpex208 RST1 GND 1.79188f
Cpex209 RST2 VDD 1.130309925f
Cpex210 RST2 VRESET 3.51290376476f
Cpex211 RST2 f22 2.27897702559f
Cpex212 RST2 s22 0.891220992676f
Cpex213 RST2 f21 2.23448126768f
Cpex214 RST2 s21 0.967821549109f
Cpex215 RST2 f20 2.22306748351f
Cpex216 RST2 s20 0.939514962893f
Cpex217 RST2 f12 3.11291659613e-05f
Cpex218 RST2 s12 1.72736792856e-05f
Cpex219 RST2 f11 3.15590381956e-05f
Cpex220 RST2 s11 1.87788813285e-05f
Cpex221 RST2 f10 3.0515842278e-05f
Cpex222 RST2 s10 1.77523190506e-05f
Cpex223 RST2 GND 23.1644557007f
Cpex224 RST2 GND 26.2582f
Cpex225 RST2 GND 18.3903f
Cpex226 RST2 GND 0.50072f
Cpex227 RST2 GND 1.68827f
Cpex228 RST2 GND 1.68827f
Cpex229 VDD VRESET 29.244070354f
Cpex230 VDD f22 0.49666010815f
Cpex231 VDD s22 0.692991194795f
Cpex232 VDD f21 0.508405076634f
Cpex233 VDD s21 0.785576400352f
Cpex234 VDD f20 0.507899372214f
Cpex235 VDD s20 0.823722630007f
Cpex236 VDD f12 0.521110233197f
Cpex237 VDD s12 0.728247548323f
Cpex238 VDD f11 0.538729138657f
Cpex239 VDD s11 0.845304085556f
Cpex240 VDD f10 0.533918367354f
Cpex241 VDD s10 0.878722797084f
Cpex242 VDD f02 0.521641071447f
Cpex243 VDD s02 0.663665963799f
Cpex244 VDD f01 0.529775965499f
Cpex245 VDD s01 0.751739903239f
Cpex246 VDD f00 0.529543441025f
Cpex247 VDD s00 0.785162244296f
Cpex248 VDD GND 96.9109784004f
Cpex249 VDD GND 25.1342f
Cpex250 VDD GND 22.9237f
Cpex251 VDD GND 25.1342f
Cpex252 VDD GND 19.6314f
Cpex253 VDD GND 17.4879f
Cpex254 VDD GND 25.1342f
Cpex255 VDD GND 19.6314f
Cpex256 VDD GND 12.68f
Cpex257 VDD GND 3.86778f
Cpex258 VDD GND 2.85581f
Cpex259 VDD GND 2.85581f
Cpex260 VDD GND 2.85581f
Cpex261 VDD GND 2.85581f
Cpex262 VDD GND 3.86778f
Cpex263 VDD GND 2.85581f
Cpex264 VDD GND 2.85581f
Cpex265 VDD GND 3.86778f
Cpex266 VRESET f22 0.349923986248f
Cpex267 VRESET s22 0.457448044621f
Cpex268 VRESET f21 0.345147956775f
Cpex269 VRESET s21 0.45716940561f
Cpex270 VRESET f20 0.338089002374f
Cpex271 VRESET s20 0.466979764425f
Cpex272 VRESET f12 0.373526912844f
Cpex273 VRESET s12 0.481871142536f
Cpex274 VRESET f11 0.383028061646f
Cpex275 VRESET s11 0.488948397518f
Cpex276 VRESET f10 0.37118120612f
Cpex277 VRESET s10 0.495788495477f
Cpex278 VRESET f02 0.386047797349f
Cpex279 VRESET s02 0.45850109604f
Cpex280 VRESET f01 0.375349431502f
Cpex281 VRESET s01 0.452981579284f
Cpex282 VRESET f00 0.367176745576f
Cpex283 VRESET s00 0.460438760078f
Cpex284 VRESET GND 93.4584446449f
Cpex285 VRESET GND 25.4906f
Cpex286 VRESET GND 23.035f
Cpex287 VRESET GND 25.4906f
Cpex288 VRESET GND 19.9524f
Cpex289 VRESET GND 17.1595f
Cpex290 VRESET GND 25.4906f
Cpex291 VRESET GND 19.9524f
Cpex292 VRESET GND 12.7256f
Cpex293 VRESET GND 2.95906f
Cpex294 VRESET GND 2.95906f
Cpex295 VRESET GND 2.23311f
Cpex296 VRESET GND 2.95906f
Cpex297 VRESET GND 2.95906f
Cpex298 VRESET GND 2.23311f
Cpex299 VRESET GND 2.95906f
Cpex300 VRESET GND 2.95906f
Cpex301 VRESET GND 2.23311f
Cpex302 f22 s22 2.85790210964f
Cpex303 f22 f21 0.000880096965677f
Cpex304 f22 s21 0.00217371488835f
Cpex305 f22 f12 0.000125353562603f
Cpex306 f22 s12 5.37227433165e-05f
Cpex307 f22 f11 2.02517447287e-06f
Cpex308 f22 s11 2.23449886517e-06f
Cpex309 f22 GND 25.5786466515f
Cpex310 f22 GND 0.88993f
Cpex311 f22 GND 0.88993f
Cpex312 s22 f21 0.00221967549156f
Cpex313 s22 s21 0.0167647264109f
Cpex314 s22 f12 0.00280809480389f
Cpex315 s22 s12 0.00152781859952f
Cpex316 s22 f11 1.10183190433e-05f
Cpex317 s22 s11 1.05757466208e-05f
Cpex318 s22 GND 16.6263381896f
Cpex319 s22 GND 0.07757f
Cpex320 s22 GND 1.38787f
Cpex321 s22 GND 0.01425f
Cpex322 s22 GND 17.0693f
Cpex323 s22 GND 0.02092f
Cpex324 f21 s21 2.88419978624f
Cpex325 f21 f20 0.000878240540009f
Cpex326 f21 s20 0.00200838347865f
Cpex327 f21 f11 0.000108381103451f
Cpex328 f21 s11 4.54499698506e-05f
Cpex329 f21 f10 1.78506126479e-06f
Cpex330 f21 s10 1.92687278452e-06f
Cpex331 f21 GND 24.7440748516f
Cpex332 f21 GND 0.84812f
Cpex333 f21 GND 0.84812f
Cpex334 s21 f20 0.0022029819326f
Cpex335 s21 s20 0.0147394732902f
Cpex336 s21 f12 6.38077470714e-05f
Cpex337 s21 s12 7.13702081794e-05f
Cpex338 s21 f11 0.00275020829496f
Cpex339 s21 s11 0.00150654585574f
Cpex340 s21 f10 9.40139389705e-06f
Cpex341 s21 s10 8.96028670954e-06f
Cpex342 s21 GND 16.7163688759f
Cpex343 s21 GND 0.0767f
Cpex344 s21 GND 1.3723f
Cpex345 s21 GND 0.01409f
Cpex346 s21 GND 16.8778f
Cpex347 s21 GND 0.02068f
Cpex348 f20 s20 2.86494857897f
Cpex349 f20 f10 0.000114742715473f
Cpex350 f20 s10 4.81043040366e-05f
Cpex351 f20 GND 24.6052270207f
Cpex352 f20 GND 0.84436f
Cpex353 f20 GND 0.84436f
Cpex354 s20 f11 5.62678940193e-05f
Cpex355 s20 s11 6.42474982429e-05f
Cpex356 s20 f10 0.00275932092337f
Cpex357 s20 s10 0.00150962014724f
Cpex358 s20 GND 16.4766197145f
Cpex359 s20 GND 0.07447f
Cpex360 s20 GND 1.33246f
Cpex361 s20 GND 0.01368f
Cpex362 s20 GND 16.3879f
Cpex363 s20 GND 0.02008f
Cpex364 f12 s12 2.48479117577f
Cpex365 f12 f11 0.0010259290241f
Cpex366 f12 s11 0.00239184227393f
Cpex367 f12 f02 0.000132773614177f
Cpex368 f12 s02 5.64866496946e-05f
Cpex369 f12 f01 2.08670670115e-06f
Cpex370 f12 s01 2.13285218166e-06f
Cpex371 f12 GND 26.5086222757f
Cpex372 f12 GND 0.93184f
Cpex373 f12 GND 0.93184f
Cpex374 s12 f11 0.00249209720061f
Cpex375 s12 s11 0.0177510108203f
Cpex376 s12 f02 0.00279106795619f
Cpex377 s12 s02 0.00148993936726f
Cpex378 s12 f01 1.163465003e-05f
Cpex379 s12 s01 1.03480730148e-05f
Cpex380 s12 GND 16.5893595739f
Cpex381 s12 GND 0.08675f
Cpex382 s12 GND 1.55211f
Cpex383 s12 GND 0.01594f
Cpex384 s12 GND 19.0894f
Cpex385 s12 GND 0.02339f
Cpex386 f11 s11 2.5571303549f
Cpex387 f11 f10 0.00100840879319f
Cpex388 f11 s10 0.00221592934404f
Cpex389 f11 f01 0.000117293136461f
Cpex390 f11 s01 4.94156132792e-05f
Cpex391 f11 f00 1.86342611113e-06f
Cpex392 f11 s00 1.90612137862e-06f
Cpex393 f11 GND 25.9553647849f
Cpex394 f11 GND 0.90216f
Cpex395 f11 GND 0.90216f
Cpex396 s11 f10 0.00246619255705f
Cpex397 s11 s10 0.0158164673131f
Cpex398 s11 f02 6.2193062398e-05f
Cpex399 s11 s02 6.47468177884e-05f
Cpex400 s11 f01 0.00272558821678f
Cpex401 s11 s01 0.00146154470772f
Cpex402 s11 f00 1.00458522323e-05f
Cpex403 s11 s00 9.06524466475e-06f
Cpex404 s11 GND 16.7532946903f
Cpex405 s11 GND 0.08662f
Cpex406 s11 GND 1.54992f
Cpex407 s11 GND 0.01591f
Cpex408 s11 GND 19.0624f
Cpex409 s11 GND 0.02336f
Cpex410 f10 s10 2.53010209866f
Cpex411 f10 f00 0.000123072817769f
Cpex412 f10 s00 5.16103540491e-05f
Cpex413 f10 GND 25.7767002186f
Cpex414 f10 GND 0.89712f
Cpex415 f10 GND 0.89712f
Cpex416 s10 f01 5.48129114933e-05f
Cpex417 s10 s01 5.74641783967e-05f
Cpex418 s10 f00 0.00273310186873f
Cpex419 s10 s00 0.00147040423605f
Cpex420 s10 GND 16.4972490484f
Cpex421 s10 GND 0.08437f
Cpex422 s10 GND 1.50958f
Cpex423 s10 GND 0.0155f
Cpex424 s10 GND 18.5663f
Cpex425 s10 GND 0.02275f
Cpex426 f02 s02 3.02498009133f
Cpex427 f02 f01 0.000953092958277f
Cpex428 f02 s01 0.00226433383747f
Cpex429 f02 GND 26.5858287465f
Cpex430 f02 GND 0.93323f
Cpex431 f02 GND 0.93323f
Cpex432 s02 f01 0.00238702049617f
Cpex433 s02 s01 0.0171173926317f
Cpex434 s02 GND 16.876142664f
Cpex435 s02 GND 0.07972f
Cpex436 s02 GND 1.42632f
Cpex437 s02 GND 0.01465f
Cpex438 s02 GND 17.5423f
Cpex439 s02 GND 0.0215f
Cpex440 f01 s01 3.02504842459f
Cpex441 f01 f00 0.000923363877277f
Cpex442 f01 s00 0.00209978565068f
Cpex443 f01 GND 25.7233719932f
Cpex444 f01 GND 0.8886f
Cpex445 f01 GND 0.8886f
Cpex446 s01 f00 0.00229446611419f
Cpex447 s01 s00 0.015187705441f
Cpex448 s01 GND 16.9394306085f
Cpex449 s01 GND 0.07835f
Cpex450 s01 GND 1.40185f
Cpex451 s01 GND 0.01439f
Cpex452 s01 GND 17.2413f
Cpex453 s01 GND 0.02113f
Cpex454 f00 s00 3.00437626132f
Cpex455 f00 GND 25.5232469588f
Cpex456 f00 GND 0.88306f
Cpex457 f00 GND 0.88306f
Cpex458 s00 GND 16.697803939f
Cpex459 s00 GND 0.07617f
Cpex460 s00 GND 1.36295f
Cpex461 s00 GND 0.01399f
Cpex462 s00 GND 16.7628f
Cpex463 s00 GND 0.02054f
.ends array_c
