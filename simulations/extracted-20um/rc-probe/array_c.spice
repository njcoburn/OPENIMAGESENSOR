* Same extracted capacitance with ideal wires.
.subckt array_c COL0 COL1 COL2 GND VRESET VDD RST0 ROW0 RST1 ROW1 RST2 ROW2
X0 VRESET RST0 s01 GND nfet_03v3 ad=0.44p pd=2.88u as=0.44p ps=2.88u w=1u l=0.5u
D0 GND s01 diode_nd2ps_03v3 pj=80u area=0.4n
X1 VRESET RST1 s11 GND nfet_03v3 ad=0.44p pd=2.88u as=0.44p ps=2.88u w=1u l=0.5u
X2 f10 ROW1 COL0 GND nfet_03v3 ad=0.44p pd=2.88u as=0.44p ps=2.88u w=1u l=0.5u
D1 GND s11 diode_nd2ps_03v3 pj=80u area=0.4n
X3 VDD s02 f02 GND nfet_03v3 ad=0.44p pd=2.88u as=0.44p ps=2.88u w=1u l=0.5u
D2 GND s22 diode_nd2ps_03v3 pj=80u area=0.4n
X4 f00 ROW0 COL0 GND nfet_03v3 ad=0.44p pd=2.88u as=0.44p ps=2.88u w=1u l=0.5u
X5 VDD s10 f10 GND nfet_03v3 ad=0.44p pd=2.88u as=0.44p ps=2.88u w=1u l=0.5u
X6 VRESET RST2 s21 GND nfet_03v3 ad=0.44p pd=2.88u as=0.44p ps=2.88u w=1u l=0.5u
X7 VRESET RST1 s10 GND nfet_03v3 ad=0.44p pd=2.88u as=0.44p ps=2.88u w=1u l=0.5u
X8 f20 ROW2 COL0 GND nfet_03v3 ad=0.44p pd=2.88u as=0.44p ps=2.88u w=1u l=0.5u
X9 VDD s20 f20 GND nfet_03v3 ad=0.44p pd=2.88u as=0.44p ps=2.88u w=1u l=0.5u
D3 GND s02 diode_nd2ps_03v3 pj=80u area=0.4n
X10 f11 ROW1 COL1 GND nfet_03v3 ad=0.44p pd=2.88u as=0.44p ps=2.88u w=1u l=0.5u
X11 f01 ROW0 COL1 GND nfet_03v3 ad=0.44p pd=2.88u as=0.44p ps=2.88u w=1u l=0.5u
X12 VRESET RST0 s02 GND nfet_03v3 ad=0.44p pd=2.88u as=0.44p ps=2.88u w=1u l=0.5u
X13 VRESET RST2 s20 GND nfet_03v3 ad=0.44p pd=2.88u as=0.44p ps=2.88u w=1u l=0.5u
D4 GND s12 diode_nd2ps_03v3 pj=80u area=0.4n
X14 VDD s00 f00 GND nfet_03v3 ad=0.44p pd=2.88u as=0.44p ps=2.88u w=1u l=0.5u
X15 VDD s11 f11 GND nfet_03v3 ad=0.44p pd=2.88u as=0.44p ps=2.88u w=1u l=0.5u
X16 f12 ROW1 COL2 GND nfet_03v3 ad=0.44p pd=2.88u as=0.44p ps=2.88u w=1u l=0.5u
X17 VDD s12 f12 GND nfet_03v3 ad=0.44p pd=2.88u as=0.44p ps=2.88u w=1u l=0.5u
D5 GND s20 diode_nd2ps_03v3 pj=80u area=0.4n
X18 f21 ROW2 COL1 GND nfet_03v3 ad=0.44p pd=2.88u as=0.44p ps=2.88u w=1u l=0.5u
X19 VRESET RST1 s12 GND nfet_03v3 ad=0.44p pd=2.88u as=0.44p ps=2.88u w=1u l=0.5u
D6 GND s00 diode_nd2ps_03v3 pj=80u area=0.4n
X20 VDD s21 f21 GND nfet_03v3 ad=0.44p pd=2.88u as=0.44p ps=2.88u w=1u l=0.5u
D7 GND s21 diode_nd2ps_03v3 pj=80u area=0.4n
X21 f22 ROW2 COL2 GND nfet_03v3 ad=0.44p pd=2.88u as=0.44p ps=2.88u w=1u l=0.5u
D8 GND s10 diode_nd2ps_03v3 pj=80u area=0.4n
X22 VDD s01 f01 GND nfet_03v3 ad=0.44p pd=2.88u as=0.44p ps=2.88u w=1u l=0.5u
X23 VDD s22 f22 GND nfet_03v3 ad=0.44p pd=2.88u as=0.44p ps=2.88u w=1u l=0.5u
X24 VRESET RST0 s00 GND nfet_03v3 ad=0.44p pd=2.88u as=0.44p ps=2.88u w=1u l=0.5u
X25 VRESET RST2 s22 GND nfet_03v3 ad=0.44p pd=2.88u as=0.44p ps=2.88u w=1u l=0.5u
X26 f02 ROW0 COL2 GND nfet_03v3 ad=0.44p pd=2.88u as=0.44p ps=2.88u w=1u l=0.5u
Cpex0 COL0 ROW0 0.65205f
Cpex1 COL0 ROW1 0.65205f
Cpex2 COL0 ROW2 0.65205f
Cpex3 COL0 RST0 0.13627f
Cpex4 COL0 RST1 0.13627f
Cpex5 COL0 RST2 0.13627f
Cpex6 COL0 VDD 3.89151f
Cpex7 COL0 VRESET 0.41762f
Cpex8 COL0 f20 0.2326f
Cpex9 COL0 s20 0.80901f
Cpex10 COL0 f10 0.2326f
Cpex11 COL0 s10 0.80901f
Cpex12 COL0 f00 0.2326f
Cpex13 COL0 s00 0.74265f
Cpex14 COL0 GND 25.78633f
Cpex15 COL0 GND 3.98869f
Cpex16 COL0 GND 2.53464f
Cpex17 COL0 GND 1.07247f
Cpex18 COL0 GND 0.69818f
Cpex19 COL0 GND 0.69818f
Cpex20 COL1 ROW0 0.65205f
Cpex21 COL1 ROW1 0.65205f
Cpex22 COL1 ROW2 0.65205f
Cpex23 COL1 RST0 0.13627f
Cpex24 COL1 RST1 0.13627f
Cpex25 COL1 RST2 0.13627f
Cpex26 COL1 VDD 3.89151f
Cpex27 COL1 VRESET 0.41762f
Cpex28 COL1 f21 0.2326f
Cpex29 COL1 s21 0.80901f
Cpex30 COL1 f11 0.2326f
Cpex31 COL1 s11 0.80901f
Cpex32 COL1 f01 0.2326f
Cpex33 COL1 s01 0.74265f
Cpex34 COL1 GND 25.78633f
Cpex35 COL1 GND 3.98869f
Cpex36 COL1 GND 2.53464f
Cpex37 COL1 GND 1.07247f
Cpex38 COL1 GND 0.69818f
Cpex39 COL1 GND 0.69818f
Cpex40 COL2 ROW0 0.65127f
Cpex41 COL2 ROW1 0.65127f
Cpex42 COL2 ROW2 0.65127f
Cpex43 COL2 RST0 0.1355f
Cpex44 COL2 RST1 0.1355f
Cpex45 COL2 RST2 0.1355f
Cpex46 COL2 VDD 3.88917f
Cpex47 COL2 VRESET 0.41529f
Cpex48 COL2 f22 0.2326f
Cpex49 COL2 s22 0.80901f
Cpex50 COL2 f12 0.2326f
Cpex51 COL2 s12 0.80901f
Cpex52 COL2 f02 0.2326f
Cpex53 COL2 s02 0.74265f
Cpex54 COL2 GND 25.80921f
Cpex55 COL2 GND 3.98486f
Cpex56 COL2 GND 2.53221f
Cpex57 COL2 GND 1.07144f
Cpex58 COL2 GND 0.6975f
Cpex59 COL2 GND 0.6975f
Cpex60 ROW0 RST0 4.14771f
Cpex61 ROW0 VDD 0.21087f
Cpex62 ROW0 VRESET 4.15562f
Cpex63 ROW0 f02 0.44365f
Cpex64 ROW0 s02 0.06422f
Cpex65 ROW0 f01 0.44365f
Cpex66 ROW0 s01 0.06422f
Cpex67 ROW0 f00 0.44365f
Cpex68 ROW0 s00 0.06422f
Cpex69 ROW0 GND 13.10426f
Cpex70 ROW0 GND 5.68693f
Cpex71 ROW0 GND 4.00349f
Cpex72 ROW0 GND 0.6467f
Cpex73 ROW0 GND 0.32169f
Cpex74 ROW0 GND 0.32169f
Cpex75 ROW1 RST1 4.14771f
Cpex76 ROW1 VDD 0.21087f
Cpex77 ROW1 VRESET 4.15562f
Cpex78 ROW1 f12 0.44365f
Cpex79 ROW1 s12 0.06422f
Cpex80 ROW1 f11 0.44365f
Cpex81 ROW1 s11 0.06422f
Cpex82 ROW1 f10 0.44365f
Cpex83 ROW1 s10 0.06422f
Cpex84 ROW1 GND 13.10426f
Cpex85 ROW1 GND 5.68693f
Cpex86 ROW1 GND 4.00349f
Cpex87 ROW1 GND 0.6467f
Cpex88 ROW1 GND 0.32169f
Cpex89 ROW1 GND 0.32169f
Cpex90 ROW2 RST2 4.14771f
Cpex91 ROW2 VDD 0.21087f
Cpex92 ROW2 VRESET 4.15562f
Cpex93 ROW2 f22 0.44365f
Cpex94 ROW2 s22 0.06422f
Cpex95 ROW2 f21 0.44365f
Cpex96 ROW2 s21 0.06422f
Cpex97 ROW2 f20 0.44365f
Cpex98 ROW2 s20 0.06422f
Cpex99 ROW2 GND 13.10426f
Cpex100 ROW2 GND 5.68693f
Cpex101 ROW2 GND 4.00349f
Cpex102 ROW2 GND 0.6467f
Cpex103 ROW2 GND 0.32169f
Cpex104 ROW2 GND 0.32169f
Cpex105 RST0 VDD 0.21011f
Cpex106 RST0 VRESET 1.54347f
Cpex107 RST0 f02 1.22333f
Cpex108 RST0 s02 0.37545f
Cpex109 RST0 f01 1.22333f
Cpex110 RST0 s01 0.37545f
Cpex111 RST0 f00 1.22333f
Cpex112 RST0 s00 0.37545f
Cpex113 RST0 GND 12.8197f
Cpex114 RST0 GND 5.82696f
Cpex115 RST0 GND 4.08099f
Cpex116 RST0 GND 0.11112f
Cpex117 RST0 GND 0.37464f
Cpex118 RST0 GND 0.37464f
Cpex119 RST1 VDD 0.21011f
Cpex120 RST1 VRESET 1.54347f
Cpex121 RST1 f12 1.22333f
Cpex122 RST1 s12 0.37545f
Cpex123 RST1 f11 1.22333f
Cpex124 RST1 s11 0.37545f
Cpex125 RST1 f10 1.22333f
Cpex126 RST1 s10 0.37545f
Cpex127 RST1 GND 12.8197f
Cpex128 RST1 GND 5.82696f
Cpex129 RST1 GND 4.08099f
Cpex130 RST1 GND 0.11112f
Cpex131 RST1 GND 0.37464f
Cpex132 RST1 GND 0.37464f
Cpex133 RST2 VDD 0.21011f
Cpex134 RST2 VRESET 1.54347f
Cpex135 RST2 f22 1.22333f
Cpex136 RST2 s22 0.37545f
Cpex137 RST2 f21 1.22333f
Cpex138 RST2 s21 0.37545f
Cpex139 RST2 f20 1.22333f
Cpex140 RST2 s20 0.37545f
Cpex141 RST2 GND 12.8197f
Cpex142 RST2 GND 5.82696f
Cpex143 RST2 GND 4.08099f
Cpex144 RST2 GND 0.11112f
Cpex145 RST2 GND 0.37464f
Cpex146 RST2 GND 0.37464f
Cpex147 VDD VRESET 16.1958f
Cpex148 VDD f22 0.21834f
Cpex149 VDD s22 0.37742f
Cpex150 VDD f21 0.21834f
Cpex151 VDD s21 0.37742f
Cpex152 VDD f20 0.21834f
Cpex153 VDD s20 0.37742f
Cpex154 VDD f12 0.21834f
Cpex155 VDD s12 0.37742f
Cpex156 VDD f11 0.21834f
Cpex157 VDD s11 0.37742f
Cpex158 VDD f10 0.21834f
Cpex159 VDD s10 0.37742f
Cpex160 VDD f02 0.21834f
Cpex161 VDD s02 0.37742f
Cpex162 VDD f01 0.21834f
Cpex163 VDD s01 0.37742f
Cpex164 VDD f00 0.21834f
Cpex165 VDD s00 0.37742f
Cpex166 VDD GND 52.81174f
Cpex167 VDD GND 4.3143f
Cpex168 VDD GND 3.93487f
Cpex169 VDD GND 4.3143f
Cpex170 VDD GND 3.36975f
Cpex171 VDD GND 3.00182f
Cpex172 VDD GND 4.3143f
Cpex173 VDD GND 3.36975f
Cpex174 VDD GND 2.17653f
Cpex175 VDD GND 0.4902f
Cpex176 VDD GND 0.66391f
Cpex177 VDD GND 0.4902f
Cpex178 VDD GND 0.66391f
Cpex179 VDD GND 0.4902f
Cpex180 VDD GND 0.4902f
Cpex181 VDD GND 0.66391f
Cpex182 VDD GND 0.4902f
Cpex183 VDD GND 0.4902f
Cpex184 VRESET f22 0.06683f
Cpex185 VRESET s22 0.18144f
Cpex186 VRESET f21 0.06683f
Cpex187 VRESET s21 0.18144f
Cpex188 VRESET f20 0.06683f
Cpex189 VRESET s20 0.18144f
Cpex190 VRESET f12 0.06683f
Cpex191 VRESET s12 0.18144f
Cpex192 VRESET f11 0.06683f
Cpex193 VRESET s11 0.18144f
Cpex194 VRESET f10 0.06683f
Cpex195 VRESET s10 0.18144f
Cpex196 VRESET f02 0.06683f
Cpex197 VRESET s02 0.18144f
Cpex198 VRESET f01 0.06683f
Cpex199 VRESET s01 0.18144f
Cpex200 VRESET f00 0.06683f
Cpex201 VRESET s00 0.18144f
Cpex202 VRESET GND 49.98227f
Cpex203 VRESET GND 4.72485f
Cpex204 VRESET GND 4.26968f
Cpex205 VRESET GND 4.72485f
Cpex206 VRESET GND 3.6983f
Cpex207 VRESET GND 3.18062f
Cpex208 VRESET GND 4.72485f
Cpex209 VRESET GND 3.6983f
Cpex210 VRESET GND 2.35877f
Cpex211 VRESET GND 0.41392f
Cpex212 VRESET GND 0.54848f
Cpex213 VRESET GND 0.54848f
Cpex214 VRESET GND 0.54848f
Cpex215 VRESET GND 0.54848f
Cpex216 VRESET GND 0.41392f
Cpex217 VRESET GND 0.54848f
Cpex218 VRESET GND 0.54848f
Cpex219 VRESET GND 0.41392f
Cpex220 f22 s22 1.60401f
Cpex221 f22 GND 8.39942f
Cpex222 f22 GND 0.18149f
Cpex223 f22 GND 0.18149f
Cpex224 s22 GND 10.81948f
Cpex225 s22 GND 0.0138f
Cpex226 s22 GND 0.24686f
Cpex227 s22 GND 0.00253f
Cpex228 s22 GND 3.03615f
Cpex229 s22 GND 0.00372f
Cpex230 f21 s21 1.60401f
Cpex231 f21 GND 8.39942f
Cpex232 f21 GND 0.18149f
Cpex233 f21 GND 0.18149f
Cpex234 s21 GND 10.81948f
Cpex235 s21 GND 0.0138f
Cpex236 s21 GND 0.24686f
Cpex237 s21 GND 0.00253f
Cpex238 s21 GND 3.03615f
Cpex239 s21 GND 0.00372f
Cpex240 f20 s20 1.60401f
Cpex241 f20 GND 8.39942f
Cpex242 f20 GND 0.18149f
Cpex243 f20 GND 0.18149f
Cpex244 s20 GND 10.81948f
Cpex245 s20 GND 0.0138f
Cpex246 s20 GND 0.24686f
Cpex247 s20 GND 0.00253f
Cpex248 s20 GND 3.03615f
Cpex249 s20 GND 0.00372f
Cpex250 f12 s12 1.60401f
Cpex251 f12 GND 8.39942f
Cpex252 f12 GND 0.18149f
Cpex253 f12 GND 0.18149f
Cpex254 s12 GND 10.81948f
Cpex255 s12 GND 0.0138f
Cpex256 s12 GND 0.24686f
Cpex257 s12 GND 0.00253f
Cpex258 s12 GND 3.03615f
Cpex259 s12 GND 0.00372f
Cpex260 f11 s11 1.60401f
Cpex261 f11 GND 8.39942f
Cpex262 f11 GND 0.18149f
Cpex263 f11 GND 0.18149f
Cpex264 s11 GND 10.81948f
Cpex265 s11 GND 0.0138f
Cpex266 s11 GND 0.24686f
Cpex267 s11 GND 0.00253f
Cpex268 s11 GND 3.03615f
Cpex269 s11 GND 0.00372f
Cpex270 f10 s10 1.60401f
Cpex271 f10 GND 8.39942f
Cpex272 f10 GND 0.18149f
Cpex273 f10 GND 0.18149f
Cpex274 s10 GND 10.81948f
Cpex275 s10 GND 0.0138f
Cpex276 s10 GND 0.24686f
Cpex277 s10 GND 0.00253f
Cpex278 s10 GND 3.03615f
Cpex279 s10 GND 0.00372f
Cpex280 f02 s02 1.60401f
Cpex281 f02 GND 8.39942f
Cpex282 f02 GND 0.18149f
Cpex283 f02 GND 0.18149f
Cpex284 s02 GND 10.81737f
Cpex285 s02 GND 0.01353f
Cpex286 s02 GND 0.24206f
Cpex287 s02 GND 0.00249f
Cpex288 s02 GND 2.97709f
Cpex289 s02 GND 0.00365f
Cpex290 f01 s01 1.60401f
Cpex291 f01 GND 8.39942f
Cpex292 f01 GND 0.18149f
Cpex293 f01 GND 0.18149f
Cpex294 s01 GND 10.81737f
Cpex295 s01 GND 0.01353f
Cpex296 s01 GND 0.24206f
Cpex297 s01 GND 0.00249f
Cpex298 s01 GND 2.97709f
Cpex299 s01 GND 0.00365f
Cpex300 f00 s00 1.60401f
Cpex301 f00 GND 8.39942f
Cpex302 f00 GND 0.18149f
Cpex303 f00 GND 0.18149f
Cpex304 s00 GND 10.81737f
Cpex305 s00 GND 0.01353f
Cpex306 s00 GND 0.24206f
Cpex307 s00 GND 0.00249f
Cpex308 s00 GND 2.97709f
Cpex309 s00 GND 0.00365f
.ends array_c
