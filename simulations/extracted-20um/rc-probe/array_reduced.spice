* RC from verified GDS; capacitive-only nodes eliminated at zero net charge.
.subckt array_pex COL0 COL1 COL2 GND VRESET VDD RST0 ROW0 RST1 ROW1 RST2 ROW2
X0 n258 n210 n329 n177 nfet_03v3 ad=0.44p pd=2.88u as=0.44p ps=2.88u w=1u l=0.5u
D0 n183 n330 diode_nd2ps_03v3 pj=80u area=0.4n
X1 n252 n216 n302 n177 nfet_03v3 ad=0.44p pd=2.88u as=0.44p ps=2.88u w=1u l=0.5u
X2 n307 n199 n5 n179 nfet_03v3 ad=0.44p pd=2.88u as=0.44p ps=2.88u w=1u l=0.5u
D1 n183 n303 diode_nd2ps_03v3 pj=80u area=0.4n
X3 n236 n322 n315 n185 nfet_03v3 ad=0.44p pd=2.88u as=0.44p ps=2.88u w=1u l=0.5u
D2 n186 n267 diode_nd2ps_03v3 pj=80u area=0.4n
X4 n334 n193 n4 n179 nfet_03v3 ad=0.44p pd=2.88u as=0.44p ps=2.88u w=1u l=0.5u
X5 n240 n313 n306 n184 nfet_03v3 ad=0.44p pd=2.88u as=0.44p ps=2.88u w=1u l=0.5u
X6 n254 n222 n275 n177 nfet_03v3 ad=0.44p pd=2.88u as=0.44p ps=2.88u w=1u l=0.5u
X7 n253 n217 n311 n176 nfet_03v3 ad=0.44p pd=2.88u as=0.44p ps=2.88u w=1u l=0.5u
X8 n280 n205 n3 n179 nfet_03v3 ad=0.44p pd=2.88u as=0.44p ps=2.88u w=1u l=0.5u
X9 n238 n286 n279 n184 nfet_03v3 ad=0.44p pd=2.88u as=0.44p ps=2.88u w=1u l=0.5u
D3 n186 n321 diode_nd2ps_03v3 pj=80u area=0.4n
X10 n298 n198 n11 n180 nfet_03v3 ad=0.44p pd=2.88u as=0.44p ps=2.88u w=1u l=0.5u
X11 n325 n192 n10 n180 nfet_03v3 ad=0.44p pd=2.88u as=0.44p ps=2.88u w=1u l=0.5u
X12 n259 n209 n320 n181 nfet_03v3 ad=0.44p pd=2.88u as=0.44p ps=2.88u w=1u l=0.5u
X13 n255 n223 n284 n176 nfet_03v3 ad=0.44p pd=2.88u as=0.44p ps=2.88u w=1u l=0.5u
D4 n186 n294 diode_nd2ps_03v3 pj=80u area=0.4n
X14 n233 n340 n333 n184 nfet_03v3 ad=0.44p pd=2.88u as=0.44p ps=2.88u w=1u l=0.5u
X15 n241 n304 n297 n187 nfet_03v3 ad=0.44p pd=2.88u as=0.44p ps=2.88u w=1u l=0.5u
X16 n289 n197 n17 n182 nfet_03v3 ad=0.44p pd=2.88u as=0.44p ps=2.88u w=1u l=0.5u
X17 n234 n295 n288 n185 nfet_03v3 ad=0.44p pd=2.88u as=0.44p ps=2.88u w=1u l=0.5u
D5 n178 n285 diode_nd2ps_03v3 pj=80u area=0.4n
X18 n271 n204 n9 n180 nfet_03v3 ad=0.44p pd=2.88u as=0.44p ps=2.88u w=1u l=0.5u
X19 n251 n215 n293 n181 nfet_03v3 ad=0.44p pd=2.88u as=0.44p ps=2.88u w=1u l=0.5u
D6 n178 n339 diode_nd2ps_03v3 pj=80u area=0.4n
X20 n235 n277 n270 n187 nfet_03v3 ad=0.44p pd=2.88u as=0.44p ps=2.88u w=1u l=0.5u
D7 n183 n276 diode_nd2ps_03v3 pj=80u area=0.4n
X21 n261 n203 n15 n182 nfet_03v3 ad=0.44p pd=2.88u as=0.44p ps=2.88u w=1u l=0.5u
D8 n178 n312 diode_nd2ps_03v3 pj=80u area=0.4n
X22 n237 n331 n324 n187 nfet_03v3 ad=0.44p pd=2.88u as=0.44p ps=2.88u w=1u l=0.5u
X23 n239 n268 n262 n185 nfet_03v3 ad=0.44p pd=2.88u as=0.44p ps=2.88u w=1u l=0.5u
X24 n257 n211 n338 n176 nfet_03v3 ad=0.44p pd=2.88u as=0.44p ps=2.88u w=1u l=0.5u
X25 n256 n221 n266 n181 nfet_03v3 ad=0.44p pd=2.88u as=0.44p ps=2.88u w=1u l=0.5u
X26 n316 n191 n16 n182 nfet_03v3 ad=0.44p pd=2.88u as=0.44p ps=2.88u w=1u l=0.5u
R0 n189 n191 55.567
R1 n190 n193 37.612
R2 n189 n192 37.612
R3 n190 n189 17.9555
R4 ROW0 n190 8.978
R5 n207 n209 54.892
R6 n208 n211 36.937
R7 n207 n210 36.937
R8 n208 n207 17.9555
R9 RST0 n208 2.228
R10 n195 n197 55.567
R11 n196 n199 37.612
R12 n195 n198 37.612
R13 n196 n195 17.9555
R14 ROW1 n196 8.978
R15 n213 n215 54.892
R16 n214 n217 36.937
R17 n213 n216 36.937
R18 n214 n213 17.9555
R19 RST1 n214 2.228
R20 n13 n15 49.9572
R21 n14 n16 38.7523
R22 n13 n17 38.7523
R23 n14 n13 11.2055
R24 COL2 n14 9.203
R25 n7 n9 49.9572
R26 n8 n10 38.7523
R27 n7 n11 38.7523
R28 n8 n7 11.2055
R29 COL1 n8 9.203
R30 n1 n3 49.9572
R31 n2 n4 38.7523
R32 n1 n5 38.7523
R33 n2 n1 11.2055
R34 COL0 n2 9.203
R35 n201 n203 55.567
R36 n202 n205 37.612
R37 n201 n204 37.612
R38 n202 n201 17.9555
R39 ROW2 n202 8.978
R40 n225 n239 43.0272
R41 n227 n234 43.0272
R42 n230 n236 43.0272
R43 n225 n235 25.0723
R44 n226 n238 25.0723
R45 n227 n241 25.0723
R46 n228 n240 25.0723
R47 n230 n237 25.0723
R48 n231 n233 25.0723
R49 n229 n226 22.8605
R50 n226 n225 17.9555
R51 n228 n227 17.9555
R52 n231 n230 17.9555
R53 n229 n228 11.6555
R54 n232 n231 11.6555
R55 n232 n229 11.2055
R56 VDD n232 8.528
R57 n243 n256 42.3522
R58 n245 n251 42.3522
R59 n248 n259 42.3522
R60 n243 n254 24.3972
R61 n244 n255 24.3972
R62 n245 n252 24.3972
R63 n246 n253 24.3972
R64 n248 n258 24.3972
R65 n249 n257 24.3972
R66 n247 n244 20.1605
R67 n244 n243 17.9555
R68 n246 n245 17.9555
R69 n249 n248 17.9555
R70 n250 n247 11.2055
R71 n247 n246 8.9555
R72 n250 n249 8.9555
R73 VRESET n250 7.853
R74 n219 n221 54.892
R75 n220 n223 36.937
R76 n219 n222 36.937
R77 n220 n219 17.9555
R78 RST2 n220 2.228
R79 n49 n64 388.279
R80 n126 n111 388.279
R81 n150 n139 382.974
R82 n149 n139 382.974
R83 n155 n150 382.974
R84 n155 n149 382.974
R85 n148 n141 382.974
R86 n141 n140 382.974
R87 n142 n140 382.974
R88 n148 n142 382.974
R89 n120 n114 382.974
R90 n114 n113 382.974
R91 n115 n113 382.974
R92 n120 n115 382.974
R93 n58 n53 382.974
R94 n53 n31 382.974
R95 n59 n31 382.974
R96 n59 n58 382.974
R97 n156 n137 382.974
R98 n137 n135 382.974
R99 n157 n135 382.974
R100 n157 n156 382.974
R101 n27 n122 382.974
R102 n122 n112 382.974
R103 n123 n112 382.974
R104 n27 n123 382.974
R105 n92 n85 382.974
R106 n85 n84 382.974
R107 n86 n84 382.974
R108 n92 n86 382.974
R109 n29 n108 382.974
R110 n30 n108 382.974
R111 n30 n109 382.974
R112 n29 n109 382.974
R113 n93 n75 382.974
R114 n94 n75 382.974
R115 n57 n94 382.974
R116 n57 n93 382.974
R117 n80 n99 259.57
R118 n74 n132 259.57
R119 n100 n97 259.57
R120 n43 n101 259.57
R121 n175 n127 259.57
R122 n169 n129 259.57
R123 n178 n154 225.779
R124 n178 n64 225.779
R125 n183 n103 225.779
R126 n183 n111 225.779
R127 n186 n133 225.779
R128 n186 n138 225.779
R129 n67 n154 173.047
R130 n36 n103 173.047
R131 n163 n133 173.047
R132 n176 n88 31.6396
R133 n80 n176 31.6396
R134 n184 n99 31.6396
R135 n74 n184 31.6396
R136 n179 n132 31.6396
R137 n67 n179 31.6396
R138 n49 n177 31.6396
R139 n177 n97 31.6396
R140 n187 n100 31.6396
R141 n43 n187 31.6396
R142 n180 n101 31.6396
R143 n36 n180 31.6396
R144 n181 n126 31.6396
R145 n175 n181 31.6396
R146 n185 n127 31.6396
R147 n169 n185 31.6396
R148 n182 n129 31.6396
R149 n163 n182 31.6396
R150 n166 n131 27.8893
R151 n145 n128 27.8893
R152 n160 n159 27.8893
R153 n62 n61 21.8592
R154 n117 n102 21.8592
R155 n89 n143 21.8592
R156 n24 n23 21.8592
R157 n33 n32 21.8592
R158 n54 n52 21.8592
R159 n78 n18 21.2855
R160 n171 n170 17.4557
R161 n173 n172 17.4557
R162 n38 n37 17.4557
R163 n40 n39 17.4557
R164 n48 n165 17.4557
R165 n65 n63 17.4557
R166 n73 n19 17.4557
R167 n82 n81 17.4557
R168 n130 n125 17.4557
R169 n22 n21 17.4557
R170 n104 n98 17.4557
R171 n45 n44 17.4557
R172 n47 n46 17.4557
R173 n69 n68 17.4557
R174 n72 n71 17.4557
R175 n70 n110 17.4557
R176 n162 n128 17.4557
R177 n161 n160 17.4557
R178 n166 n164 17.4557
R179 n168 n167 17.4557
R180 n174 n105 17.4557
R181 n35 n34 17.4557
R182 n41 n96 17.4557
R183 n51 n50 17.4557
R184 n66 n121 17.4557
R185 n77 n76 17.4557
R186 n79 n78 17.4557
R187 n83 n18 11.2055
R188 n83 n82 10.0805
R189 n70 n18 10.0805
R190 n153 n151 7.5083
R191 n153 n152 7.5083
R192 n147 n144 7.5083
R193 n147 n146 7.5083
R194 n42 n20 7.5083
R195 n60 n42 7.5083
R196 n119 n116 7.5083
R197 n119 n118 7.5083
R198 n136 n134 7.5083
R199 n158 n136 7.5083
R200 n91 n87 7.5083
R201 n91 n90 7.5083
R202 n26 n124 7.5083
R203 n26 n25 7.5083
R204 n28 n106 7.5083
R205 n28 n107 7.5083
R206 n56 n55 7.5083
R207 n56 n95 7.5083
R208 n151 n131 7.4669
R209 n152 n131 7.4669
R210 n145 n144 7.4669
R211 n146 n145 7.4669
R212 n61 n20 7.4669
R213 n61 n60 7.4669
R214 n117 n116 7.4669
R215 n118 n117 7.4669
R216 n159 n134 7.4669
R217 n159 n158 7.4669
R218 n89 n87 7.4669
R219 n90 n89 7.4669
R220 n24 n124 7.4669
R221 n25 n24 7.4669
R222 n32 n106 7.4669
R223 n32 n107 7.4669
R224 n54 n95 7.4669
R225 n55 n54 7.4669
R226 n52 n121 6.0305
R227 n34 n33 6.0305
R228 n38 n102 6.0305
R229 n63 n62 6.0305
R230 n23 n98 6.0305
R231 n69 n143 6.0305
R232 n52 n51 5.1305
R233 n33 n105 5.1305
R234 n172 n102 5.1305
R235 n62 n165 5.1305
R236 n23 n22 5.1305
R237 n46 n143 5.1305
R238 GND n83 4.478
R239 n78 n77 3.3305
R240 n77 n121 3.3305
R241 n51 n96 3.3305
R242 n34 n96 3.3305
R243 n167 n105 3.3305
R244 n167 n166 3.3305
R245 n171 n128 3.3305
R246 n172 n171 3.3305
R247 n39 n38 3.3305
R248 n39 n165 3.3305
R249 n63 n19 3.3305
R250 n82 n19 3.3305
R251 n160 n125 3.3305
R252 n22 n125 3.3305
R253 n45 n98 3.3305
R254 n46 n45 3.3305
R255 n71 n69 3.3305
R256 n71 n70 3.3305
R257 n162 n129 2.54855
R258 n81 n80 2.54855
R259 n74 n73 2.54855
R260 n67 n65 2.54855
R261 n48 n97 2.54855
R262 n43 n40 2.54855
R263 n37 n36 2.54855
R264 n175 n173 2.54855
R265 n170 n169 2.54855
R266 n163 n162 2.54855
R267 n170 n127 2.54855
R268 n173 n126 2.54855
R269 n37 n101 2.54855
R270 n40 n100 2.54855
R271 n49 n48 2.54855
R272 n65 n132 2.54855
R273 n73 n99 2.54855
R274 n81 n88 2.54855
R275 n161 n129 2.54855
R276 n80 n110 2.54855
R277 n74 n72 2.54855
R278 n68 n67 2.54855
R279 n47 n97 2.54855
R280 n44 n43 2.54855
R281 n36 n104 2.54855
R282 n21 n175 2.54855
R283 n169 n130 2.54855
R284 n163 n161 2.54855
R285 n130 n127 2.54855
R286 n21 n126 2.54855
R287 n104 n101 2.54855
R288 n44 n100 2.54855
R289 n49 n47 2.54855
R290 n68 n132 2.54855
R291 n72 n99 2.54855
R292 n110 n88 2.54855
R293 n164 n129 2.54855
R294 n164 n163 2.54855
R295 n168 n127 2.54855
R296 n169 n168 2.54855
R297 n174 n126 2.54855
R298 n175 n174 2.54855
R299 n35 n101 2.54855
R300 n36 n35 2.54855
R301 n41 n100 2.54855
R302 n43 n41 2.54855
R303 n50 n49 2.54855
R304 n50 n97 2.54855
R305 n66 n132 2.54855
R306 n67 n66 2.54855
R307 n76 n99 2.54855
R308 n76 n74 2.54855
R309 n79 n88 2.54855
R310 n80 n79 2.54855
R311 n186 n139 0.12143
R312 n139 n131 0.12143
R313 n149 n138 0.12143
R314 n151 n149 0.12143
R315 n186 n155 0.12143
R316 n155 n153 0.12143
R317 n150 n133 0.12143
R318 n152 n150 0.12143
R319 n178 n57 0.12143
R320 n57 n56 0.12143
R321 n178 n75 0.12143
R322 n54 n75 0.12143
R323 n94 n154 0.12143
R324 n55 n94 0.12143
R325 n93 n64 0.12143
R326 n95 n93 0.12143
R327 n30 n183 0.12143
R328 n32 n30 0.12143
R329 n109 n103 0.12143
R330 n109 n107 0.12143
R331 n111 n108 0.12143
R332 n108 n106 0.12143
R333 n183 n29 0.12143
R334 n29 n28 0.12143
R335 n178 n84 0.12143
R336 n89 n84 0.12143
R337 n86 n154 0.12143
R338 n90 n86 0.12143
R339 n85 n64 0.12143
R340 n87 n85 0.12143
R341 n178 n92 0.12143
R342 n92 n91 0.12143
R343 n183 n112 0.12143
R344 n24 n112 0.12143
R345 n123 n103 0.12143
R346 n25 n123 0.12143
R347 n122 n111 0.12143
R348 n124 n122 0.12143
R349 n183 n27 0.12143
R350 n27 n26 0.12143
R351 n186 n135 0.12143
R352 n159 n135 0.12143
R353 n157 n133 0.12143
R354 n158 n157 0.12143
R355 n138 n137 0.12143
R356 n137 n134 0.12143
R357 n156 n186 0.12143
R358 n156 n136 0.12143
R359 n178 n31 0.12143
R360 n61 n31 0.12143
R361 n59 n154 0.12143
R362 n60 n59 0.12143
R363 n64 n53 0.12143
R364 n53 n20 0.12143
R365 n58 n178 0.12143
R366 n58 n42 0.12143
R367 n183 n113 0.12143
R368 n117 n113 0.12143
R369 n115 n103 0.12143
R370 n118 n115 0.12143
R371 n114 n111 0.12143
R372 n116 n114 0.12143
R373 n183 n120 0.12143
R374 n120 n119 0.12143
R375 n186 n140 0.12143
R376 n145 n140 0.12143
R377 n142 n133 0.12143
R378 n146 n142 0.12143
R379 n141 n138 0.12143
R380 n144 n141 0.12143
R381 n186 n148 0.12143
R382 n148 n147 0.12143
R383 n314 n316 4.7885
R384 n314 n315 4.7885
R385 n319 n317 29.0165
R386 n319 n318 24.199
R387 n317 n319 20.9142
R388 n318 n322 11.3885
R389 n317 n321 6.3005
R390 n317 n320 4.7885
R391 n318 n317 0.2925
R392 n323 n325 4.7885
R393 n323 n324 4.7885
R394 n328 n326 29.0165
R395 n328 n327 24.199
R396 n326 n328 20.9142
R397 n327 n331 11.3885
R398 n326 n330 6.3005
R399 n326 n329 4.7885
R400 n327 n326 0.2925
R401 n332 n334 4.7885
R402 n332 n333 4.7885
R403 n337 n335 29.0165
R404 n337 n336 24.199
R405 n335 n337 20.9142
R406 n336 n340 11.3885
R407 n335 n339 6.3005
R408 n335 n338 4.7885
R409 n336 n335 0.2925
R410 n287 n289 4.7885
R411 n287 n288 4.7885
R412 n292 n290 29.0165
R413 n292 n291 24.199
R414 n290 n292 20.9142
R415 n291 n295 11.3885
R416 n290 n294 6.3005
R417 n290 n293 4.7885
R418 n291 n290 0.2925
R419 n296 n298 4.7885
R420 n296 n297 4.7885
R421 n301 n299 29.0165
R422 n301 n300 24.199
R423 n299 n301 20.9142
R424 n300 n304 11.3885
R425 n299 n303 6.3005
R426 n299 n302 4.7885
R427 n300 n299 0.2925
R428 n305 n307 4.7885
R429 n305 n306 4.7885
R430 n310 n308 29.0165
R431 n310 n309 24.199
R432 n308 n310 20.9142
R433 n309 n313 11.3885
R434 n308 n312 6.3005
R435 n308 n311 4.7885
R436 n309 n308 0.2925
R437 n260 n262 4.7885
R438 n260 n261 4.7885
R439 n265 n263 29.0165
R440 n265 n264 24.199
R441 n263 n265 20.9142
R442 n264 n268 11.3885
R443 n263 n267 6.3005
R444 n263 n266 4.7885
R445 n264 n263 0.2925
R446 n269 n271 4.7885
R447 n269 n270 4.7885
R448 n274 n272 29.0165
R449 n274 n273 24.199
R450 n272 n274 20.9142
R451 n273 n277 11.3885
R452 n272 n276 6.3005
R453 n272 n275 4.7885
R454 n273 n272 0.2925
R455 n278 n280 4.7885
R456 n278 n279 4.7885
R457 n283 n281 29.0165
R458 n283 n282 24.199
R459 n281 n283 20.9142
R460 n282 n286 11.3885
R461 n281 n285 6.3005
R462 n281 n284 4.7885
R463 n282 n281 0.2925
Cpex0 COL0 ROW0 0.65205f
Cpex1 COL0 ROW1 0.65205f
Cpex2 COL0 ROW2 0.65205f
Cpex3 COL0 RST0 0.13627f
Cpex4 COL0 RST1 0.13627f
Cpex5 COL0 RST2 0.13627f
Cpex6 COL0 VDD 3.89151f
Cpex7 COL0 VRESET 0.41762f
Cpex8 COL0 n278 0.2326f
Cpex9 COL0 n281 0.80901f
Cpex10 COL0 n305 0.2326f
Cpex11 COL0 n308 0.80901f
Cpex12 COL0 n332 0.2326f
Cpex13 COL0 n335 0.74265f
Cpex14 COL0 GND 25.78633f
Cpex15 n1 GND 3.98869f
Cpex16 n2 GND 2.53464f
Cpex17 n3 GND 1.07247f
Cpex18 n4 GND 0.69818f
Cpex19 n5 GND 0.69818f
Cpex20 COL1 ROW0 0.65205f
Cpex21 COL1 ROW1 0.65205f
Cpex22 COL1 ROW2 0.65205f
Cpex23 COL1 RST0 0.13627f
Cpex24 COL1 RST1 0.13627f
Cpex25 COL1 RST2 0.13627f
Cpex26 COL1 VDD 3.89151f
Cpex27 COL1 VRESET 0.41762f
Cpex28 COL1 n269 0.2326f
Cpex29 COL1 n272 0.80901f
Cpex30 COL1 n296 0.2326f
Cpex31 COL1 n299 0.80901f
Cpex32 COL1 n323 0.2326f
Cpex33 COL1 n326 0.74265f
Cpex34 COL1 GND 25.78633f
Cpex35 n7 GND 3.98869f
Cpex36 n8 GND 2.53464f
Cpex37 n9 GND 1.07247f
Cpex38 n10 GND 0.69818f
Cpex39 n11 GND 0.69818f
Cpex40 COL2 ROW0 0.65127f
Cpex41 COL2 ROW1 0.65127f
Cpex42 COL2 ROW2 0.65127f
Cpex43 COL2 RST0 0.1355f
Cpex44 COL2 RST1 0.1355f
Cpex45 COL2 RST2 0.1355f
Cpex46 COL2 VDD 3.88917f
Cpex47 COL2 VRESET 0.41529f
Cpex48 COL2 n260 0.2326f
Cpex49 COL2 n263 0.80901f
Cpex50 COL2 n287 0.2326f
Cpex51 COL2 n290 0.80901f
Cpex52 COL2 n314 0.2326f
Cpex53 COL2 n317 0.74265f
Cpex54 COL2 GND 25.80921f
Cpex55 n13 GND 3.98486f
Cpex56 n14 GND 2.53221f
Cpex57 n15 GND 1.07144f
Cpex58 n16 GND 0.6975f
Cpex59 n17 GND 0.6975f
Cpex60 ROW0 RST0 4.14771f
Cpex61 ROW0 VDD 0.21087f
Cpex62 ROW0 VRESET 4.15562f
Cpex63 ROW0 n314 0.44365f
Cpex64 ROW0 n317 0.06422f
Cpex65 ROW0 n323 0.44365f
Cpex66 ROW0 n326 0.06422f
Cpex67 ROW0 n332 0.44365f
Cpex68 ROW0 n335 0.06422f
Cpex69 ROW0 GND 13.10426f
Cpex70 n189 GND 5.68693f
Cpex71 n190 GND 4.00349f
Cpex72 n191 GND 0.6467f
Cpex73 n192 GND 0.32169f
Cpex74 n193 GND 0.32169f
Cpex75 ROW1 RST1 4.14771f
Cpex76 ROW1 VDD 0.21087f
Cpex77 ROW1 VRESET 4.15562f
Cpex78 ROW1 n287 0.44365f
Cpex79 ROW1 n290 0.06422f
Cpex80 ROW1 n296 0.44365f
Cpex81 ROW1 n299 0.06422f
Cpex82 ROW1 n305 0.44365f
Cpex83 ROW1 n308 0.06422f
Cpex84 ROW1 GND 13.10426f
Cpex85 n195 GND 5.68693f
Cpex86 n196 GND 4.00349f
Cpex87 n197 GND 0.6467f
Cpex88 n198 GND 0.32169f
Cpex89 n199 GND 0.32169f
Cpex90 ROW2 RST2 4.14771f
Cpex91 ROW2 VDD 0.21087f
Cpex92 ROW2 VRESET 4.15562f
Cpex93 ROW2 n260 0.44365f
Cpex94 ROW2 n263 0.06422f
Cpex95 ROW2 n269 0.44365f
Cpex96 ROW2 n272 0.06422f
Cpex97 ROW2 n278 0.44365f
Cpex98 ROW2 n281 0.06422f
Cpex99 ROW2 GND 13.10426f
Cpex100 n201 GND 5.68693f
Cpex101 n202 GND 4.00349f
Cpex102 n203 GND 0.6467f
Cpex103 n204 GND 0.32169f
Cpex104 n205 GND 0.32169f
Cpex105 RST0 VDD 0.21011f
Cpex106 RST0 VRESET 1.54347f
Cpex107 RST0 n314 1.22333f
Cpex108 RST0 n317 0.37545f
Cpex109 RST0 n323 1.22333f
Cpex110 RST0 n326 0.37545f
Cpex111 RST0 n332 1.22333f
Cpex112 RST0 n335 0.37545f
Cpex113 RST0 GND 12.8197f
Cpex114 n207 GND 5.82696f
Cpex115 n208 GND 4.08099f
Cpex116 n209 GND 0.11112f
Cpex117 n210 GND 0.37464f
Cpex118 n211 GND 0.37464f
Cpex119 RST1 VDD 0.21011f
Cpex120 RST1 VRESET 1.54347f
Cpex121 RST1 n287 1.22333f
Cpex122 RST1 n290 0.37545f
Cpex123 RST1 n296 1.22333f
Cpex124 RST1 n299 0.37545f
Cpex125 RST1 n305 1.22333f
Cpex126 RST1 n308 0.37545f
Cpex127 RST1 GND 12.8197f
Cpex128 n213 GND 5.82696f
Cpex129 n214 GND 4.08099f
Cpex130 n215 GND 0.11112f
Cpex131 n216 GND 0.37464f
Cpex132 n217 GND 0.37464f
Cpex133 RST2 VDD 0.21011f
Cpex134 RST2 VRESET 1.54347f
Cpex135 RST2 n260 1.22333f
Cpex136 RST2 n263 0.37545f
Cpex137 RST2 n269 1.22333f
Cpex138 RST2 n272 0.37545f
Cpex139 RST2 n278 1.22333f
Cpex140 RST2 n281 0.37545f
Cpex141 RST2 GND 12.8197f
Cpex142 n219 GND 5.82696f
Cpex143 n220 GND 4.08099f
Cpex144 n221 GND 0.11112f
Cpex145 n222 GND 0.37464f
Cpex146 n223 GND 0.37464f
Cpex147 VDD VRESET 16.1958f
Cpex148 VDD n260 0.21834f
Cpex149 VDD n263 0.37742f
Cpex150 VDD n269 0.21834f
Cpex151 VDD n272 0.37742f
Cpex152 VDD n278 0.21834f
Cpex153 VDD n281 0.37742f
Cpex154 VDD n287 0.21834f
Cpex155 VDD n290 0.37742f
Cpex156 VDD n296 0.21834f
Cpex157 VDD n299 0.37742f
Cpex158 VDD n305 0.21834f
Cpex159 VDD n308 0.37742f
Cpex160 VDD n314 0.21834f
Cpex161 VDD n317 0.37742f
Cpex162 VDD n323 0.21834f
Cpex163 VDD n326 0.37742f
Cpex164 VDD n332 0.21834f
Cpex165 VDD n335 0.37742f
Cpex166 VDD GND 52.81174f
Cpex167 n225 GND 4.3143f
Cpex168 n226 GND 3.93487f
Cpex169 n227 GND 4.3143f
Cpex170 n228 GND 3.36975f
Cpex171 n229 GND 3.00182f
Cpex172 n230 GND 4.3143f
Cpex173 n231 GND 3.36975f
Cpex174 n232 GND 2.17653f
Cpex175 n233 GND 0.4902f
Cpex176 n234 GND 0.66391f
Cpex177 n235 GND 0.4902f
Cpex178 n236 GND 0.66391f
Cpex179 n237 GND 0.4902f
Cpex180 n238 GND 0.4902f
Cpex181 n239 GND 0.66391f
Cpex182 n240 GND 0.4902f
Cpex183 n241 GND 0.4902f
Cpex184 VRESET n260 0.06683f
Cpex185 VRESET n263 0.18144f
Cpex186 VRESET n269 0.06683f
Cpex187 VRESET n272 0.18144f
Cpex188 VRESET n278 0.06683f
Cpex189 VRESET n281 0.18144f
Cpex190 VRESET n287 0.06683f
Cpex191 VRESET n290 0.18144f
Cpex192 VRESET n296 0.06683f
Cpex193 VRESET n299 0.18144f
Cpex194 VRESET n305 0.06683f
Cpex195 VRESET n308 0.18144f
Cpex196 VRESET n314 0.06683f
Cpex197 VRESET n317 0.18144f
Cpex198 VRESET n323 0.06683f
Cpex199 VRESET n326 0.18144f
Cpex200 VRESET n332 0.06683f
Cpex201 VRESET n335 0.18144f
Cpex202 VRESET GND 49.98227f
Cpex203 n243 GND 4.72485f
Cpex204 n244 GND 4.26968f
Cpex205 n245 GND 4.72485f
Cpex206 n246 GND 3.6983f
Cpex207 n247 GND 3.18062f
Cpex208 n248 GND 4.72485f
Cpex209 n249 GND 3.6983f
Cpex210 n250 GND 2.35877f
Cpex211 n251 GND 0.41392f
Cpex212 n252 GND 0.54848f
Cpex213 n253 GND 0.54848f
Cpex214 n254 GND 0.54848f
Cpex215 n255 GND 0.54848f
Cpex216 n256 GND 0.41392f
Cpex217 n257 GND 0.54848f
Cpex218 n258 GND 0.54848f
Cpex219 n259 GND 0.41392f
Cpex220 n260 n263 1.60401f
Cpex221 n260 GND 8.39942f
Cpex222 n261 GND 0.18149f
Cpex223 n262 GND 0.18149f
Cpex224 n263 GND 10.81948f
Cpex225 n264 GND 0.0138f
Cpex226 n265 GND 0.24686f
Cpex227 n266 GND 0.00253f
Cpex228 n267 GND 3.03615f
Cpex229 n268 GND 0.00372f
Cpex230 n269 n272 1.60401f
Cpex231 n269 GND 8.39942f
Cpex232 n270 GND 0.18149f
Cpex233 n271 GND 0.18149f
Cpex234 n272 GND 10.81948f
Cpex235 n273 GND 0.0138f
Cpex236 n274 GND 0.24686f
Cpex237 n275 GND 0.00253f
Cpex238 n276 GND 3.03615f
Cpex239 n277 GND 0.00372f
Cpex240 n278 n281 1.60401f
Cpex241 n278 GND 8.39942f
Cpex242 n279 GND 0.18149f
Cpex243 n280 GND 0.18149f
Cpex244 n281 GND 10.81948f
Cpex245 n282 GND 0.0138f
Cpex246 n283 GND 0.24686f
Cpex247 n284 GND 0.00253f
Cpex248 n285 GND 3.03615f
Cpex249 n286 GND 0.00372f
Cpex250 n287 n290 1.60401f
Cpex251 n287 GND 8.39942f
Cpex252 n288 GND 0.18149f
Cpex253 n289 GND 0.18149f
Cpex254 n290 GND 10.81948f
Cpex255 n291 GND 0.0138f
Cpex256 n292 GND 0.24686f
Cpex257 n293 GND 0.00253f
Cpex258 n294 GND 3.03615f
Cpex259 n295 GND 0.00372f
Cpex260 n296 n299 1.60401f
Cpex261 n296 GND 8.39942f
Cpex262 n297 GND 0.18149f
Cpex263 n298 GND 0.18149f
Cpex264 n299 GND 10.81948f
Cpex265 n300 GND 0.0138f
Cpex266 n301 GND 0.24686f
Cpex267 n302 GND 0.00253f
Cpex268 n303 GND 3.03615f
Cpex269 n304 GND 0.00372f
Cpex270 n305 n308 1.60401f
Cpex271 n305 GND 8.39942f
Cpex272 n306 GND 0.18149f
Cpex273 n307 GND 0.18149f
Cpex274 n308 GND 10.81948f
Cpex275 n309 GND 0.0138f
Cpex276 n310 GND 0.24686f
Cpex277 n311 GND 0.00253f
Cpex278 n312 GND 3.03615f
Cpex279 n313 GND 0.00372f
Cpex280 n314 n317 1.60401f
Cpex281 n314 GND 8.39942f
Cpex282 n315 GND 0.18149f
Cpex283 n316 GND 0.18149f
Cpex284 n317 GND 10.81737f
Cpex285 n318 GND 0.01353f
Cpex286 n319 GND 0.24206f
Cpex287 n320 GND 0.00249f
Cpex288 n321 GND 2.97709f
Cpex289 n322 GND 0.00365f
Cpex290 n323 n326 1.60401f
Cpex291 n323 GND 8.39942f
Cpex292 n324 GND 0.18149f
Cpex293 n325 GND 0.18149f
Cpex294 n326 GND 10.81737f
Cpex295 n327 GND 0.01353f
Cpex296 n328 GND 0.24206f
Cpex297 n329 GND 0.00249f
Cpex298 n330 GND 2.97709f
Cpex299 n331 GND 0.00365f
Cpex300 n332 n335 1.60401f
Cpex301 n332 GND 8.39942f
Cpex302 n333 GND 0.18149f
Cpex303 n334 GND 0.18149f
Cpex304 n335 GND 10.81737f
Cpex305 n336 GND 0.01353f
Cpex306 n337 GND 0.24206f
Cpex307 n338 GND 0.00249f
Cpex308 n339 GND 2.97709f
Cpex309 n340 GND 0.00365f
.ends array_pex
