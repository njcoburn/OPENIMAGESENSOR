* Independent hierarchical electrical reference. Simulation light is external.
.subckt pixel_physical VDD VRESET GND RST ROW COL
Xrst VRESET RST sense GND nfet_03v3 W=1u L=0.5u
Xsf VDD sense sf GND nfet_03v3 W=1u L=0.5u
Xsel sf ROW COL GND nfet_03v3 W=1u L=0.5u
Dphoto GND sense diode_nd2ps_03v3 area=400p pj=80u
.ends pixel_physical
.subckt array_3x3 VDD VRESET GND RST0 RST1 RST2 ROW0 ROW1 ROW2 COL0 COL1 COL2
X00 VDD VRESET GND RST0 ROW0 COL0 pixel_physical
X01 VDD VRESET GND RST0 ROW0 COL1 pixel_physical
X02 VDD VRESET GND RST0 ROW0 COL2 pixel_physical
X10 VDD VRESET GND RST1 ROW1 COL0 pixel_physical
X11 VDD VRESET GND RST1 ROW1 COL1 pixel_physical
X12 VDD VRESET GND RST1 ROW1 COL2 pixel_physical
X20 VDD VRESET GND RST2 ROW2 COL0 pixel_physical
X21 VDD VRESET GND RST2 ROW2 COL1 pixel_physical
X22 VDD VRESET GND RST2 ROW2 COL2 pixel_physical
.ends array_3x3

.subckt column_readout GND BIAS COL0 COL1 COL2 OUT SEL0 SEL1 SEL2
Xref BIAS BIAS GND GND nfet_03v3 w=2u l=2u
Xb0 COL0 BIAS GND GND nfet_03v3 w=2u l=2u
Xb1 COL1 BIAS GND GND nfet_03v3 w=2u l=2u
Xb2 COL2 BIAS GND GND nfet_03v3 w=2u l=2u
Xm0 OUT SEL0 COL0 GND nfet_03v3 w=1u l=0.5u
Xm1 OUT SEL1 COL1 GND nfet_03v3 w=1u l=0.5u
Xm2 OUT SEL2 COL2 GND nfet_03v3 w=1u l=0.5u
.ends

* PMOS source follower for the low-voltage mux output; non-unity gain, shifted output.
* Ideal external reference current is supplied at PREF. Devices not laid out.
.subckt output_buffer IN BUF PREF VDD GND
Xref PREF PREF VDD VDD pfet_03v3 w=20u l=2u ad=8.8p as=8.8p pd=40.88u ps=40.88u
Xload BUF PREF VDD VDD pfet_03v3 w=20u l=2u ad=8.8p as=8.8p pd=40.88u ps=40.88u
Xfollow GND IN BUF VDD pfet_03v3 w=20u l=0.5u ad=8.8p as=8.8p pd=40.88u ps=40.88u
.ends output_buffer

.subckt sensor_3x3 VDD VRESET GND RST0 RST1 RST2 ROW0 ROW1 ROW2 BIAS SEL0 SEL1 SEL2 PREF BUF COL0 COL1 COL2 OUT
Xa VDD VRESET GND RST0 RST1 RST2 ROW0 ROW1 ROW2 COL0 COL1 COL2 array_3x3
Xr GND BIAS COL0 COL1 COL2 OUT SEL0 SEL1 SEL2 column_readout
Xb OUT BUF PREF VDD GND output_buffer
.ends sensor_3x3
