Physical 3x3 GF180 row-scan test
.include /foss/pdks/gf180mcuD/libs.tech/ngspice/design.ngspice
.lib /foss/pdks/gf180mcuD/libs.tech/ngspice/sm141064.ngspice typical
.lib /foss/pdks/gf180mcuD/libs.tech/ngspice/sm141064.ngspice diode_typical
.options gmin=1e-17 abstol=1e-14 reltol=5e-5 chgtol=1e-16 trtol=3 method=gear
.temp 27
Vdd VDD 0 3.3
Vreset VRESET 0 2.0
Vr0 RST0 0 PWL(0 3.3 2e-05 3.3 2.001e-05 0 5e-05 0 5.001e-05 3.3 7.001e-05 3.3 7.002e-05 0 0.00305 0 0.00305001 3.3 0.00307001 3.3 0.00307002 0 0.00605 0 0.00605001 3.3 0.00607001 3.3 0.00607002 0)
Vs0 ROW0 0 PULSE(0 3.3 970u 10n 10n 60u 3m)
Ilight00 xsensor.n371 xsensor.n243 0.0p
.ic v(xsensor.n371)=0 v(xsensor.n406)=0
Ilight01 xsensor.n359 xsensor.n245 80.0p
.ic v(xsensor.n359)=0 v(xsensor.n382)=0
Ilight02 xsensor.n389 xsensor.n247 240.0p
.ic v(xsensor.n389)=0 v(xsensor.n400)=0
Vr1 RST1 0 PWL(0 3.3 2e-05 3.3 2.001e-05 0 0.00105 0 0.00105001 3.3 0.00107001 3.3 0.00107002 0 0.00405 0 0.00405001 3.3 0.00407001 3.3 0.00407002 0 0.00705 0 0.00705001 3.3 0.00707001 3.3 0.00707002 0)
Vs1 ROW1 0 PULSE(0 3.3 1970u 10n 10n 60u 3m)
Ilight10 xsensor.n375 xsensor.n243 240.0p
.ic v(xsensor.n375)=0 v(xsensor.n408)=0
Ilight11 xsensor.n363 xsensor.n245 0.0p
.ic v(xsensor.n363)=0 v(xsensor.n384)=0
Ilight12 xsensor.n393 xsensor.n247 80.0p
.ic v(xsensor.n393)=0 v(xsensor.n402)=0
Vr2 RST2 0 PWL(0 3.3 2e-05 3.3 2.001e-05 0 0.00205 0 0.00205001 3.3 0.00207001 3.3 0.00207002 0 0.00505 0 0.00505001 3.3 0.00507001 3.3 0.00507002 0 0.00805 0 0.00805001 3.3 0.00807001 3.3 0.00807002 0)
Vs2 ROW2 0 PULSE(0 3.3 2970u 10n 10n 60u 3m)
Ilight20 xsensor.n379 xsensor.n243 80.0p
.ic v(xsensor.n379)=0 v(xsensor.n410)=0
Ilight21 xsensor.n367 xsensor.n245 240.0p
.ic v(xsensor.n367)=0 v(xsensor.n386)=0
Ilight22 xsensor.n397 xsensor.n247 0.0p
.ic v(xsensor.n397)=0 v(xsensor.n404)=0
Cload0 COL0 0 1p
.ic v(COL0)=0
Cload1 COL1 0 1p
.ic v(COL1)=0
Cload2 COL2 0 1p
.ic v(COL2)=0
Iref VDD BIAS 0.5u
Vsel0 SEL0 0 PULSE(0 3.3 975u 10n 10n 16u 1m)
Vsel1 SEL1 0 PULSE(0 3.3 993u 10n 10n 16u 1m)
Vsel2 SEL2 0 PULSE(0 3.3 1011u 10n 10n 16u 1m)
Cout OUT 0 1p
Rout OUT 0 1G
.ic v(OUT)=0
.include /foss/designs/checkpoints/integrated/pex/sensor_reduced.spice
Xsensor COL0 COL1 COL2 VRESET RST0 ROW0 RST1 ROW1 RST2 ROW2 BIAS SEL0 SEL1 SEL2 PREF BUF OUT 0 VDD sensor_pex
Ibufref PREF 0 40u
Rbond BUF BOND 1
Lbond BOND PAD 5n
Cpad PAD 0 5p
Riso PAD ADCIN 100
Cboard ADCIN 0 100p
Rinput ADCIN 0 1Meg
Csample HOLD 0 20p
Ssample ADCIN HOLD ACQ 0 sample_switch
Sreset HOLD 0 RSTADC 0 sample_switch
.model sample_switch SW(Ron=100 Roff=1e12 Vt=1.65 Vh=0)
VACQ ACQ 0 PWL(0 0 0.00098 0 0.00098001 3.3 0.000985 3.3 0.00098501 0 0.000998 0 0.00099801 3.3 0.001003 3.3 0.00100301 0 0.001016 0 0.00101601 3.3 0.001021 3.3 0.00102101 0 0.00198 0 0.00198001 3.3 0.001985 3.3 0.00198501 0 0.001998 0 0.00199801 3.3 0.002003 3.3 0.00200301 0 0.002016 0 0.00201601 3.3 0.002021 3.3 0.00202101 0 0.00298 0 0.00298001 3.3 0.002985 3.3 0.00298501 0 0.002998 0 0.00299801 3.3 0.003003 3.3 0.00300301 0 0.003016 0 0.00301601 3.3 0.003021 3.3 0.00302101 0 0.00398 0 0.00398001 3.3 0.003985 3.3 0.00398501 0 0.003998 0 0.00399801 3.3 0.004003 3.3 0.00400301 0 0.004016 0 0.00401601 3.3 0.004021 3.3 0.00402101 0 0.00498 0 0.00498001 3.3 0.004985 3.3 0.00498501 0 0.004998 0 0.00499801 3.3 0.005003 3.3 0.00500301 0 0.005016 0 0.00501601 3.3 0.005021 3.3 0.00502101 0 0.00598 0 0.00598001 3.3 0.005985 3.3 0.00598501 0 0.005998 0 0.00599801 3.3 0.006003 3.3 0.00600301 0 0.006016 0 0.00601601 3.3 0.006021 3.3 0.00602101 0 0.00698 0 0.00698001 3.3 0.006985 3.3 0.00698501 0 0.006998 0 0.00699801 3.3 0.007003 3.3 0.00700301 0 0.007016 0 0.00701601 3.3 0.007021 3.3 0.00702101 0 0.00798 0 0.00798001 3.3 0.007985 3.3 0.00798501 0 0.007998 0 0.00799801 3.3 0.008003 3.3 0.00800301 0 0.008016 0 0.00801601 3.3 0.008021 3.3 0.00802101 0 0.00898 0 0.00898001 3.3 0.008985 3.3 0.00898501 0 0.008998 0 0.00899801 3.3 0.009003 3.3 0.00900301 0 0.009016 0 0.00901601 3.3 0.009021 3.3 0.00902101 0)
VRSTADC RSTADC 0 PWL(0 0 0.000978 0 0.00097801 3.3 0.000979 3.3 0.00097901 0 0.000996 0 0.00099601 3.3 0.000997 3.3 0.00099701 0 0.001014 0 0.00101401 3.3 0.001015 3.3 0.00101501 0 0.001978 0 0.00197801 3.3 0.001979 3.3 0.00197901 0 0.001996 0 0.00199601 3.3 0.001997 3.3 0.00199701 0 0.002014 0 0.00201401 3.3 0.002015 3.3 0.00201501 0 0.002978 0 0.00297801 3.3 0.002979 3.3 0.00297901 0 0.002996 0 0.00299601 3.3 0.002997 3.3 0.00299701 0 0.003014 0 0.00301401 3.3 0.003015 3.3 0.00301501 0 0.003978 0 0.00397801 3.3 0.003979 3.3 0.00397901 0 0.003996 0 0.00399601 3.3 0.003997 3.3 0.00399701 0 0.004014 0 0.00401401 3.3 0.004015 3.3 0.00401501 0 0.004978 0 0.00497801 3.3 0.004979 3.3 0.00497901 0 0.004996 0 0.00499601 3.3 0.004997 3.3 0.00499701 0 0.005014 0 0.00501401 3.3 0.005015 3.3 0.00501501 0 0.005978 0 0.00597801 3.3 0.005979 3.3 0.00597901 0 0.005996 0 0.00599601 3.3 0.005997 3.3 0.00599701 0 0.006014 0 0.00601401 3.3 0.006015 3.3 0.00601501 0 0.006978 0 0.00697801 3.3 0.006979 3.3 0.00697901 0 0.006996 0 0.00699601 3.3 0.006997 3.3 0.00699701 0 0.007014 0 0.00701401 3.3 0.007015 3.3 0.00701501 0 0.007978 0 0.00797801 3.3 0.007979 3.3 0.00797901 0 0.007996 0 0.00799601 3.3 0.007997 3.3 0.00799701 0 0.008014 0 0.00801401 3.3 0.008015 3.3 0.00801501 0 0.008978 0 0.00897801 3.3 0.008979 3.3 0.00897901 0 0.008996 0 0.00899601 3.3 0.008997 3.3 0.00899701 0 0.009014 0 0.00901401 3.3 0.009015 3.3 0.00901501 0)
