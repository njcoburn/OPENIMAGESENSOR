Physical 3x3 GF180 row-scan test
.include /foss/pdks/gf180mcuD/libs.tech/ngspice/design.ngspice
.lib /foss/pdks/gf180mcuD/libs.tech/ngspice/sm141064.ngspice typical
.lib /foss/pdks/gf180mcuD/libs.tech/ngspice/sm141064.ngspice diode_typical
.include /foss/designs/build/parasitics/rc-filled/array_reduced.spice
.options gmin=1e-17 abstol=1e-14 reltol=1e-4 chgtol=1e-16 trtol=3 method=gear
Vdd VDD 0 3.3
Vreset VRESET 0 2.0
Xarray COL0 COL1 COL2 0 VRESET VDD RST0 ROW0 RST1 ROW1 RST2 ROW2 array_pex
Vr0 RST0 0 PULSE(0 3.3 50u 10n 10n 20u 3m)
Vs0 ROW0 0 PULSE(0 3.3 970u 10n 10n 60u 3m)
Ilight00 xarray.n339 xarray.n186 0.0p
.ic v(xarray.n339)=0 v(xarray.n333)=0
Ilight01 xarray.n330 xarray.n187 80.0p
.ic v(xarray.n330)=0 v(xarray.n324)=0
Ilight02 xarray.n321 xarray.n176 240.0p
.ic v(xarray.n321)=0 v(xarray.n315)=0
Vr1 RST1 0 PULSE(0 3.3 1050u 10n 10n 20u 3m)
Vs1 ROW1 0 PULSE(0 3.3 1970u 10n 10n 60u 3m)
Ilight10 xarray.n312 xarray.n186 240.0p
.ic v(xarray.n312)=0 v(xarray.n306)=0
Ilight11 xarray.n303 xarray.n187 0.0p
.ic v(xarray.n303)=0 v(xarray.n297)=0
Ilight12 xarray.n294 xarray.n176 80.0p
.ic v(xarray.n294)=0 v(xarray.n288)=0
Vr2 RST2 0 PULSE(0 3.3 2050u 10n 10n 20u 3m)
Vs2 ROW2 0 PULSE(0 3.3 2970u 10n 10n 60u 3m)
Ilight20 xarray.n285 xarray.n186 80.0p
.ic v(xarray.n285)=0 v(xarray.n279)=0
Ilight21 xarray.n276 xarray.n187 240.0p
.ic v(xarray.n276)=0 v(xarray.n270)=0
Ilight22 xarray.n267 xarray.n176 0.0p
.ic v(xarray.n267)=0 v(xarray.n261)=0
Rload0 COL0 0 1Meg
Cload0 COL0 0 1p
.ic v(COL0)=0
Rload1 COL1 0 1Meg
Cload1 COL1 0 1p
.ic v(COL1)=0
Rload2 COL2 0 1Meg
Cload2 COL2 0 1p
.ic v(COL2)=0
.control
set num_threads=1
set wr_singlescale
set wr_vecnames
tran 0.2u 9.05m uic
wrdata /foss/designs/build/parasitics/sim/RC_filled/wave.txt v(ROW0) v(ROW1) v(ROW2) v(COL0) v(COL1) v(COL2) v(xarray.n339)-v(xarray.n186) v(xarray.n330)-v(xarray.n187) v(xarray.n321)-v(xarray.n176) v(xarray.n312)-v(xarray.n186) v(xarray.n303)-v(xarray.n187) v(xarray.n294)-v(xarray.n176) v(xarray.n285)-v(xarray.n186) v(xarray.n276)-v(xarray.n187) v(xarray.n267)-v(xarray.n176)
quit
.endc
.end
