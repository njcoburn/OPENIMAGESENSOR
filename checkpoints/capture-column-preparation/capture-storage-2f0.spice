* Conditional 2f0 MIM candidate; manufacturing option unselected.
* Requires the original PDK model and its corner/Monte Carlo parameters.
* Separate bottom-metal islands; join with upper-metal routes.
.subckt capture_storage_2f0 STORE GND
Xplate0 STORE GND cap_mim_2f0_m4m5_noshield c_width=64u c_length=38.875u
Xplate1 STORE GND cap_mim_2f0_m4m5_noshield c_width=64u c_length=38.875u
Xplate2 STORE GND cap_mim_2f0_m4m5_noshield c_width=64u c_length=38.875u
Xplate3 STORE GND cap_mim_2f0_m4m5_noshield c_width=64u c_length=38.875u
Xplate4 STORE GND cap_mim_2f0_m4m5_noshield c_width=64u c_length=38.875u
Xplate5 STORE GND cap_mim_2f0_m4m5_noshield c_width=64u c_length=38.875u
Xplate6 STORE GND cap_mim_2f0_m4m5_noshield c_width=64u c_length=38.875u
Xplate7 STORE GND cap_mim_2f0_m4m5_noshield c_width=64u c_length=38.875u
.ends capture_storage_2f0
