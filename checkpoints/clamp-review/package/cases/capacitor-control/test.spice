MOS-capacitor isolated diagnostic
.include /foss/pdks/gf180mcuD/libs.tech/ngspice/design.ngspice
.lib /foss/pdks/gf180mcuD/libs.tech/ngspice/sm141064.ngspice typical
.lib /foss/pdks/gf180mcuD/libs.tech/ngspice/sm141064.ngspice diode_typical
.lib /foss/pdks/gf180mcuD/libs.tech/ngspice/sm141064.ngspice res_typical
.lib /foss/pdks/gf180mcuD/libs.tech/ngspice/sm141064.ngspice moscap_typical
.temp 27
.options gmin=1e-17 reltol=1e-6 abstol=1e-12 chgtol=1e-16 trtol=3 method=gear
Vsrc drive 0 PWL(0 0 100u 3.3)
Rdrive drive gate 1000
X0 gate 0 cap_nmos_06v0 c_width=25u c_length=10u

.control
set klu
set num_threads=1
set numdgt=15
set wr_singlescale
set wr_vecnames
tran 100n 153u 0 100n uic
wrdata tran.dat v(gate) i(Vsrc)
quit
.endc
.end
