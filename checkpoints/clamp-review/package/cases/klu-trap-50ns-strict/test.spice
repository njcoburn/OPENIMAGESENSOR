MOS-capacitor isolated diagnostic
.include /foss/pdks/gf180mcuD/libs.tech/ngspice/design.ngspice
.lib /foss/pdks/gf180mcuD/libs.tech/ngspice/sm141064.ngspice typical
.lib /foss/pdks/gf180mcuD/libs.tech/ngspice/sm141064.ngspice diode_typical
.lib /foss/pdks/gf180mcuD/libs.tech/ngspice/sm141064.ngspice res_typical
.lib /foss/pdks/gf180mcuD/libs.tech/ngspice/sm141064.ngspice moscap_typical
.temp 27
.options gmin=1e-17 reltol=1e-6 abstol=1e-12 chgtol=1e-16 trtol=3 method=gear
.options method=trap reltol=1e-7 abstol=1e-14
X1 VDD_B.t144 a_58313_15032.t39 DVSS_B.t364 DVSS_B.t363 nfet_06v0 ad=13p pd=50.52u as=13p ps=50.52u w=50u l=0.7u
X2 VDD_B.t118 a_58313_15032.t85 DVSS_B.t297 DVSS_B.t296 nfet_06v0 ad=13p pd=50.52u as=13p ps=50.52u w=50u l=0.7u
X7 a_58313_15032.t0 a_60857_41340.t20 VDD_B.t2 VDD_B.t1 pfet_06v0 ad=1.3p pd=5.52u as=1.3p ps=5.52u w=5u l=0.7u
X14 VDD_B.t136 a_58313_15032.t107 DVSS_B.t350 DVSS_B.t349 nfet_06v0 ad=13p pd=50.52u as=13p ps=50.52u w=50u l=0.7u
X17 a_58313_15032.t16 a_60857_41340.t12 DVSS_B.t149 DVSS_B.t148 nfet_06v0 ad=1.3p pd=5.52u as=1.3p ps=5.52u w=5u l=0.7u
X18 DVSS_B.t206 a_58313_15032.t60 VDD_B.t77 DVSS_B.t205 nfet_06v0 ad=13p pd=50.52u as=13p ps=50.52u w=50u l=0.7u
X19 DVSS_B.t299 a_58313_15032.t96 VDD_B.t119 DVSS_B.t298 nfet_06v0 ad=13p pd=50.52u as=13p ps=50.52u w=50u l=0.7u
X20 VDD_B.t73 a_60857_41340.t17 a_58313_15032.t18 VDD_B.t72 pfet_06v0 ad=1.3p pd=5.52u as=1.3p ps=5.52u w=5u l=0.7u
X25 DVSS_B.t295 a_58313_15032.t66 VDD_B.t117 DVSS_B.t294 nfet_06v0 ad=13p pd=50.52u as=13p ps=50.52u w=50u l=0.7u
X28 a_58313_15032.t23 a_60857_41340.t26 VDD_B.t114 VDD_B.t113 pfet_06v0 ad=1.3p pd=5.52u as=1.3p ps=5.52u w=5u l=0.7u
X29 VDD_B.t150 a_58313_15032.t35 DVSS_B.t509 DVSS_B.t508 nfet_06v0 ad=13p pd=50.52u as=13p ps=50.52u w=50u l=0.7u
X30 VDD_B.t57 a_58313_15032.t71 DVSS_B.t153 DVSS_B.t152 nfet_06v0 ad=13p pd=50.52u as=13p ps=50.52u w=50u l=0.7u
X31 VDD_B.t83 a_58313_15032.t41 DVSS_B.t225 DVSS_B.t224 nfet_06v0 ad=13p pd=50.52u as=13p ps=50.52u w=50u l=0.7u
X32 VDD_B.t76 a_58313_15032.t51 DVSS_B.t204 DVSS_B.t203 nfet_06v0 ad=13p pd=50.52u as=13p ps=50.52u w=50u l=0.7u
X33 VDD_B.t124 a_58313_15032.t87 DVSS_B.t305 DVSS_B.t304 nfet_06v0 ad=13p pd=50.52u as=13p ps=50.52u w=50u l=0.7u
X35 a_55226_55631# a_54946_42758# VDD_B.t71 ppolyf_u r_width=0.8u r_length=63.855u
X43 DVSS_B.t143 a_58313_15032.t62 VDD_B.t53 DVSS_B.t142 nfet_06v0 ad=13p pd=50.52u as=13p ps=50.52u w=50u l=0.7u
X44 DVSS_B.t293 a_58313_15032.t98 VDD_B.t116 DVSS_B.t292 nfet_06v0 ad=13p pd=50.52u as=13p ps=50.52u w=50u l=0.7u
X47 a_60857_41340.t5 a_59881_41340.t6 DVSS_B.t202 DVSS_B.t201 nfet_06v0 ad=1.3p pd=5.52u as=1.3p ps=5.52u w=5u l=0.7u
X51 VDD_B.t55 a_60857_41340.t29 a_58313_15032.t15 VDD_B.t54 pfet_06v0 ad=1.3p pd=5.52u as=1.3p ps=5.52u w=5u l=0.7u
X52 VDD_B.t102 a_58313_15032.t109 DVSS_B.t268 DVSS_B.t267 nfet_06v0 ad=22p pd=0.10088m as=13p ps=50.52u w=50u l=0.7u
X54 VDD_B.t45 a_53266_42758# VDD_B.t44 ppolyf_u r_width=0.8u r_length=63.855u
X55 a_58313_15032.t12 a_60857_41340.t30 VDD_B.t25 VDD_B.t24 pfet_06v0 ad=1.3p pd=5.52u as=1.3p ps=5.52u w=5u l=0.7u
X56 DVSS_B.t216 a_60857_41340.t13 a_58313_15032.t19 DVSS_B.t215 nfet_06v0 ad=1.3p pd=5.52u as=1.3p ps=5.52u w=5u l=0.7u
X57 VDD_B.t115 a_58313_15032.t37 DVSS_B.t291 DVSS_B.t290 nfet_06v0 ad=13p pd=50.52u as=13p ps=50.52u w=50u l=0.7u
X61 VDD_B.t27 a_58313_15032.t53 DVSS_B.t70 DVSS_B.t69 nfet_06v0 ad=13p pd=50.52u as=13p ps=50.52u w=50u l=0.7u
X63 a_55786_55631# a_55506_42758# VDD_B.t96 ppolyf_u r_width=0.8u r_length=63.855u
X68 VDD_B.t111 a_58313_15032.t75 DVSS_B.t287 DVSS_B.t286 nfet_06v0 ad=13p pd=50.52u as=13p ps=50.52u w=50u l=0.7u
X72 DVSS_B.t84 a_59881_41340.t9 a_60857_41340.t2 DVSS_B.t83 nfet_06v0 ad=1.3p pd=5.52u as=1.3p ps=5.52u w=5u l=0.7u
X73 DVSS_B.t80 a_58313_15032.t100 VDD_B.t33 DVSS_B.t79 nfet_06v0 ad=13p pd=50.52u as=13p ps=50.52u w=50u l=0.7u
X80 VDD_B.t47 a_58313_15032.t43 DVSS_B.t114 DVSS_B.t113 nfet_06v0 ad=13p pd=50.52u as=13p ps=50.52u w=50u l=0.7u
X84 VDD_B.t112 a_58313_15032.t89 DVSS_B.t289 DVSS_B.t288 nfet_06v0 ad=22p pd=0.10088m as=13p ps=50.52u w=50u l=0.7u
X88 VDD_B.t139 a_60857_41340.t33 a_58313_15032.t26 VDD_B.t138 pfet_06v0 ad=1.3p pd=5.52u as=1.3p ps=5.52u w=5u l=0.7u
X93 DVSS_B.t258 a_58313_15032.t64 VDD_B.t92 DVSS_B.t257 nfet_06v0 ad=13p pd=50.52u as=13p ps=50.52u w=50u l=0.7u
X98 DVSS_B.t366 a_58313_15032.t34 VDD_B.t145 DVSS_B.t365 nfet_06v0 ad=13p pd=50.52u as=13p ps=50.52u w=50u l=0.7u
X102 a_55786_55631# a_56066_42758# VDD_B.t0 ppolyf_u r_width=0.8u r_length=63.855u
X104 DVSS_B.t159 a_58313_15032.t102 VDD_B.t62 DVSS_B.t158 nfet_06v0 ad=13p pd=50.52u as=13p ps=50.52u w=50u l=0.7u
X107 a_55226_55631# a_55506_42758# VDD_B.t97 ppolyf_u r_width=0.8u r_length=63.855u
X108 VDD_B.t141 a_58313_15032.t55 DVSS_B.t360 DVSS_B.t359 nfet_06v0 ad=13p pd=50.52u as=13p ps=50.52u w=50u l=0.7u
X113 a_60857_41340.t0 a_59881_41340.t13 VDD_B.t17 VDD_B.t16 pfet_06v0 ad=1.3p pd=5.52u as=1.3p ps=5.52u w=5u l=0.7u
X115 VDD_B.t134 a_56346_55631# a_59881_41340.t4 VDD_B.t133 pfet_06v0 ad=1.3p pd=5.52u as=1.3p ps=5.52u w=5u l=0.7u
X116 VDD_B.t59 a_60857_41340.t15 a_58313_15032.t17 VDD_B.t58 pfet_06v0 ad=2.2p pd=10.88u as=1.3p ps=5.52u w=5u l=0.7u
X118 a_56346_55631# DVSS_B.t337 cap_nmos_06v0 c_width=25u c_length=10u
X119 VDD_B.t135 a_58313_15032.t77 DVSS_B.t348 DVSS_B.t347 nfet_06v0 ad=13p pd=50.52u as=13p ps=50.52u w=50u l=0.7u
X120 VDD_B.t42 a_58313_15032.t83 DVSS_B.t100 DVSS_B.t99 nfet_06v0 ad=13p pd=50.52u as=13p ps=50.52u w=50u l=0.7u
X125 DVSS_B.t303 a_58313_15032.t30 VDD_B.t123 DVSS_B.t302 nfet_06v0 ad=13p pd=50.52u as=22p ps=0.10088m w=50u l=0.7u
X126 a_58313_15032.t22 a_60857_41340.t24 VDD_B.t99 VDD_B.t98 pfet_06v0 ad=1.3p pd=5.52u as=1.3p ps=5.52u w=5u l=0.7u
X135 a_53546_55631# a_53266_42758# VDD_B.t81 ppolyf_u r_width=0.8u r_length=63.855u
X136 VDD_B.t8 a_60857_41340.t21 a_58313_15032.t5 VDD_B.t7 pfet_06v0 ad=1.3p pd=5.52u as=1.3p ps=5.52u w=5u l=0.7u
X138 VDD_B.t78 a_58313_15032.t57 DVSS_B.t212 DVSS_B.t211 nfet_06v0 ad=13p pd=50.52u as=13p ps=50.52u w=50u l=0.7u
X141 a_58313_15032.t13 a_60857_41340.t18 VDD_B.t30 VDD_B.t29 pfet_06v0 ad=1.3p pd=5.52u as=1.3p ps=5.52u w=5u l=0.7u
X144 VDD_B.t89 a_58313_15032.t79 DVSS_B.t250 DVSS_B.t249 nfet_06v0 ad=13p pd=50.52u as=13p ps=50.52u w=50u l=0.7u
X150 DVSS_B.t134 a_58313_15032.t68 VDD_B.t52 DVSS_B.t133 nfet_06v0 ad=13p pd=50.52u as=13p ps=50.52u w=50u l=0.7u
X151 VDD_B.t43 a_58313_15032.t95 DVSS_B.t102 DVSS_B.t101 nfet_06v0 ad=13p pd=50.52u as=13p ps=50.52u w=50u l=0.7u
X152 DVSS_B.t132 a_58313_15032.t104 VDD_B.t51 DVSS_B.t131 nfet_06v0 ad=13p pd=50.52u as=13p ps=50.52u w=50u l=0.7u
X155 VDD_B.t122 a_60857_41340.t27 a_58313_15032.t24 VDD_B.t121 pfet_06v0 ad=1.3p pd=5.52u as=1.3p ps=5.52u w=5u l=0.7u
X156 a_58313_15032.t3 a_60857_41340.t10 DVSS_B.t21 DVSS_B.t20 nfet_06v0 ad=1.3p pd=5.52u as=1.3p ps=5.52u w=5u l=0.7u
X157 DVSS_B.t112 a_58313_15032.t32 VDD_B.t46 DVSS_B.t111 nfet_06v0 ad=13p pd=50.52u as=13p ps=50.52u w=50u l=0.7u
X158 a_58313_15032.t11 a_60857_41340.t28 VDD_B.t22 VDD_B.t21 pfet_06v0 ad=1.3p pd=5.52u as=1.3p ps=5.52u w=5u l=0.7u
X160 DVSS_B.t37 a_60857_41340.t11 a_58313_15032.t6 DVSS_B.t36 nfet_06v0 ad=1.3p pd=5.52u as=1.3p ps=5.52u w=5u l=0.7u
X165 a_58313_15032.t7 a_60857_41340.t36 VDD_B.t11 VDD_B.t10 pfet_06v0 ad=1.3p pd=5.52u as=1.3p ps=5.52u w=5u l=0.7u
X166 DVSS_B.t60 a_58313_15032.t70 VDD_B.t18 DVSS_B.t59 nfet_06v0 ad=13p pd=50.52u as=22p ps=0.10088m w=50u l=0.7u
X167 a_60857_41340.t7 a_59881_41340.t10 DVSS_B.t356 DVSS_B.t355 nfet_06v0 ad=1.3p pd=5.52u as=2.2p ps=10.88u w=5u l=0.7u
X168 VDD_B.t37 a_58313_15032.t49 DVSS_B.t90 DVSS_B.t89 nfet_06v0 ad=22p pd=0.10088m as=13p ps=50.52u w=50u l=0.7u
X170 VDD_B.t94 a_60857_41340.t25 a_58313_15032.t21 VDD_B.t93 pfet_06v0 ad=1.3p pd=5.52u as=1.3p ps=5.52u w=5u l=0.7u
X171 a_56346_55631# DVSS_B.t329 cap_nmos_06v0 c_width=25u c_length=10u
X174 a_56346_55631# a_56066_42758# VDD_B.t82 ppolyf_u r_width=0.8u r_length=63.855u
X177 VDD_B.t61 a_58313_15032.t91 DVSS_B.t157 DVSS_B.t156 nfet_06v0 ad=13p pd=50.52u as=13p ps=50.52u w=50u l=0.7u
X180 a_58313_15032.t28 a_60857_41340.t34 VDD_B.t147 VDD_B.t146 pfet_06v0 ad=1.3p pd=5.52u as=1.3p ps=5.52u w=5u l=0.7u
X181 DVSS_B.t173 a_59881_41340.t7 a_60857_41340.t4 DVSS_B.t172 nfet_06v0 ad=1.3p pd=5.52u as=1.3p ps=5.52u w=5u l=0.7u
X183 DVSS_B.t271 a_58313_15032.t106 VDD_B.t103 DVSS_B.t270 nfet_06v0 ad=13p pd=50.52u as=13p ps=50.52u w=50u l=0.7u
X186 a_58313_15032.t25 a_60857_41340.t14 DVSS_B.t322 DVSS_B.t321 nfet_06v0 ad=1.3p pd=5.52u as=1.3p ps=5.52u w=5u l=0.7u
X191 a_56346_55631# DVSS_B.t341 cap_nmos_06v0 c_width=25u c_length=10u
X192 DVSS_B.t326 a_58313_15032.t50 VDD_B.t126 DVSS_B.t325 nfet_06v0 ad=13p pd=50.52u as=22p ps=0.10088m w=50u l=0.7u
X196 VDD_B.t88 a_58313_15032.t59 DVSS_B.t240 DVSS_B.t239 nfet_06v0 ad=13p pd=50.52u as=13p ps=50.52u w=50u l=0.7u
X197 a_59881_41340.t0 a_56346_55631# DVSS_B.t346 DVSS_B.t345 nfet_06v0 ad=2.2p pd=10.88u as=2.2p ps=10.88u w=5u l=0.7u
X198 VDD_B.t140 a_58313_15032.t45 DVSS_B.t358 DVSS_B.t357 nfet_06v0 ad=13p pd=50.52u as=13p ps=50.52u w=50u l=0.7u
X199 VDD_B.t154 a_58313_15032.t81 DVSS_B.t531 DVSS_B.t530 nfet_06v0 ad=13p pd=50.52u as=13p ps=50.52u w=50u l=0.7u
X201 VDD_B.t107 a_58313_15032.t61 DVSS_B.t279 DVSS_B.t278 nfet_06v0 ad=13p pd=50.52u as=13p ps=50.52u w=50u l=0.7u
X202 VDD_B.t26 a_58313_15032.t97 DVSS_B.t68 DVSS_B.t67 nfet_06v0 ad=13p pd=50.52u as=13p ps=50.52u w=50u l=0.7u
X207 a_54106_55631# a_54386_42758# VDD_B.t35 ppolyf_u r_width=0.8u r_length=63.855u
X209 VDD_B.t6 a_60857_41340.t37 a_58313_15032.t4 VDD_B.t5 pfet_06v0 ad=1.3p pd=5.52u as=1.3p ps=5.52u w=5u l=0.7u
X211 a_60857_41340.t6 a_59881_41340.t11 VDD_B.t75 VDD_B.t74 pfet_06v0 ad=2.2p pd=10.88u as=1.3p ps=5.52u w=5u l=0.7u
X214 a_53546_55631# a_53826_42758# VDD_B.t36 ppolyf_u r_width=0.8u r_length=63.855u
X215 DVSS_B.t167 a_58313_15032.t36 VDD_B.t68 DVSS_B.t166 nfet_06v0 ad=13p pd=50.52u as=13p ps=50.52u w=50u l=0.7u
X216 DVSS_B.t285 a_58313_15032.t72 VDD_B.t110 DVSS_B.t284 nfet_06v0 ad=13p pd=50.52u as=13p ps=50.52u w=50u l=0.7u
X220 DVSS_B.t151 a_58313_15032.t78 VDD_B.t56 DVSS_B.t150 nfet_06v0 ad=13p pd=50.52u as=13p ps=50.52u w=50u l=0.7u
X227 VDD_B.t130 a_56346_55631# a_59881_41340.t2 VDD_B.t129 pfet_06v0 ad=1.3p pd=5.52u as=1.3p ps=5.52u w=5u l=0.7u
X229 VDD_B.t109 a_58313_15032.t93 DVSS_B.t283 DVSS_B.t282 nfet_06v0 ad=13p pd=50.52u as=13p ps=50.52u w=50u l=0.7u
X232 VDD_B.t69 a_58313_15032.t99 DVSS_B.t169 DVSS_B.t168 nfet_06v0 ad=13p pd=50.52u as=13p ps=50.52u w=50u l=0.7u
X234 DVSS_B.t352 a_58313_15032.t108 VDD_B.t137 DVSS_B.t351 nfet_06v0 ad=13p pd=50.52u as=13p ps=50.52u w=50u l=0.7u
X239 VDD_B.t20 a_60857_41340.t19 a_58313_15032.t10 VDD_B.t19 pfet_06v0 ad=1.3p pd=5.52u as=1.3p ps=5.52u w=5u l=0.7u
X240 DVSS_B.t177 a_58313_15032.t88 VDD_B.t70 DVSS_B.t176 nfet_06v0 ad=13p pd=50.52u as=13p ps=50.52u w=50u l=0.7u
X244 DVSS_B.t281 a_58313_15032.t38 VDD_B.t108 DVSS_B.t280 nfet_06v0 ad=13p pd=50.52u as=13p ps=50.52u w=50u l=0.7u
X245 VDD_B.t39 a_58313_15032.t47 DVSS_B.t96 DVSS_B.t95 nfet_06v0 ad=13p pd=50.52u as=13p ps=50.52u w=50u l=0.7u
X246 DVSS_B.t218 a_58313_15032.t74 VDD_B.t80 DVSS_B.t217 nfet_06v0 ad=13p pd=50.52u as=13p ps=50.52u w=50u l=0.7u
X248 a_56346_55631# DVSS_B.t333 cap_nmos_06v0 c_width=25u c_length=10u
X249 VDD_B.t153 a_58313_15032.t63 DVSS_B.t529 DVSS_B.t528 nfet_06v0 ad=13p pd=50.52u as=13p ps=50.52u w=50u l=0.7u
X250 DVSS_B.t163 a_58313_15032.t90 VDD_B.t64 DVSS_B.t162 nfet_06v0 ad=13p pd=50.52u as=22p ps=0.10088m w=50u l=0.7u
X254 a_54106_55631# a_53826_42758# VDD_B.t152 ppolyf_u r_width=0.8u r_length=63.855u
X255 a_58313_15032.t14 a_60857_41340.t16 VDD_B.t41 VDD_B.t40 pfet_06v0 ad=1.3p pd=5.52u as=1.3p ps=5.52u w=5u l=0.7u
X257 VDD_B.t87 a_58313_15032.t105 DVSS_B.t238 DVSS_B.t237 nfet_06v0 ad=13p pd=50.52u as=13p ps=50.52u w=50u l=0.7u
X259 a_56346_55631# DVSS_B.t339 cap_nmos_06v0 c_width=25u c_length=10u
X260 VDD_B.t66 a_59881_41340.t12 a_60857_41340.t3 VDD_B.t65 pfet_06v0 ad=1.3p pd=5.52u as=1.3p ps=5.52u w=5u l=0.7u
X261 DVSS_B.t161 a_58313_15032.t84 VDD_B.t63 DVSS_B.t160 nfet_06v0 ad=13p pd=50.52u as=13p ps=50.52u w=50u l=0.7u
X264 a_58313_15032.t27 a_60857_41340.t22 VDD_B.t143 VDD_B.t142 pfet_06v0 ad=1.3p pd=5.52u as=1.3p ps=5.52u w=5u l=0.7u
X267 DVSS_B.t264 a_58313_15032.t44 VDD_B.t100 DVSS_B.t263 nfet_06v0 ad=13p pd=50.52u as=13p ps=50.52u w=50u l=0.7u
X268 DVSS_B.t515 a_58313_15032.t80 VDD_B.t151 DVSS_B.t514 nfet_06v0 ad=13p pd=50.52u as=13p ps=50.52u w=50u l=0.7u
X275 VDD_B.t85 a_60857_41340.t23 a_58313_15032.t20 VDD_B.t84 pfet_06v0 ad=1.3p pd=5.52u as=1.3p ps=5.52u w=5u l=0.7u
X277 VDD_B.t4 a_60857_41340.t31 a_58313_15032.t2 VDD_B.t3 pfet_06v0 ad=1.3p pd=5.52u as=1.3p ps=5.52u w=5u l=0.7u
X280 VDD_B.t9 a_58313_15032.t65 DVSS_B.t35 DVSS_B.t34 nfet_06v0 ad=13p pd=50.52u as=13p ps=50.52u w=50u l=0.7u
X281 VDD_B.t90 a_58313_15032.t101 DVSS_B.t252 DVSS_B.t251 nfet_06v0 ad=13p pd=50.52u as=13p ps=50.52u w=50u l=0.7u
X285 a_54666_55631# a_54386_42758# VDD_B.t125 ppolyf_u r_width=0.8u r_length=63.855u
X286 a_58313_15032.t29 a_60857_41340.t32 VDD_B.t149 VDD_B.t148 pfet_06v0 ad=1.3p pd=5.52u as=1.3p ps=5.52u w=5u l=0.7u
X287 DVSS_B.t74 a_59881_41340.t5 a_60857_41340.t1 DVSS_B.t73 nfet_06v0 ad=1.3p pd=5.52u as=1.3p ps=5.52u w=5u l=0.7u
X293 DVSS_B.t266 a_58313_15032.t40 VDD_B.t101 DVSS_B.t265 nfet_06v0 ad=13p pd=50.52u as=13p ps=50.52u w=50u l=0.7u
X294 DVSS_B.t273 a_58313_15032.t76 VDD_B.t104 DVSS_B.t272 nfet_06v0 ad=13p pd=50.52u as=13p ps=50.52u w=50u l=0.7u
X295 DVSS_B.t256 a_58313_15032.t86 VDD_B.t91 DVSS_B.t255 nfet_06v0 ad=13p pd=50.52u as=13p ps=50.52u w=50u l=0.7u
X297 a_56346_55631# DVSS_B.t343 cap_nmos_06v0 c_width=25u c_length=10u
X298 DVSS_B.t155 a_58313_15032.t46 VDD_B.t60 DVSS_B.t154 nfet_06v0 ad=13p pd=50.52u as=13p ps=50.52u w=50u l=0.7u
X299 DVSS_B.t236 a_58313_15032.t56 VDD_B.t86 DVSS_B.t235 nfet_06v0 ad=13p pd=50.52u as=13p ps=50.52u w=50u l=0.7u
X300 DVSS_B.t66 a_58313_15032.t82 VDD_B.t23 DVSS_B.t65 nfet_06v0 ad=13p pd=50.52u as=13p ps=50.52u w=50u l=0.7u
X301 DVSS_B.t82 a_58313_15032.t92 VDD_B.t34 DVSS_B.t81 nfet_06v0 ad=13p pd=50.52u as=13p ps=50.52u w=50u l=0.7u
X304 DVSS_B.t11 a_60857_41340.t9 a_58313_15032.t1 DVSS_B.t10 nfet_06v0 ad=2.2p pd=10.88u as=1.3p ps=5.52u w=5u l=0.7u
X308 a_60857_41340.t8 a_59881_41340.t8 DVSS_B.t525 DVSS_B.t524 nfet_06v0 ad=1.3p pd=5.52u as=1.3p ps=5.52u w=5u l=0.7u
X313 VDD_B.t13 a_60857_41340.t35 a_58313_15032.t8 VDD_B.t12 pfet_06v0 ad=1.3p pd=5.52u as=1.3p ps=5.52u w=5u l=0.7u
X314 VDD_B.t120 a_58313_15032.t31 DVSS_B.t301 DVSS_B.t300 nfet_06v0 ad=13p pd=50.52u as=13p ps=50.52u w=50u l=0.7u
X315 VDD_B.t31 a_58313_15032.t103 DVSS_B.t76 DVSS_B.t75 nfet_06v0 ad=13p pd=50.52u as=13p ps=50.52u w=50u l=0.7u
X316 a_56346_55631# DVSS_B.t331 cap_nmos_06v0 c_width=25u c_length=10u
X317 VDD_B.t48 a_58313_15032.t73 DVSS_B.t118 DVSS_B.t117 nfet_06v0 ad=13p pd=50.52u as=13p ps=50.52u w=50u l=0.7u
X324 DVSS_B.t72 a_58313_15032.t42 VDD_B.t28 DVSS_B.t71 nfet_06v0 ad=13p pd=50.52u as=13p ps=50.52u w=50u l=0.7u
X325 DVSS_B.t277 a_58313_15032.t52 VDD_B.t106 DVSS_B.t276 nfet_06v0 ad=13p pd=50.52u as=13p ps=50.52u w=50u l=0.7u
X327 DVSS_B.t124 a_58313_15032.t58 VDD_B.t50 DVSS_B.t123 nfet_06v0 ad=13p pd=50.52u as=13p ps=50.52u w=50u l=0.7u
X328 VDD_B.t49 a_58313_15032.t67 DVSS_B.t120 DVSS_B.t119 nfet_06v0 ad=13p pd=50.52u as=13p ps=50.52u w=50u l=0.7u
X329 DVSS_B.t275 a_58313_15032.t94 VDD_B.t105 DVSS_B.t274 nfet_06v0 ad=13p pd=50.52u as=13p ps=50.52u w=50u l=0.7u
X335 a_59881_41340.t3 a_56346_55631# VDD_B.t132 VDD_B.t131 pfet_06v0 ad=1.3p pd=5.52u as=1.3p ps=5.52u w=5u l=0.7u
X340 a_58313_15032.t9 a_60857_41340.t38 VDD_B.t15 VDD_B.t14 pfet_06v0 ad=1.3p pd=5.52u as=2.2p ps=10.88u w=5u l=0.7u
X346 VDD_B.t67 a_58313_15032.t33 DVSS_B.t165 DVSS_B.t164 nfet_06v0 ad=13p pd=50.52u as=13p ps=50.52u w=50u l=0.7u
X347 DVSS_B.t214 a_58313_15032.t48 VDD_B.t79 DVSS_B.t213 nfet_06v0 ad=13p pd=50.52u as=13p ps=50.52u w=50u l=0.7u
X353 a_59881_41340.t1 a_56346_55631# VDD_B.t128 VDD_B.t127 pfet_06v0 ad=1.3p pd=5.52u as=2.2p ps=10.88u w=5u l=0.7u
X354 a_56346_55631# DVSS_B.t335 cap_nmos_06v0 c_width=25u c_length=10u
X355 DVSS_B.t94 a_58313_15032.t54 VDD_B.t38 DVSS_B.t93 nfet_06v0 ad=13p pd=50.52u as=13p ps=50.52u w=50u l=0.7u
X356 a_54666_55631# a_54946_42758# VDD_B.t32 ppolyf_u r_width=0.8u r_length=63.855u
X357 VDD_B.t95 a_58313_15032.t69 DVSS_B.t260 DVSS_B.t259 nfet_06v0 ad=22p pd=0.10088m as=13p ps=50.52u w=50u l=0.7u
Riso0 VDD_A VDD_B 3.57767920279989
Riso1 VDD_A VDD_B.t0 46.1713636284829
Riso2 VDD_A VDD_B.t100 867.255850739168
Riso3 VDD_A VDD_B.t101 749.819125882406
Riso4 VDD_A VDD_B.t102 48.6780566953363
Riso5 VDD_A VDD_B.t103 123.073679210137
Riso6 VDD_A VDD_B.t104 655.033460178166
Riso7 VDD_A VDD_B.t105 242.53972596961
Riso8 VDD_A VDD_B.t106 1101.96681454426
Riso9 VDD_A VDD_B.t107 1071.49154035099
Riso10 VDD_A VDD_B.t108 688.965631830984
Riso11 VDD_A VDD_B.t109 242.53972596961
Riso12 VDD_A VDD_B.t11 110.014991613334
Riso13 VDD_A VDD_B.t110 752.512486319349
Riso14 VDD_A VDD_B.t111 655.033460178166
Riso15 VDD_A VDD_B.t112 182.301825119715
Riso16 VDD_A VDD_B.t114 175.065993601788
Riso17 VDD_A VDD_B.t115 688.965631830984
Riso18 VDD_A VDD_B.t116 196.555957279878
Riso19 VDD_A VDD_B.t117 996.249346145092
Riso20 VDD_A VDD_B.t118 430.920549344654
Riso21 VDD_A VDD_B.t119 218.792404400696
Riso22 VDD_A VDD_B.t120 512.582740690294
Riso23 VDD_A VDD_B.t122 175.065993601788
Riso24 VDD_A VDD_B.t123 234.715306997471
Riso25 VDD_A VDD_B.t124 392.378431303263
Riso26 VDD_A VDD_B.t125 109.822484425587
Riso27 VDD_A VDD_B.t126 550.904743335841
Riso28 VDD_A VDD_B.t127 5345.80276138463
Riso29 VDD_A VDD_B.t128 34.0128777193117
Riso30 VDD_A VDD_B.t13 140.091676823799
Riso31 VDD_A VDD_B.t130 76.1765184475224
Riso32 VDD_A VDD_B.t132 76.1765184475224
Riso33 VDD_A VDD_B.t134 86.070503544123
Riso34 VDD_A VDD_B.t135 606.923054533199
Riso35 VDD_A VDD_B.t136 108.414419138633
Riso36 VDD_A VDD_B.t137 108.414419138633
Riso37 VDD_A VDD_B.t139 166.739843579243
Riso38 VDD_A VDD_B.t140 920.730103136332
Riso39 VDD_A VDD_B.t141 1121.09111510651
Riso40 VDD_A VDD_B.t143 245.512135103679
Riso41 VDD_A VDD_B.t144 749.819125882406
Riso42 VDD_A VDD_B.t145 569.394453936722
Riso43 VDD_A VDD_B.t147 140.091676823799
Riso44 VDD_A VDD_B.t149 166.739843579243
Riso45 VDD_A VDD_B.t15 55.7033265614166
Riso46 VDD_A VDD_B.t150 628.469019603777
Riso47 VDD_A VDD_B.t151 560.075540468293
Riso48 VDD_A VDD_B.t152 162.662975627487
Riso49 VDD_A VDD_B.t153 1037.23106712417
Riso50 VDD_A VDD_B.t154 514.933877480704
Riso51 VDD_A VDD_B.t17 86.070503544123
Riso52 VDD_A VDD_B.t18 409.490428754462
Riso53 VDD_A VDD_B.t2 235.402131959703
Riso54 VDD_A VDD_B.t20 194.413144624597
Riso55 VDD_A VDD_B.t22 161.976203151513
Riso56 VDD_A VDD_B.t23 514.933877480704
Riso57 VDD_A VDD_B.t24 3649.09875026929
Riso58 VDD_A VDD_B.t25 170.240721720076
Riso59 VDD_A VDD_B.t26 196.555957279878
Riso60 VDD_A VDD_B.t27 1116.94695066929
Riso61 VDD_A VDD_B.t28 809.743288277396
Riso62 VDD_A VDD_B.t3 6704.16697153474
Riso63 VDD_A VDD_B.t30 194.413144624597
Riso64 VDD_A VDD_B.t31 139.16740266758
Riso65 VDD_A VDD_B.t32 90.722288251998
Riso66 VDD_A VDD_B.t33 175.874677068637
Riso67 VDD_A VDD_B.t34 267.6992993848
Riso68 VDD_A VDD_B.t35 151.694959703804
Riso69 VDD_A VDD_B.t36 160.09757460124
Riso70 VDD_A VDD_B.t37 516.262895837967
Riso71 VDD_A VDD_B.t38 1116.94695066929
Riso72 VDD_A VDD_B.t39 968.475054814712
Riso73 VDD_A VDD_B.t4 170.240721720076
Riso74 VDD_A VDD_B.t41 148.693213999135
Riso75 VDD_A VDD_B.t42 471.812888082265
Riso76 VDD_A VDD_B.t43 218.792404400696
Riso77 VDD_A VDD_B.t44 208.654360450604
Riso78 VDD_A VDD_B.t45 612.527989889545
Riso79 VDD_A VDD_B.t46 512.582740690294
Riso80 VDD_A VDD_B.t47 867.255850739168
Riso81 VDD_A VDD_B.t48 703.815372220793
Riso82 VDD_A VDD_B.t49 950.009072486927
Riso83 VDD_A VDD_B.t50 1114.48042072126
Riso84 VDD_A VDD_B.t51 139.16740266758
Riso85 VDD_A VDD_B.t52 950.009072486927
Riso86 VDD_A VDD_B.t53 1071.49154035099
Riso87 VDD_A VDD_B.t55 161.976203151513
Riso88 VDD_A VDD_B.t56 606.923054533199
Riso89 VDD_A VDD_B.t57 752.512486319349
Riso90 VDD_A VDD_B.t58 12439.2498471354
Riso91 VDD_A VDD_B.t59 71.2758376676999
Riso92 VDD_A VDD_B.t6 110.014991613334
Riso93 VDD_A VDD_B.t60 920.730103136332
Riso94 VDD_A VDD_B.t61 267.6992993848
Riso95 VDD_A VDD_B.t62 156.753122177395
Riso96 VDD_A VDD_B.t63 471.812888082265
Riso97 VDD_A VDD_B.t64 150.502237996273
Riso98 VDD_A VDD_B.t66 92.4488625422303
Riso99 VDD_A VDD_B.t67 569.394453936722
Riso100 VDD_A VDD_B.t68 628.469019603777
Riso101 VDD_A VDD_B.t69 175.874677068637
Riso102 VDD_A VDD_B.t70 392.378431303263
Riso103 VDD_A VDD_B.t71 86.8089660144854
Riso104 VDD_A VDD_B.t73 148.693213999135
Riso105 VDD_A VDD_B.t75 92.4488625422303
Riso106 VDD_A VDD_B.t76 1101.96681454426
Riso107 VDD_A VDD_B.t77 1097.64290455039
Riso108 VDD_A VDD_B.t78 1114.48042072126
Riso109 VDD_A VDD_B.t79 968.475054814712
Riso110 VDD_A VDD_B.t8 235.402131959703
Riso111 VDD_A VDD_B.t80 703.815372220793
Riso112 VDD_A VDD_B.t81 220.82657080313
Riso113 VDD_A VDD_B.t82 34.021973644248
Riso114 VDD_A VDD_B.t83 809.743288277396
Riso115 VDD_A VDD_B.t85 245.512135103679
Riso116 VDD_A VDD_B.t86 1121.09111510651
Riso117 VDD_A VDD_B.t87 123.073679210137
Riso118 VDD_A VDD_B.t88 1097.64290455039
Riso119 VDD_A VDD_B.t89 560.075540468293
Riso120 VDD_A VDD_B.t9 996.249346145092
Riso121 VDD_A VDD_B.t90 156.753122177395
Riso122 VDD_A VDD_B.t91 430.920549344654
Riso123 VDD_A VDD_B.t92 1037.23106712417
Riso124 VDD_A VDD_B.t94 217.902299789546
Riso125 VDD_A VDD_B.t95 460.54038034442
Riso126 VDD_A VDD_B.t96 45.664408341547
Riso127 VDD_A VDD_B.t97 65.5495674597151
Riso128 VDD_A VDD_B.t99 217.902299789546
Riso129 VDD_B VDD_B.t0 68.5039944487958
Riso130 VDD_B VDD_B.t100 401.945938661764
Riso131 VDD_B VDD_B.t101 375.981770442791
Riso132 VDD_B VDD_B.t102 13.7846419176735
Riso133 VDD_B VDD_B.t103 34.7348073467319
Riso134 VDD_B VDD_B.t104 179.354505727747
Riso135 VDD_B VDD_B.t105 67.3560559067177
Riso136 VDD_B VDD_B.t106 397.57018433698
Riso137 VDD_B VDD_B.t107 328.027912268726
Riso138 VDD_B VDD_B.t108 358.175622315427
Riso139 VDD_B VDD_B.t109 67.3560559067177
Riso140 VDD_B VDD_B.t11 37.9142737460212
Riso141 VDD_B VDD_B.t110 208.01833157314
Riso142 VDD_B VDD_B.t111 179.354505727747
Riso143 VDD_B VDD_B.t112 50.0810900701896
Riso144 VDD_B VDD_B.t114 39.5394730915894
Riso145 VDD_B VDD_B.t115 358.175622315427
Riso146 VDD_B VDD_B.t116 54.9092743073233
Riso147 VDD_B VDD_B.t117 292.151549219701
Riso148 VDD_B VDD_B.t118 117.832075142724
Riso149 VDD_B VDD_B.t119 60.9410440973756
Riso150 VDD_B VDD_B.t120 292.015083174228
Riso151 VDD_B VDD_B.t122 39.5394730915894
Riso152 VDD_B VDD_B.t123 137.029732239108
Riso153 VDD_B VDD_B.t124 107.518733366165
Riso154 VDD_B VDD_B.t125 162.942531305319
Riso155 VDD_B VDD_B.t126 206.986615903119
Riso156 VDD_B VDD_B.t127 4317.27897275853
Riso157 VDD_B VDD_B.t128 24.5057817141784
Riso158 VDD_B VDD_B.t13 44.9178042028332
Riso159 VDD_B VDD_B.t130 43.2361657103171
Riso160 VDD_B VDD_B.t132 43.2361657103171
Riso161 VDD_B VDD_B.t134 37.9254547342994
Riso162 VDD_B VDD_B.t135 165.778273665217
Riso163 VDD_B VDD_B.t136 30.6546467389065
Riso164 VDD_B VDD_B.t137 30.6546467389065
Riso165 VDD_B VDD_B.t139 48.0375857557769
Riso166 VDD_B VDD_B.t140 409.37029254679
Riso167 VDD_B VDD_B.t141 375.382106661546
Riso168 VDD_B VDD_B.t143 47.7737305889389
Riso169 VDD_B VDD_B.t144 375.981770442791
Riso170 VDD_B VDD_B.t145 315.575143186705
Riso171 VDD_B VDD_B.t147 44.9178042028332
Riso172 VDD_B VDD_B.t149 48.0375857557769
Riso173 VDD_B VDD_B.t15 20.1950084320061
Riso174 VDD_B VDD_B.t150 337.838361746786
Riso175 VDD_B VDD_B.t151 152.805054356142
Riso176 VDD_B VDD_B.t152 241.341444213614
Riso177 VDD_B VDD_B.t153 310.267652041742
Riso178 VDD_B VDD_B.t154 140.477040888115
Riso179 VDD_B VDD_B.t17 37.9254547342994
Riso180 VDD_B VDD_B.t18 114.053833115568
Riso181 VDD_B VDD_B.t2 42.0670732138526
Riso182 VDD_B VDD_B.t20 32.6327244937161
Riso183 VDD_B VDD_B.t22 38.3321668632564
Riso184 VDD_B VDD_B.t23 140.477040888115
Riso185 VDD_B VDD_B.t24 928.598233950434
Riso186 VDD_B VDD_B.t25 43.6625994018229
Riso187 VDD_B VDD_B.t26 54.9092743073233
Riso188 VDD_B VDD_B.t27 387.725051912271
Riso189 VDD_B VDD_B.t28 390.716941137032
Riso190 VDD_B VDD_B.t3 1706.03155352169
Riso191 VDD_B VDD_B.t30 32.6327244937161
Riso192 VDD_B VDD_B.t31 39.1909724443421
Riso193 VDD_B VDD_B.t32 134.603759611791
Riso194 VDD_B VDD_B.t33 49.2726573606995
Riso195 VDD_B VDD_B.t34 74.1303761852447
Riso196 VDD_B VDD_B.t35 225.068307730228
Riso197 VDD_B VDD_B.t36 237.535184145685
Riso198 VDD_B VDD_B.t37 211.041299209433
Riso199 VDD_B VDD_B.t38 387.725051912271
Riso200 VDD_B VDD_B.t39 412.848357584442
Riso201 VDD_B VDD_B.t4 43.6625994018229
Riso202 VDD_B VDD_B.t41 24.0994844604896
Riso203 VDD_B VDD_B.t42 128.816877624127
Riso204 VDD_B VDD_B.t43 60.9410440973756
Riso205 VDD_B VDD_B.t44 309.578405893292
Riso206 VDD_B VDD_B.t45 908.801705679755
Riso207 VDD_B VDD_B.t46 292.015083174228
Riso208 VDD_B VDD_B.t47 401.945938661764
Riso209 VDD_B VDD_B.t48 193.466913125645
Riso210 VDD_B VDD_B.t49 273.980903597847
Riso211 VDD_B VDD_B.t50 361.010019038086
Riso212 VDD_B VDD_B.t51 39.1909724443421
Riso213 VDD_B VDD_B.t52 273.980903597847
Riso214 VDD_B VDD_B.t53 328.027912268726
Riso215 VDD_B VDD_B.t55 38.3321668632564
Riso216 VDD_B VDD_B.t56 165.778273665217
Riso217 VDD_B VDD_B.t57 208.01833157314
Riso218 VDD_B VDD_B.t58 1987.54153917485
Riso219 VDD_B VDD_B.t59 11.4128144898512
Riso220 VDD_B VDD_B.t6 37.9142737460212
Riso221 VDD_B VDD_B.t60 409.37029254679
Riso222 VDD_B VDD_B.t61 74.1303761852447
Riso223 VDD_B VDD_B.t62 44.0343078819666
Riso224 VDD_B VDD_B.t63 128.816877624127
Riso225 VDD_B VDD_B.t64 41.5653915279237
Riso226 VDD_B VDD_B.t66 35.5999688160778
Riso227 VDD_B VDD_B.t67 315.575143186705
Riso228 VDD_B VDD_B.t68 337.838361746786
Riso229 VDD_B VDD_B.t69 49.2726573606995
Riso230 VDD_B VDD_B.t70 107.518733366165
Riso231 VDD_B VDD_B.t71 128.797602206695
Riso232 VDD_B VDD_B.t73 24.0994844604896
Riso233 VDD_B VDD_B.t75 35.5999688160778
Riso234 VDD_B VDD_B.t76 397.57018433698
Riso235 VDD_B VDD_B.t77 345.077027897946
Riso236 VDD_B VDD_B.t78 361.010019038086
Riso237 VDD_B VDD_B.t79 412.848357584442
Riso238 VDD_B VDD_B.t8 42.0670732138526
Riso239 VDD_B VDD_B.t80 193.466913125645
Riso240 VDD_B VDD_B.t81 327.638193711743
Riso241 VDD_B VDD_B.t82 50.4780649845239
Riso242 VDD_B VDD_B.t83 390.716941137032
Riso243 VDD_B VDD_B.t85 47.7737305889389
Riso244 VDD_B VDD_B.t86 375.382106661546
Riso245 VDD_B VDD_B.t87 34.7348073467319
Riso246 VDD_B VDD_B.t88 345.077027897946
Riso247 VDD_B VDD_B.t89 152.805054356142
Riso248 VDD_B VDD_B.t9 292.151549219701
Riso249 VDD_B VDD_B.t90 44.0343078819666
Riso250 VDD_B VDD_B.t91 117.832075142724
Riso251 VDD_B VDD_B.t92 310.267652041742
Riso252 VDD_B VDD_B.t94 46.2028766713207
Riso253 VDD_B VDD_B.t95 131.006599366531
Riso254 VDD_B VDD_B.t96 67.7518299157861
Riso255 VDD_B VDD_B.t97 97.2552433476576
Riso256 VDD_B VDD_B.t99 46.2028766713207
Riso257 VDD_B.t0 VDD_B.t100 14563.4225324885
Riso258 VDD_B.t0 VDD_B.t101 12509.9781628694
Riso259 VDD_B.t0 VDD_B.t102 883.724731741013
Riso260 VDD_B.t0 VDD_B.t103 2232.50902734428
Riso261 VDD_B.t0 VDD_B.t104 11800.7428284951
Riso262 VDD_B.t0 VDD_B.t105 4392.52179499775
Riso263 VDD_B.t0 VDD_B.t106 18986.2856830792
Riso264 VDD_B.t0 VDD_B.t107 18882.9548934882
Riso265 VDD_B.t0 VDD_B.t108 11463.0190428695
Riso266 VDD_B.t0 VDD_B.t109 4392.52179499775
Riso267 VDD_B.t0 VDD_B.t11 2007.03863144623
Riso268 VDD_B.t0 VDD_B.t110 13518.9901983825
Riso269 VDD_B.t0 VDD_B.t111 11800.7428284951
Riso270 VDD_B.t0 VDD_B.t112 3298.63752849134
Riso271 VDD_B.t0 VDD_B.t114 3301.47961680024
Riso272 VDD_B.t0 VDD_B.t115 11463.0190428695
Riso273 VDD_B.t0 VDD_B.t116 3561.26452120942
Riso274 VDD_B.t0 VDD_B.t117 17684.0092783188
Riso275 VDD_B.t0 VDD_B.t118 7791.87719752385
Riso276 VDD_B.t0 VDD_B.t119 3963.2691040723
Riso277 VDD_B.t0 VDD_B.t120 8473.70640137432
Riso278 VDD_B.t0 VDD_B.t122 3301.47961680024
Riso279 VDD_B.t0 VDD_B.t123 3874.01248276751
Riso280 VDD_B.t0 VDD_B.t124 7097.63811056489
Riso281 VDD_B.t0 VDD_B.t125 92.6067938980922
Riso282 VDD_B.t0 VDD_B.t126 9446.82331594509
Riso283 VDD_B.t0 VDD_B.t127 87443.7752561934
Riso284 VDD_B.t0 VDD_B.t128 561.869493248303
Riso285 VDD_B.t0 VDD_B.t13 2569.38375142202
Riso286 VDD_B.t0 VDD_B.t130 1290.07033396031
Riso287 VDD_B.t0 VDD_B.t132 1290.07033396031
Riso288 VDD_B.t0 VDD_B.t134 1509.16567504975
Riso289 VDD_B.t0 VDD_B.t135 10945.6144009128
Riso290 VDD_B.t0 VDD_B.t136 1967.35927147196
Riso291 VDD_B.t0 VDD_B.t137 1967.35927147196
Riso292 VDD_B.t0 VDD_B.t139 3082.37588276874
Riso293 VDD_B.t0 VDD_B.t140 15518.6881576286
Riso294 VDD_B.t0 VDD_B.t141 19500.3476760015
Riso295 VDD_B.t0 VDD_B.t143 4648.76422205629
Riso296 VDD_B.t0 VDD_B.t144 12509.9781628694
Riso297 VDD_B.t0 VDD_B.t145 9430.32238285542
Riso298 VDD_B.t0 VDD_B.t147 2569.38375142202
Riso299 VDD_B.t0 VDD_B.t149 3082.37588276874
Riso300 VDD_B.t0 VDD_B.t15 1009.39737126389
Riso301 VDD_B.t0 VDD_B.t150 10430.9784901037
Riso302 VDD_B.t0 VDD_B.t151 10109.5456435727
Riso303 VDD_B.t0 VDD_B.t152 136.996123426586
Riso304 VDD_B.t0 VDD_B.t153 18348.4508762605
Riso305 VDD_B.t0 VDD_B.t154 9301.32578846545
Riso306 VDD_B.t0 VDD_B.t17 1509.16567504975
Riso307 VDD_B.t0 VDD_B.t18 7343.41132362697
Riso308 VDD_B.t0 VDD_B.t2 4468.47728438021
Riso309 VDD_B.t0 VDD_B.t20 3697.73324646841
Riso310 VDD_B.t0 VDD_B.t22 3045.48305966259
Riso311 VDD_B.t0 VDD_B.t23 9301.32578846545
Riso312 VDD_B.t0 VDD_B.t24 68156.8953861466
Riso313 VDD_B.t0 VDD_B.t25 3177.70874463404
Riso314 VDD_B.t0 VDD_B.t26 3561.26452120942
Riso315 VDD_B.t0 VDD_B.t27 19336.6163479006
Riso316 VDD_B.t0 VDD_B.t28 13551.4733264214
Riso317 VDD_B.t0 VDD_B.t3 125218.646630605
Riso318 VDD_B.t0 VDD_B.t30 3697.73324646841
Riso319 VDD_B.t0 VDD_B.t31 2523.56740484841
Riso320 VDD_B.t0 VDD_B.t32 76.5224442001775
Riso321 VDD_B.t0 VDD_B.t33 3187.33536754592
Riso322 VDD_B.t0 VDD_B.t34 4847.19795092851
Riso323 VDD_B.t0 VDD_B.t35 127.849474899998
Riso324 VDD_B.t0 VDD_B.t36 134.702056664882
Riso325 VDD_B.t0 VDD_B.t37 8772.56310338653
Riso326 VDD_B.t0 VDD_B.t38 19336.6163479006
Riso327 VDD_B.t0 VDD_B.t39 16388.2158156273
Riso328 VDD_B.t0 VDD_B.t4 3177.70874463404
Riso329 VDD_B.t0 VDD_B.t41 2831.43897034011
Riso330 VDD_B.t0 VDD_B.t42 8527.32641817352
Riso331 VDD_B.t0 VDD_B.t43 3963.2691040723
Riso332 VDD_B.t0 VDD_B.t44 175.058261770304
Riso333 VDD_B.t0 VDD_B.t45 568.174438313033
Riso334 VDD_B.t0 VDD_B.t46 8473.70640137432
Riso335 VDD_B.t0 VDD_B.t47 14563.4225324885
Riso336 VDD_B.t0 VDD_B.t48 12663.3845747252
Riso337 VDD_B.t0 VDD_B.t49 16914.8765153028
Riso338 VDD_B.t0 VDD_B.t50 19474.5876426515
Riso339 VDD_B.t0 VDD_B.t51 2523.56740484841
Riso340 VDD_B.t0 VDD_B.t52 16914.8765153028
Riso341 VDD_B.t0 VDD_B.t53 18882.9548934882
Riso342 VDD_B.t0 VDD_B.t55 3045.48305966259
Riso343 VDD_B.t0 VDD_B.t56 10945.6144009128
Riso344 VDD_B.t0 VDD_B.t57 13518.9901983825
Riso345 VDD_B.t0 VDD_B.t58 236980.470602079
Riso346 VDD_B.t0 VDD_B.t59 1357.8058095676
Riso347 VDD_B.t0 VDD_B.t6 2007.03863144623
Riso348 VDD_B.t0 VDD_B.t60 15518.6881576286
Riso349 VDD_B.t0 VDD_B.t61 4847.19795092851
Riso350 VDD_B.t0 VDD_B.t62 2841.57848013764
Riso351 VDD_B.t0 VDD_B.t63 8527.32641817352
Riso352 VDD_B.t0 VDD_B.t64 2724.56897490939
Riso353 VDD_B.t0 VDD_B.t66 1658.02803060423
Riso354 VDD_B.t0 VDD_B.t67 9430.32238285542
Riso355 VDD_B.t0 VDD_B.t68 10430.9784901037
Riso356 VDD_B.t0 VDD_B.t69 3187.33536754592
Riso357 VDD_B.t0 VDD_B.t70 7097.63811056489
Riso358 VDD_B.t0 VDD_B.t71 73.1197097956983
Riso359 VDD_B.t0 VDD_B.t73 2831.43897034011
Riso360 VDD_B.t0 VDD_B.t75 1658.02803060423
Riso361 VDD_B.t0 VDD_B.t76 18986.2856830792
Riso362 VDD_B.t0 VDD_B.t77 19264.5700788428
Riso363 VDD_B.t0 VDD_B.t78 19474.5876426515
Riso364 VDD_B.t0 VDD_B.t79 16388.2158156273
Riso365 VDD_B.t0 VDD_B.t8 4468.47728438021
Riso366 VDD_B.t0 VDD_B.t80 12663.3845747252
Riso367 VDD_B.t0 VDD_B.t81 185.567110154149
Riso368 VDD_B.t0 VDD_B.t82 22.0742952965242
Riso369 VDD_B.t0 VDD_B.t83 13551.4733264214
Riso370 VDD_B.t0 VDD_B.t85 4648.76422205629
Riso371 VDD_B.t0 VDD_B.t86 19500.3476760015
Riso372 VDD_B.t0 VDD_B.t87 2232.50902734428
Riso373 VDD_B.t0 VDD_B.t88 19264.5700788428
Riso374 VDD_B.t0 VDD_B.t89 10109.5456435727
Riso375 VDD_B.t0 VDD_B.t9 17684.0092783188
Riso376 VDD_B.t0 VDD_B.t90 2841.57848013764
Riso377 VDD_B.t0 VDD_B.t91 7791.87719752385
Riso378 VDD_B.t0 VDD_B.t92 18348.4508762605
Riso379 VDD_B.t0 VDD_B.t94 4116.46856243757
Riso380 VDD_B.t0 VDD_B.t95 8221.98365604176
Riso381 VDD_B.t0 VDD_B.t96 20.2858653994822
Riso382 VDD_B.t0 VDD_B.t97 53.6789918848391
Riso383 VDD_B.t0 VDD_B.t99 4116.46856243757
Riso384 VDD_B.t1 VDD_B.t19 158.648
Riso385 VDD_B.t1 VDD_B.t7 158.648
Riso386 VDD_B.t10 VDD_B.t12 158.648
Riso387 VDD_B.t10 VDD_B.t5 158.648
Riso388 VDD_B.t100 VDD_B.t101 42.7029555210061
Riso389 VDD_B.t100 VDD_B.t102 694.373679082448
Riso390 VDD_B.t100 VDD_B.t103 1385.16711053232
Riso391 VDD_B.t100 VDD_B.t104 458.219770125129
Riso392 VDD_B.t100 VDD_B.t105 1121.58186855572
Riso393 VDD_B.t100 VDD_B.t106 81.3824084705324
Riso394 VDD_B.t100 VDD_B.t107 165.940875239316
Riso395 VDD_B.t100 VDD_B.t108 48.2141135044291
Riso396 VDD_B.t100 VDD_B.t109 1121.58186855572
Riso397 VDD_B.t100 VDD_B.t11 4656.07704379451
Riso398 VDD_B.t100 VDD_B.t110 370.855388422495
Riso399 VDD_B.t100 VDD_B.t111 458.219770125129
Riso400 VDD_B.t100 VDD_B.t112 433.891897133333
Riso401 VDD_B.t100 VDD_B.t114 6986.59240490015
Riso402 VDD_B.t100 VDD_B.t115 48.2141135044291
Riso403 VDD_B.t100 VDD_B.t116 1248.53101019061
Riso404 VDD_B.t100 VDD_B.t117 212.733777281075
Riso405 VDD_B.t100 VDD_B.t118 727.174073727447
Riso406 VDD_B.t100 VDD_B.t119 1187.7966646101
Riso407 VDD_B.t100 VDD_B.t120 61.3378808219145
Riso408 VDD_B.t100 VDD_B.t122 6986.59240490015
Riso409 VDD_B.t100 VDD_B.t123 32.3514952938677
Riso410 VDD_B.t100 VDD_B.t124 787.249139229879
Riso411 VDD_B.t100 VDD_B.t125 34640.3293852641
Riso412 VDD_B.t100 VDD_B.t126 35.6024053309566
Riso413 VDD_B.t100 VDD_B.t127 208564.213087038
Riso414 VDD_B.t100 VDD_B.t128 1337.10109999738
Riso415 VDD_B.t100 VDD_B.t13 5935.2894563017
Riso416 VDD_B.t100 VDD_B.t130 3052.17242337081
Riso417 VDD_B.t100 VDD_B.t132 3052.17242337081
Riso418 VDD_B.t100 VDD_B.t134 3540.85171126568
Riso419 VDD_B.t100 VDD_B.t135 506.526271819467
Riso420 VDD_B.t100 VDD_B.t136 1380.42663350841
Riso421 VDD_B.t100 VDD_B.t137 1380.42663350841
Riso422 VDD_B.t100 VDD_B.t139 7070.74357837353
Riso423 VDD_B.t100 VDD_B.t140 37.8140902361695
Riso424 VDD_B.t100 VDD_B.t141 109.825767153291
Riso425 VDD_B.t100 VDD_B.t143 7108.66349745628
Riso426 VDD_B.t100 VDD_B.t144 42.7029555210061
Riso427 VDD_B.t100 VDD_B.t145 57.9511109446611
Riso428 VDD_B.t100 VDD_B.t147 5935.2894563017
Riso429 VDD_B.t100 VDD_B.t149 7070.74357837353
Riso430 VDD_B.t100 VDD_B.t15 2348.01277116462
Riso431 VDD_B.t100 VDD_B.t150 53.4328166500979
Riso432 VDD_B.t100 VDD_B.t151 557.818178857911
Riso433 VDD_B.t100 VDD_B.t152 51307.3355059756
Riso434 VDD_B.t100 VDD_B.t153 188.420748276079
Riso435 VDD_B.t100 VDD_B.t154 611.914701113251
Riso436 VDD_B.t100 VDD_B.t17 3540.85171126568
Riso437 VDD_B.t100 VDD_B.t18 169.790548148494
Riso438 VDD_B.t100 VDD_B.t2 5782.89391805527
Riso439 VDD_B.t100 VDD_B.t20 4264.18126601093
Riso440 VDD_B.t100 VDD_B.t22 6814.64027993373
Riso441 VDD_B.t100 VDD_B.t23 611.914701113251
Riso442 VDD_B.t100 VDD_B.t24 154865.393228737
Riso443 VDD_B.t100 VDD_B.t25 7227.21567081837
Riso444 VDD_B.t100 VDD_B.t26 1248.53101019061
Riso445 VDD_B.t100 VDD_B.t27 94.7636818469557
Riso446 VDD_B.t100 VDD_B.t28 37.2327066554401
Riso447 VDD_B.t100 VDD_B.t3 284520.514617812
Riso448 VDD_B.t100 VDD_B.t30 4264.18126601093
Riso449 VDD_B.t100 VDD_B.t31 1372.19039287798
Riso450 VDD_B.t100 VDD_B.t32 28615.7244035349
Riso451 VDD_B.t100 VDD_B.t33 1301.29742843352
Riso452 VDD_B.t100 VDD_B.t34 1052.07213623634
Riso453 VDD_B.t100 VDD_B.t35 47847.7918042788
Riso454 VDD_B.t100 VDD_B.t36 50498.1538796511
Riso455 VDD_B.t100 VDD_B.t37 26.2878457374936
Riso456 VDD_B.t100 VDD_B.t38 94.7636818469557
Riso457 VDD_B.t100 VDD_B.t39 44.2811508841418
Riso458 VDD_B.t100 VDD_B.t4 7227.21567081837
Riso459 VDD_B.t100 VDD_B.t41 3068.35210327971
Riso460 VDD_B.t100 VDD_B.t42 668.516697855381
Riso461 VDD_B.t100 VDD_B.t43 1187.7966646101
Riso462 VDD_B.t100 VDD_B.t44 65813.9889248089
Riso463 VDD_B.t100 VDD_B.t45 193204.255380369
Riso464 VDD_B.t100 VDD_B.t46 61.3378808219145
Riso465 VDD_B.t100 VDD_B.t47 0.066954995047411
Riso466 VDD_B.t100 VDD_B.t48 412.988783347162
Riso467 VDD_B.t100 VDD_B.t49 238.736056687114
Riso468 VDD_B.t100 VDD_B.t50 126.664818243705
Riso469 VDD_B.t100 VDD_B.t51 1372.19039287798
Riso470 VDD_B.t100 VDD_B.t52 238.736056687114
Riso471 VDD_B.t100 VDD_B.t53 165.940875239316
Riso472 VDD_B.t100 VDD_B.t55 6814.64027993373
Riso473 VDD_B.t100 VDD_B.t56 506.526271819467
Riso474 VDD_B.t100 VDD_B.t57 370.855388422495
Riso475 VDD_B.t100 VDD_B.t58 250422.883727675
Riso476 VDD_B.t100 VDD_B.t59 1440.5757267653
Riso477 VDD_B.t100 VDD_B.t6 4656.07704379451
Riso478 VDD_B.t100 VDD_B.t60 37.8140902361695
Riso479 VDD_B.t100 VDD_B.t61 1052.07213623634
Riso480 VDD_B.t100 VDD_B.t62 1343.41514117875
Riso481 VDD_B.t100 VDD_B.t63 668.516697855381
Riso482 VDD_B.t100 VDD_B.t64 502.068156916961
Riso483 VDD_B.t100 VDD_B.t66 3868.0817367061
Riso484 VDD_B.t100 VDD_B.t67 57.9511109446611
Riso485 VDD_B.t100 VDD_B.t68 53.4328166500979
Riso486 VDD_B.t100 VDD_B.t69 1301.29742843352
Riso487 VDD_B.t100 VDD_B.t70 787.249139229879
Riso488 VDD_B.t100 VDD_B.t71 27381.379979375
Riso489 VDD_B.t100 VDD_B.t73 3068.35210327971
Riso490 VDD_B.t100 VDD_B.t75 3868.0817367061
Riso491 VDD_B.t100 VDD_B.t76 81.3824084705324
Riso492 VDD_B.t100 VDD_B.t77 145.355394122071
Riso493 VDD_B.t100 VDD_B.t78 126.664818243705
Riso494 VDD_B.t100 VDD_B.t79 44.2811508841418
Riso495 VDD_B.t100 VDD_B.t8 5782.89391805527
Riso496 VDD_B.t100 VDD_B.t80 412.988783347162
Riso497 VDD_B.t100 VDD_B.t81 69653.360963819
Riso498 VDD_B.t100 VDD_B.t82 10731.2485192599
Riso499 VDD_B.t100 VDD_B.t83 37.2327066554401
Riso500 VDD_B.t100 VDD_B.t85 7108.66349745628
Riso501 VDD_B.t100 VDD_B.t86 109.825767153291
Riso502 VDD_B.t100 VDD_B.t87 1385.16711053232
Riso503 VDD_B.t100 VDD_B.t88 145.355394122071
Riso504 VDD_B.t100 VDD_B.t89 557.818178857911
Riso505 VDD_B.t100 VDD_B.t9 212.733777281075
Riso506 VDD_B.t100 VDD_B.t90 1343.41514117875
Riso507 VDD_B.t100 VDD_B.t91 727.174073727447
Riso508 VDD_B.t100 VDD_B.t92 188.420748276079
Riso509 VDD_B.t100 VDD_B.t94 7559.20666168931
Riso510 VDD_B.t100 VDD_B.t95 136.21108352287
Riso511 VDD_B.t100 VDD_B.t96 14403.5181357257
Riso512 VDD_B.t100 VDD_B.t97 20675.7169967747
Riso513 VDD_B.t100 VDD_B.t99 7559.20666168931
Riso514 VDD_B.t101 VDD_B.t102 683.322141753208
Riso515 VDD_B.t101 VDD_B.t103 1388.65703710239
Riso516 VDD_B.t101 VDD_B.t104 516.52895645885
Riso517 VDD_B.t101 VDD_B.t105 1183.75525240334
Riso518 VDD_B.t101 VDD_B.t106 102.848120146156
Riso519 VDD_B.t101 VDD_B.t107 199.742992982124
Riso520 VDD_B.t101 VDD_B.t108 34.8785525112217
Riso521 VDD_B.t101 VDD_B.t109 1183.75525240334
Riso522 VDD_B.t101 VDD_B.t11 4317.33758027708
Riso523 VDD_B.t101 VDD_B.t110 423.612411146204
Riso524 VDD_B.t101 VDD_B.t111 516.52895645885
Riso525 VDD_B.t101 VDD_B.t112 469.902928591919
Riso526 VDD_B.t101 VDD_B.t114 6705.147159617
Riso527 VDD_B.t101 VDD_B.t115 34.8785525112217
Riso528 VDD_B.t101 VDD_B.t116 1297.45238728643
Riso529 VDD_B.t101 VDD_B.t117 251.732093268587
Riso530 VDD_B.t101 VDD_B.t118 796.20936395615
Riso531 VDD_B.t101 VDD_B.t119 1244.2452380906
Riso532 VDD_B.t101 VDD_B.t120 45.5351783824288
Riso533 VDD_B.t101 VDD_B.t122 6705.147159617
Riso534 VDD_B.t101 VDD_B.t123 24.1831370736629
Riso535 VDD_B.t101 VDD_B.t124 857.269704197132
Riso536 VDD_B.t101 VDD_B.t125 29756.0386782385
Riso537 VDD_B.t101 VDD_B.t126 45.4483352680896
Riso538 VDD_B.t101 VDD_B.t127 175678.034336638
Riso539 VDD_B.t101 VDD_B.t128 1135.39919144796
Riso540 VDD_B.t101 VDD_B.t13 5532.3088306395
Riso541 VDD_B.t101 VDD_B.t130 2646.46262217298
Riso542 VDD_B.t101 VDD_B.t132 2646.46262217298
Riso543 VDD_B.t101 VDD_B.t134 3165.01222825586
Riso544 VDD_B.t101 VDD_B.t135 567.460246932697
Riso545 VDD_B.t101 VDD_B.t136 1370.97437010682
Riso546 VDD_B.t101 VDD_B.t137 1370.97437010682
Riso547 VDD_B.t101 VDD_B.t139 6642.25134133414
Riso548 VDD_B.t101 VDD_B.t140 49.960748640953
Riso549 VDD_B.t101 VDD_B.t141 136.036824941516
Riso550 VDD_B.t101 VDD_B.t143 6889.25640347949
Riso551 VDD_B.t101 VDD_B.t144 0.0669484730575422
Riso552 VDD_B.t101 VDD_B.t145 42.6761666684912
Riso553 VDD_B.t101 VDD_B.t147 5532.3088306395
Riso554 VDD_B.t101 VDD_B.t149 6642.25134133414
Riso555 VDD_B.t101 VDD_B.t15 2163.27031547968
Riso556 VDD_B.t101 VDD_B.t150 39.0055126396012
Riso557 VDD_B.t101 VDD_B.t151 621.210601389331
Riso558 VDD_B.t101 VDD_B.t152 44072.994884472
Riso559 VDD_B.t101 VDD_B.t153 224.814592119193
Riso560 VDD_B.t101 VDD_B.t154 677.533321394235
Riso561 VDD_B.t101 VDD_B.t17 3165.01222825586
Riso562 VDD_B.t101 VDD_B.t18 195.326476316437
Riso563 VDD_B.t101 VDD_B.t2 5626.05363244093
Riso564 VDD_B.t101 VDD_B.t20 4158.16498173092
Riso565 VDD_B.t101 VDD_B.t22 6511.85578382443
Riso566 VDD_B.t101 VDD_B.t23 677.533321394235
Riso567 VDD_B.t101 VDD_B.t24 146973.913439072
Riso568 VDD_B.t101 VDD_B.t25 6854.56435960973
Riso569 VDD_B.t101 VDD_B.t26 1297.45238728643
Riso570 VDD_B.t101 VDD_B.t27 118.55870519227
Riso571 VDD_B.t101 VDD_B.t28 36.260685039471
Riso572 VDD_B.t101 VDD_B.t3 270022.195503128
Riso573 VDD_B.t101 VDD_B.t30 4158.16498173092
Riso574 VDD_B.t101 VDD_B.t31 1388.61938368473
Riso575 VDD_B.t101 VDD_B.t32 24580.9037404714
Riso576 VDD_B.t101 VDD_B.t33 1340.8969491925
Riso577 VDD_B.t101 VDD_B.t34 1118.27618282549
Riso578 VDD_B.t101 VDD_B.t35 41101.2472705322
Riso579 VDD_B.t101 VDD_B.t36 43377.9079670573
Riso580 VDD_B.t101 VDD_B.t37 34.1562211470159
Riso581 VDD_B.t101 VDD_B.t38 118.55870519227
Riso582 VDD_B.t101 VDD_B.t39 58.0069699992082
Riso583 VDD_B.t101 VDD_B.t4 6854.56435960973
Riso584 VDD_B.t101 VDD_B.t41 2995.49703704677
Riso585 VDD_B.t101 VDD_B.t42 736.048289965197
Riso586 VDD_B.t101 VDD_B.t43 1244.2452380906
Riso587 VDD_B.t101 VDD_B.t44 56534.208385699
Riso588 VDD_B.t101 VDD_B.t45 165962.4315912
Riso589 VDD_B.t101 VDD_B.t46 45.5351783824288
Riso590 VDD_B.t101 VDD_B.t47 42.7029555210061
Riso591 VDD_B.t101 VDD_B.t48 468.55892326043
Riso592 VDD_B.t101 VDD_B.t49 280.350239421082
Riso593 VDD_B.t101 VDD_B.t50 155.360684812773
Riso594 VDD_B.t101 VDD_B.t51 1388.61938368473
Riso595 VDD_B.t101 VDD_B.t52 280.350239421082
Riso596 VDD_B.t101 VDD_B.t53 199.742992982124
Riso597 VDD_B.t101 VDD_B.t55 6511.85578382443
Riso598 VDD_B.t101 VDD_B.t56 567.460246932697
Riso599 VDD_B.t101 VDD_B.t57 423.612411146204
Riso600 VDD_B.t101 VDD_B.t58 244582.482644134
Riso601 VDD_B.t101 VDD_B.t59 1406.89719934063
Riso602 VDD_B.t101 VDD_B.t6 4317.33758027708
Riso603 VDD_B.t101 VDD_B.t60 49.960748640953
Riso604 VDD_B.t101 VDD_B.t61 1118.27618282549
Riso605 VDD_B.t101 VDD_B.t62 1372.06487253261
Riso606 VDD_B.t101 VDD_B.t63 736.048289965197
Riso607 VDD_B.t101 VDD_B.t64 537.235448745065
Riso608 VDD_B.t101 VDD_B.t66 3529.44751802331
Riso609 VDD_B.t101 VDD_B.t67 42.6761666684912
Riso610 VDD_B.t101 VDD_B.t68 39.0055126396012
Riso611 VDD_B.t101 VDD_B.t69 1340.8969491925
Riso612 VDD_B.t101 VDD_B.t70 857.269704197132
Riso613 VDD_B.t101 VDD_B.t71 23520.6020320472
Riso614 VDD_B.t101 VDD_B.t73 2995.49703704677
Riso615 VDD_B.t101 VDD_B.t75 3529.44751802331
Riso616 VDD_B.t101 VDD_B.t76 102.848120146156
Riso617 VDD_B.t101 VDD_B.t77 176.587061369681
Riso618 VDD_B.t101 VDD_B.t78 155.360684812773
Riso619 VDD_B.t101 VDD_B.t79 58.0069699992082
Riso620 VDD_B.t101 VDD_B.t8 5626.05363244093
Riso621 VDD_B.t101 VDD_B.t80 468.55892326043
Riso622 VDD_B.t101 VDD_B.t81 59832.2284946398
Riso623 VDD_B.t101 VDD_B.t82 9218.14115718904
Riso624 VDD_B.t101 VDD_B.t83 36.260685039471
Riso625 VDD_B.t101 VDD_B.t85 6889.25640347949
Riso626 VDD_B.t101 VDD_B.t86 136.036824941516
Riso627 VDD_B.t101 VDD_B.t87 1388.65703710239
Riso628 VDD_B.t101 VDD_B.t88 176.587061369681
Riso629 VDD_B.t101 VDD_B.t89 621.210601389331
Riso630 VDD_B.t101 VDD_B.t9 251.732093268587
Riso631 VDD_B.t101 VDD_B.t90 1372.06487253261
Riso632 VDD_B.t101 VDD_B.t91 796.20936395615
Riso633 VDD_B.t101 VDD_B.t92 224.814592119193
Riso634 VDD_B.t101 VDD_B.t94 7289.2320203509
Riso635 VDD_B.t101 VDD_B.t95 158.855566002941
Riso636 VDD_B.t101 VDD_B.t96 12372.620305732
Riso637 VDD_B.t101 VDD_B.t97 17760.4383553598
Riso638 VDD_B.t101 VDD_B.t99 7289.2320203509
Riso639 VDD_B.t102 VDD_B.t103 19.3174028455437
Riso640 VDD_B.t102 VDD_B.t104 192.261656153489
Riso641 VDD_B.t102 VDD_B.t105 49.7002307097701
Riso642 VDD_B.t102 VDD_B.t106 587.210850165585
Riso643 VDD_B.t102 VDD_B.t107 430.719937039937
Riso644 VDD_B.t102 VDD_B.t108 666.461987188006
Riso645 VDD_B.t102 VDD_B.t109 49.7002307097701
Riso646 VDD_B.t102 VDD_B.t11 117.336497295685
Riso647 VDD_B.t102 VDD_B.t110 233.954021197671
Riso648 VDD_B.t102 VDD_B.t111 192.261656153489
Riso649 VDD_B.t102 VDD_B.t112 42.8800452580132
Riso650 VDD_B.t102 VDD_B.t114 101.359759650932
Riso651 VDD_B.t102 VDD_B.t115 666.461987188006
Riso652 VDD_B.t102 VDD_B.t116 37.0885209865905
Riso653 VDD_B.t102 VDD_B.t117 366.798188956932
Riso654 VDD_B.t102 VDD_B.t118 108.597158812624
Riso655 VDD_B.t102 VDD_B.t119 43.0731991257052
Riso656 VDD_B.t102 VDD_B.t120 576.794265758053
Riso657 VDD_B.t102 VDD_B.t122 101.359759650932
Riso658 VDD_B.t102 VDD_B.t123 274.946945925941
Riso659 VDD_B.t102 VDD_B.t124 95.6020416802573
Riso660 VDD_B.t102 VDD_B.t125 2102.01384496822
Riso661 VDD_B.t102 VDD_B.t126 313.396501476687
Riso662 VDD_B.t102 VDD_B.t127 15565.2773299935
Riso663 VDD_B.t102 VDD_B.t128 86.2863839969118
Riso664 VDD_B.t102 VDD_B.t13 131.717637422554
Riso665 VDD_B.t102 VDD_B.t130 146.006682212592
Riso666 VDD_B.t102 VDD_B.t132 146.006682212592
Riso667 VDD_B.t102 VDD_B.t134 123.833211454252
Riso668 VDD_B.t102 VDD_B.t135 173.045355367034
Riso669 VDD_B.t102 VDD_B.t136 16.2241543475576
Riso670 VDD_B.t102 VDD_B.t137 16.2241543475576
Riso671 VDD_B.t102 VDD_B.t139 131.106408970447
Riso672 VDD_B.t102 VDD_B.t140 688.730637079309
Riso673 VDD_B.t102 VDD_B.t141 528.242656124701
Riso674 VDD_B.t102 VDD_B.t143 166.968317868104
Riso675 VDD_B.t102 VDD_B.t144 683.322141753208
Riso676 VDD_B.t102 VDD_B.t145 612.285002462436
Riso677 VDD_B.t102 VDD_B.t147 131.717637422554
Riso678 VDD_B.t102 VDD_B.t149 131.106408970447
Riso679 VDD_B.t102 VDD_B.t15 63.9867013286806
Riso680 VDD_B.t102 VDD_B.t150 642.523408555907
Riso681 VDD_B.t102 VDD_B.t151 155.043376861535
Riso682 VDD_B.t102 VDD_B.t152 3113.38637639712
Riso683 VDD_B.t102 VDD_B.t153 398.352585486547
Riso684 VDD_B.t102 VDD_B.t154 138.297662847307
Riso685 VDD_B.t102 VDD_B.t17 123.833211454252
Riso686 VDD_B.t102 VDD_B.t18 131.051776536517
Riso687 VDD_B.t102 VDD_B.t2 181.123638179942
Riso688 VDD_B.t102 VDD_B.t20 166.953197745056
Riso689 VDD_B.t102 VDD_B.t22 95.2493392724316
Riso690 VDD_B.t102 VDD_B.t23 138.297662847307
Riso691 VDD_B.t102 VDD_B.t24 2365.45994752815
Riso692 VDD_B.t102 VDD_B.t25 111.646848933952
Riso693 VDD_B.t102 VDD_B.t26 37.0885209865905
Riso694 VDD_B.t102 VDD_B.t27 558.849673283803
Riso695 VDD_B.t102 VDD_B.t28 692.656109948668
Riso696 VDD_B.t102 VDD_B.t3 4345.85072589124
Riso697 VDD_B.t102 VDD_B.t30 166.953197745056
Riso698 VDD_B.t102 VDD_B.t31 22.9036308806606
Riso699 VDD_B.t102 VDD_B.t32 1736.43409134594
Riso700 VDD_B.t102 VDD_B.t33 31.748596762318
Riso701 VDD_B.t102 VDD_B.t34 56.9325776187958
Riso702 VDD_B.t102 VDD_B.t35 2903.45740380102
Riso703 VDD_B.t102 VDD_B.t36 3064.28433228229
Riso704 VDD_B.t102 VDD_B.t37 336.630788221143
Riso705 VDD_B.t102 VDD_B.t38 558.849673283803
Riso706 VDD_B.t102 VDD_B.t39 676.283151988719
Riso707 VDD_B.t102 VDD_B.t4 111.646848933952
Riso708 VDD_B.t102 VDD_B.t41 137.031449458636
Riso709 VDD_B.t102 VDD_B.t42 122.819476607088
Riso710 VDD_B.t102 VDD_B.t43 43.0731991257052
Riso711 VDD_B.t102 VDD_B.t44 3993.66629496842
Riso712 VDD_B.t102 VDD_B.t45 11723.8498283181
Riso713 VDD_B.t102 VDD_B.t46 576.794265758053
Riso714 VDD_B.t102 VDD_B.t47 694.373679082448
Riso715 VDD_B.t102 VDD_B.t48 212.609720802354
Riso716 VDD_B.t102 VDD_B.t49 336.353343514303
Riso717 VDD_B.t102 VDD_B.t50 496.220182047538
Riso718 VDD_B.t102 VDD_B.t51 22.9036308806606
Riso719 VDD_B.t102 VDD_B.t52 336.353343514303
Riso720 VDD_B.t102 VDD_B.t53 430.719937039937
Riso721 VDD_B.t102 VDD_B.t55 95.2493392724316
Riso722 VDD_B.t102 VDD_B.t56 173.045355367034
Riso723 VDD_B.t102 VDD_B.t57 233.954021197671
Riso724 VDD_B.t102 VDD_B.t58 11837.0994821299
Riso725 VDD_B.t102 VDD_B.t59 67.4361533363012
Riso726 VDD_B.t102 VDD_B.t6 117.336497295685
Riso727 VDD_B.t102 VDD_B.t60 688.730637079309
Riso728 VDD_B.t102 VDD_B.t61 56.9325776187958
Riso729 VDD_B.t102 VDD_B.t62 27.0323480537446
Riso730 VDD_B.t102 VDD_B.t63 122.819476607088
Riso731 VDD_B.t102 VDD_B.t64 33.1014933766171
Riso732 VDD_B.t102 VDD_B.t66 114.23133432842
Riso733 VDD_B.t102 VDD_B.t67 612.285002462436
Riso734 VDD_B.t102 VDD_B.t68 642.523408555907
Riso735 VDD_B.t102 VDD_B.t69 31.748596762318
Riso736 VDD_B.t102 VDD_B.t70 95.6020416802573
Riso737 VDD_B.t102 VDD_B.t71 1661.53269418581
Riso738 VDD_B.t102 VDD_B.t73 137.031449458636
Riso739 VDD_B.t102 VDD_B.t75 114.23133432842
Riso740 VDD_B.t102 VDD_B.t76 587.210850165585
Riso741 VDD_B.t102 VDD_B.t77 463.508557185313
Riso742 VDD_B.t102 VDD_B.t78 496.220182047538
Riso743 VDD_B.t102 VDD_B.t79 676.283151988719
Riso744 VDD_B.t102 VDD_B.t8 181.123638179942
Riso745 VDD_B.t102 VDD_B.t80 212.609720802354
Riso746 VDD_B.t102 VDD_B.t81 4226.64367495304
Riso747 VDD_B.t102 VDD_B.t82 651.184135993663
Riso748 VDD_B.t102 VDD_B.t83 692.656109948668
Riso749 VDD_B.t102 VDD_B.t85 166.968317868104
Riso750 VDD_B.t102 VDD_B.t86 528.242656124701
Riso751 VDD_B.t102 VDD_B.t87 19.3174028455437
Riso752 VDD_B.t102 VDD_B.t88 463.508557185313
Riso753 VDD_B.t102 VDD_B.t89 155.043376861535
Riso754 VDD_B.t102 VDD_B.t9 366.798188956932
Riso755 VDD_B.t102 VDD_B.t90 27.0323480537446
Riso756 VDD_B.t102 VDD_B.t91 108.597158812624
Riso757 VDD_B.t102 VDD_B.t92 398.352585486547
Riso758 VDD_B.t102 VDD_B.t94 133.809301318623
Riso759 VDD_B.t102 VDD_B.t95 157.222930129402
Riso760 VDD_B.t102 VDD_B.t96 874.021554495547
Riso761 VDD_B.t102 VDD_B.t97 1254.62558102445
Riso762 VDD_B.t102 VDD_B.t99 133.809301318623
Riso763 VDD_B.t103 VDD_B.t104 338.737166292046
Riso764 VDD_B.t103 VDD_B.t105 81.5182986995822
Riso765 VDD_B.t103 VDD_B.t106 1115.79455147991
Riso766 VDD_B.t103 VDD_B.t107 794.26544619251
Riso767 VDD_B.t103 VDD_B.t108 1366.86682360743
Riso768 VDD_B.t103 VDD_B.t109 81.5182986995822
Riso769 VDD_B.t103 VDD_B.t11 297.167847432962
Riso770 VDD_B.t103 VDD_B.t110 416.533006028838
Riso771 VDD_B.t103 VDD_B.t111 338.737166292046
Riso772 VDD_B.t103 VDD_B.t112 72.1815712993305
Riso773 VDD_B.t103 VDD_B.t114 279.168837973868
Riso774 VDD_B.t103 VDD_B.t115 1366.86682360743
Riso775 VDD_B.t103 VDD_B.t116 59.9913776020765
Riso776 VDD_B.t103 VDD_B.t117 669.332384385857
Riso777 VDD_B.t103 VDD_B.t118 185.411933196581
Riso778 VDD_B.t103 VDD_B.t119 70.1615262061326
Riso779 VDD_B.t103 VDD_B.t120 1212.96009175209
Riso780 VDD_B.t103 VDD_B.t122 279.168837973868
Riso781 VDD_B.t103 VDD_B.t123 582.286315459712
Riso782 VDD_B.t103 VDD_B.t124 162.086657646599
Riso783 VDD_B.t103 VDD_B.t125 5310.2111052715
Riso784 VDD_B.t103 VDD_B.t126 599.660541549337
Riso785 VDD_B.t103 VDD_B.t127 38929.1080994829
Riso786 VDD_B.t103 VDD_B.t128 215.689053520179
Riso787 VDD_B.t103 VDD_B.t13 340.8262414436
Riso788 VDD_B.t103 VDD_B.t130 364.916771418873
Riso789 VDD_B.t103 VDD_B.t132 364.916771418873
Riso790 VDD_B.t103 VDD_B.t134 309.498270512202
Riso791 VDD_B.t103 VDD_B.t135 303.13959386059
Riso792 VDD_B.t103 VDD_B.t136 34.2826582350228
Riso793 VDD_B.t103 VDD_B.t137 34.2826582350228
Riso794 VDD_B.t103 VDD_B.t139 348.766613154774
Riso795 VDD_B.t103 VDD_B.t140 1361.49624109379
Riso796 VDD_B.t103 VDD_B.t141 990.906930081042
Riso797 VDD_B.t103 VDD_B.t143 439.524059504274
Riso798 VDD_B.t103 VDD_B.t144 1388.65703710239
Riso799 VDD_B.t103 VDD_B.t145 1277.61498351961
Riso800 VDD_B.t103 VDD_B.t147 340.8262414436
Riso801 VDD_B.t103 VDD_B.t149 348.766613154774
Riso802 VDD_B.t103 VDD_B.t15 160.655348078034
Riso803 VDD_B.t103 VDD_B.t150 1329.5030221273
Riso804 VDD_B.t103 VDD_B.t151 269.971423339958
Riso805 VDD_B.t103 VDD_B.t152 7865.1903033469
Riso806 VDD_B.t103 VDD_B.t153 730.696095122855
Riso807 VDD_B.t103 VDD_B.t154 239.298082847339
Riso808 VDD_B.t103 VDD_B.t17 309.498270512202
Riso809 VDD_B.t103 VDD_B.t18 234.42415177402
Riso810 VDD_B.t103 VDD_B.t2 459.0276408007
Riso811 VDD_B.t103 VDD_B.t20 407.922721519227
Riso812 VDD_B.t103 VDD_B.t22 262.708103286429
Riso813 VDD_B.t103 VDD_B.t23 239.298082847339
Riso814 VDD_B.t103 VDD_B.t24 6455.25432414376
Riso815 VDD_B.t103 VDD_B.t25 304.238883849973
Riso816 VDD_B.t103 VDD_B.t26 59.9913776020765
Riso817 VDD_B.t103 VDD_B.t27 1054.91151800489
Riso818 VDD_B.t103 VDD_B.t28 1394.59805170296
Riso819 VDD_B.t103 VDD_B.t3 11859.6688646992
Riso820 VDD_B.t103 VDD_B.t30 407.922721519227
Riso821 VDD_B.t103 VDD_B.t31 36.2974257318178
Riso822 VDD_B.t103 VDD_B.t32 4386.66549105279
Riso823 VDD_B.t103 VDD_B.t33 50.997256328444
Riso824 VDD_B.t103 VDD_B.t34 94.0062714363984
Riso825 VDD_B.t103 VDD_B.t35 7334.85737320633
Riso826 VDD_B.t103 VDD_B.t36 7741.14629641788
Riso827 VDD_B.t103 VDD_B.t37 654.153276315015
Riso828 VDD_B.t103 VDD_B.t38 1054.91151800489
Riso829 VDD_B.t103 VDD_B.t39 1325.2197119911
Riso830 VDD_B.t103 VDD_B.t4 304.238883849973
Riso831 VDD_B.t103 VDD_B.t41 326.568614115345
Riso832 VDD_B.t103 VDD_B.t42 211.124795053716
Riso833 VDD_B.t103 VDD_B.t43 70.1615262061326
Riso834 VDD_B.t103 VDD_B.t44 10088.9968736674
Riso835 VDD_B.t103 VDD_B.t45 29617.3679844679
Riso836 VDD_B.t103 VDD_B.t46 1212.96009175209
Riso837 VDD_B.t103 VDD_B.t47 1385.16711053232
Riso838 VDD_B.t103 VDD_B.t48 376.618586813059
Riso839 VDD_B.t103 VDD_B.t49 610.630452785079
Riso840 VDD_B.t103 VDD_B.t50 925.310421778704
Riso841 VDD_B.t103 VDD_B.t51 36.2974257318178
Riso842 VDD_B.t103 VDD_B.t52 610.630452785079
Riso843 VDD_B.t103 VDD_B.t53 794.26544619251
Riso844 VDD_B.t103 VDD_B.t55 262.708103286429
Riso845 VDD_B.t103 VDD_B.t56 303.13959386059
Riso846 VDD_B.t103 VDD_B.t57 416.533006028838
Riso847 VDD_B.t103 VDD_B.t58 27883.9198585425
Riso848 VDD_B.t103 VDD_B.t59 159.179396888598
Riso849 VDD_B.t103 VDD_B.t6 297.167847432962
Riso850 VDD_B.t103 VDD_B.t60 1361.49624109379
Riso851 VDD_B.t103 VDD_B.t61 94.0062714363984
Riso852 VDD_B.t103 VDD_B.t62 43.1256938546101
Riso853 VDD_B.t103 VDD_B.t63 211.124795053716
Riso854 VDD_B.t103 VDD_B.t64 54.9986716946682
Riso855 VDD_B.t103 VDD_B.t66 285.902394478638
Riso856 VDD_B.t103 VDD_B.t67 1277.61498351961
Riso857 VDD_B.t103 VDD_B.t68 1329.5030221273
Riso858 VDD_B.t103 VDD_B.t69 50.997256328444
Riso859 VDD_B.t103 VDD_B.t70 162.086657646599
Riso860 VDD_B.t103 VDD_B.t71 4197.44588531507
Riso861 VDD_B.t103 VDD_B.t73 326.568614115345
Riso862 VDD_B.t103 VDD_B.t75 285.902394478638
Riso863 VDD_B.t103 VDD_B.t76 1115.79455147991
Riso864 VDD_B.t103 VDD_B.t77 859.412735815155
Riso865 VDD_B.t103 VDD_B.t78 925.310421778704
Riso866 VDD_B.t103 VDD_B.t79 1325.2197119911
Riso867 VDD_B.t103 VDD_B.t8 459.0276408007
Riso868 VDD_B.t103 VDD_B.t80 376.618586813059
Riso869 VDD_B.t103 VDD_B.t81 10677.5558279448
Riso870 VDD_B.t103 VDD_B.t82 1645.05349896135
Riso871 VDD_B.t103 VDD_B.t83 1394.59805170296
Riso872 VDD_B.t103 VDD_B.t85 439.524059504274
Riso873 VDD_B.t103 VDD_B.t86 990.906930081042
Riso874 VDD_B.t103 VDD_B.t87 0.066947531572333
Riso875 VDD_B.t103 VDD_B.t88 859.412735815155
Riso876 VDD_B.t103 VDD_B.t89 269.971423339958
Riso877 VDD_B.t103 VDD_B.t9 669.332384385857
Riso878 VDD_B.t103 VDD_B.t90 43.1256938546101
Riso879 VDD_B.t103 VDD_B.t91 185.411933196581
Riso880 VDD_B.t103 VDD_B.t92 730.696095122855
Riso881 VDD_B.t103 VDD_B.t94 362.600499823255
Riso882 VDD_B.t103 VDD_B.t95 283.965600933366
Riso883 VDD_B.t103 VDD_B.t96 2207.99638215469
Riso884 VDD_B.t103 VDD_B.t97 3169.49705600746
Riso885 VDD_B.t103 VDD_B.t99 362.600499823255
Riso886 VDD_B.t104 VDD_B.t105 183.007474749623
Riso887 VDD_B.t104 VDD_B.t106 263.79600539143
Riso888 VDD_B.t104 VDD_B.t107 141.274193231314
Riso889 VDD_B.t104 VDD_B.t108 538.531083339674
Riso890 VDD_B.t104 VDD_B.t109 183.007474749623
Riso891 VDD_B.t104 VDD_B.t11 1776.73201368253
Riso892 VDD_B.t104 VDD_B.t110 48.3346565738348
Riso893 VDD_B.t104 VDD_B.t111 0.0669657845330741
Riso894 VDD_B.t104 VDD_B.t112 54.1588199415015
Riso895 VDD_B.t104 VDD_B.t114 2434.19636195603
Riso896 VDD_B.t104 VDD_B.t115 538.531083339674
Riso897 VDD_B.t104 VDD_B.t116 233.578271805828
Riso898 VDD_B.t104 VDD_B.t117 105.20099522932
Riso899 VDD_B.t104 VDD_B.t118 79.7777098963471
Riso900 VDD_B.t104 VDD_B.t119 207.563921413136
Riso901 VDD_B.t104 VDD_B.t120 560.17926434636
Riso902 VDD_B.t104 VDD_B.t122 2434.19636195603
Riso903 VDD_B.t104 VDD_B.t123 281.422346764431
Riso904 VDD_B.t104 VDD_B.t124 92.325551190587
Riso905 VDD_B.t104 VDD_B.t125 28069.0625886836
Riso906 VDD_B.t104 VDD_B.t126 149.329421833191
Riso907 VDD_B.t104 VDD_B.t127 203993.155889391
Riso908 VDD_B.t104 VDD_B.t128 1148.50294929869
Riso909 VDD_B.t104 VDD_B.t13 2218.82521851524
Riso910 VDD_B.t104 VDD_B.t130 2000.92229739554
Riso911 VDD_B.t104 VDD_B.t132 2000.92229739554
Riso912 VDD_B.t104 VDD_B.t134 1737.49472108486
Riso913 VDD_B.t104 VDD_B.t135 41.4458598043465
Riso914 VDD_B.t104 VDD_B.t136 359.753408714003
Riso915 VDD_B.t104 VDD_B.t137 359.753408714003
Riso916 VDD_B.t104 VDD_B.t139 2571.80618795833
Riso917 VDD_B.t104 VDD_B.t140 424.713903504756
Riso918 VDD_B.t104 VDD_B.t141 210.023041959906
Riso919 VDD_B.t104 VDD_B.t143 2717.15449430018
Riso920 VDD_B.t104 VDD_B.t144 516.52895645885
Riso921 VDD_B.t104 VDD_B.t145 561.384012915692
Riso922 VDD_B.t104 VDD_B.t147 2218.82521851524
Riso923 VDD_B.t104 VDD_B.t149 2571.80618795833
Riso924 VDD_B.t104 VDD_B.t15 928.886821693964
Riso925 VDD_B.t104 VDD_B.t150 553.8853517228
Riso926 VDD_B.t104 VDD_B.t151 49.2449176195882
Riso927 VDD_B.t104 VDD_B.t152 41574.339422663
Riso928 VDD_B.t104 VDD_B.t153 122.250739801903
Riso929 VDD_B.t104 VDD_B.t154 58.2036758327039
Riso930 VDD_B.t104 VDD_B.t17 1737.49472108486
Riso931 VDD_B.t104 VDD_B.t18 28.7896698323926
Riso932 VDD_B.t104 VDD_B.t2 2300.55329394035
Riso933 VDD_B.t104 VDD_B.t20 1738.92054784117
Riso934 VDD_B.t104 VDD_B.t22 2351.59577303427
Riso935 VDD_B.t104 VDD_B.t23 58.2036758327039
Riso936 VDD_B.t104 VDD_B.t24 54435.4826241731
Riso937 VDD_B.t104 VDD_B.t25 2544.90505741211
Riso938 VDD_B.t104 VDD_B.t26 233.578271805828
Riso939 VDD_B.t104 VDD_B.t27 236.339169164131
Riso940 VDD_B.t104 VDD_B.t28 489.278731298717
Riso941 VDD_B.t104 VDD_B.t3 100009.506364168
Riso942 VDD_B.t104 VDD_B.t30 1738.92054784117
Riso943 VDD_B.t104 VDD_B.t31 314.251227821598
Riso944 VDD_B.t104 VDD_B.t32 23187.3245306099
Riso945 VDD_B.t104 VDD_B.t33 260.555640068099
Riso946 VDD_B.t104 VDD_B.t34 160.218825958488
Riso947 VDD_B.t104 VDD_B.t35 38771.0707928757
Riso948 VDD_B.t104 VDD_B.t36 40918.659464707
Riso949 VDD_B.t104 VDD_B.t37 181.669474586233
Riso950 VDD_B.t104 VDD_B.t38 236.339169164131
Riso951 VDD_B.t104 VDD_B.t39 389.96971543242
Riso952 VDD_B.t104 VDD_B.t4 2544.90505741211
Riso953 VDD_B.t104 VDD_B.t41 1266.93342377786
Riso954 VDD_B.t104 VDD_B.t42 68.3792305774904
Riso955 VDD_B.t104 VDD_B.t43 207.563921413136
Riso956 VDD_B.t104 VDD_B.t44 53329.0822323198
Riso957 VDD_B.t104 VDD_B.t45 156553.428703208
Riso958 VDD_B.t104 VDD_B.t46 560.17926434636
Riso959 VDD_B.t104 VDD_B.t47 458.219770125129
Riso960 VDD_B.t104 VDD_B.t48 41.1267560623616
Riso961 VDD_B.t104 VDD_B.t49 90.0552070357102
Riso962 VDD_B.t104 VDD_B.t50 185.254398587144
Riso963 VDD_B.t104 VDD_B.t51 314.251227821598
Riso964 VDD_B.t104 VDD_B.t52 90.0552070357102
Riso965 VDD_B.t104 VDD_B.t53 141.274193231314
Riso966 VDD_B.t104 VDD_B.t55 2351.59577303427
Riso967 VDD_B.t104 VDD_B.t56 41.4458598043465
Riso968 VDD_B.t104 VDD_B.t57 48.3346565738348
Riso969 VDD_B.t104 VDD_B.t58 103910.557769753
Riso970 VDD_B.t104 VDD_B.t59 597.263428786214
Riso971 VDD_B.t104 VDD_B.t6 1776.73201368253
Riso972 VDD_B.t104 VDD_B.t60 424.713903504756
Riso973 VDD_B.t104 VDD_B.t61 160.218825958488
Riso974 VDD_B.t104 VDD_B.t62 287.774016990459
Riso975 VDD_B.t104 VDD_B.t63 68.3792305774904
Riso976 VDD_B.t104 VDD_B.t64 71.318151563764
Riso977 VDD_B.t104 VDD_B.t66 1628.82652426141
Riso978 VDD_B.t104 VDD_B.t67 561.384012915692
Riso979 VDD_B.t104 VDD_B.t68 553.8853517228
Riso980 VDD_B.t104 VDD_B.t69 260.555640068099
Riso981 VDD_B.t104 VDD_B.t70 92.325551190587
Riso982 VDD_B.t104 VDD_B.t71 22187.135112305
Riso983 VDD_B.t104 VDD_B.t73 1266.93342377786
Riso984 VDD_B.t104 VDD_B.t75 1628.82652426141
Riso985 VDD_B.t104 VDD_B.t76 263.79600539143
Riso986 VDD_B.t104 VDD_B.t77 162.29151905161
Riso987 VDD_B.t104 VDD_B.t78 185.254398587144
Riso988 VDD_B.t104 VDD_B.t79 389.96971543242
Riso989 VDD_B.t104 VDD_B.t8 2300.55329394035
Riso990 VDD_B.t104 VDD_B.t80 41.1267560623616
Riso991 VDD_B.t104 VDD_B.t81 56440.1258042686
Riso992 VDD_B.t104 VDD_B.t82 8695.53181760339
Riso993 VDD_B.t104 VDD_B.t83 489.278731298717
Riso994 VDD_B.t104 VDD_B.t85 2717.15449430018
Riso995 VDD_B.t104 VDD_B.t86 210.023041959906
Riso996 VDD_B.t104 VDD_B.t87 338.737166292046
Riso997 VDD_B.t104 VDD_B.t88 162.29151905161
Riso998 VDD_B.t104 VDD_B.t89 49.2449176195882
Riso999 VDD_B.t104 VDD_B.t9 105.20099522932
Riso1000 VDD_B.t104 VDD_B.t90 287.774016990459
Riso1001 VDD_B.t104 VDD_B.t91 79.7777098963471
Riso1002 VDD_B.t104 VDD_B.t92 122.250739801903
Riso1003 VDD_B.t104 VDD_B.t94 2748.57674434576
Riso1004 VDD_B.t104 VDD_B.t95 39.2550665952779
Riso1005 VDD_B.t104 VDD_B.t96 11671.1722787748
Riso1006 VDD_B.t104 VDD_B.t97 16753.5356836202
Riso1007 VDD_B.t104 VDD_B.t99 2748.57674434576
Riso1008 VDD_B.t105 VDD_B.t106 791.01659413903
Riso1009 VDD_B.t105 VDD_B.t107 512.991553658014
Riso1010 VDD_B.t105 VDD_B.t108 1195.8291901637
Riso1011 VDD_B.t105 VDD_B.t109 0.0669621396807026
Riso1012 VDD_B.t105 VDD_B.t11 596.287950441313
Riso1013 VDD_B.t105 VDD_B.t110 234.941735586855
Riso1014 VDD_B.t105 VDD_B.t111 183.007474749623
Riso1015 VDD_B.t105 VDD_B.t112 32.6705850082792
Riso1016 VDD_B.t105 VDD_B.t114 691.000205820859
Riso1017 VDD_B.t105 VDD_B.t115 1195.8291901637
Riso1018 VDD_B.t105 VDD_B.t116 47.1525644659047
Riso1019 VDD_B.t105 VDD_B.t117 416.1707973372
Riso1020 VDD_B.t105 VDD_B.t118 88.4166567448977
Riso1021 VDD_B.t105 VDD_B.t119 40.0450314987865
Riso1022 VDD_B.t105 VDD_B.t120 1142.07378979784
Riso1023 VDD_B.t105 VDD_B.t122 691.000205820859
Riso1024 VDD_B.t105 VDD_B.t123 560.137659885222
Riso1025 VDD_B.t105 VDD_B.t124 75.2994506603556
Riso1026 VDD_B.t105 VDD_B.t125 10447.9837394839
Riso1027 VDD_B.t105 VDD_B.t126 433.372119007247
Riso1028 VDD_B.t105 VDD_B.t127 75558.5803060191
Riso1029 VDD_B.t105 VDD_B.t128 418.729465701152
Riso1030 VDD_B.t105 VDD_B.t13 718.049717073617
Riso1031 VDD_B.t105 VDD_B.t130 709.769992849425
Riso1032 VDD_B.t105 VDD_B.t132 709.769992849425
Riso1033 VDD_B.t105 VDD_B.t134 602.999997963375
Riso1034 VDD_B.t105 VDD_B.t135 159.975835950957
Riso1035 VDD_B.t105 VDD_B.t136 89.9365826099478
Riso1036 VDD_B.t105 VDD_B.t137 89.9365826099478
Riso1037 VDD_B.t105 VDD_B.t139 786.706132441119
Riso1038 VDD_B.t105 VDD_B.t140 1075.41647154352
Riso1039 VDD_B.t105 VDD_B.t141 676.572848626249
Riso1040 VDD_B.t105 VDD_B.t143 944.252872166634
Riso1041 VDD_B.t105 VDD_B.t144 1183.75525240334
Riso1042 VDD_B.t105 VDD_B.t145 1175.28802686327
Riso1043 VDD_B.t105 VDD_B.t147 718.049717073617
Riso1044 VDD_B.t105 VDD_B.t149 786.706132441119
Riso1045 VDD_B.t105 VDD_B.t15 316.345662552968
Riso1046 VDD_B.t105 VDD_B.t150 1193.2422138575
Riso1047 VDD_B.t105 VDD_B.t151 139.03250573893
Riso1048 VDD_B.t105 VDD_B.t152 15474.9743029498
Riso1049 VDD_B.t105 VDD_B.t153 463.131570765431
Riso1050 VDD_B.t105 VDD_B.t154 120.171799705782
Riso1051 VDD_B.t105 VDD_B.t17 602.999997963375
Riso1052 VDD_B.t105 VDD_B.t18 134.764580692341
Riso1053 VDD_B.t105 VDD_B.t2 891.535015408939
Riso1054 VDD_B.t105 VDD_B.t20 727.495398203887
Riso1055 VDD_B.t105 VDD_B.t22 654.682989996584
Riso1056 VDD_B.t105 VDD_B.t23 120.171799705782
Riso1057 VDD_B.t105 VDD_B.t24 15605.1878922316
Riso1058 VDD_B.t105 VDD_B.t25 732.473721879656
Riso1059 VDD_B.t105 VDD_B.t26 47.1525644659047
Riso1060 VDD_B.t105 VDD_B.t27 733.841874404479
Riso1061 VDD_B.t105 VDD_B.t28 1158.39299539474
Riso1062 VDD_B.t105 VDD_B.t3 28670.0340033201
Riso1063 VDD_B.t105 VDD_B.t30 727.495398203887
Riso1064 VDD_B.t105 VDD_B.t31 72.5526989064646
Riso1065 VDD_B.t105 VDD_B.t32 8630.88280531392
Riso1066 VDD_B.t105 VDD_B.t33 55.0462365727559
Riso1067 VDD_B.t105 VDD_B.t34 39.8054278236201
Riso1068 VDD_B.t105 VDD_B.t35 14431.5299424947
Riso1069 VDD_B.t105 VDD_B.t36 15230.914369798
Riso1070 VDD_B.t105 VDD_B.t37 493.095660740461
Riso1071 VDD_B.t105 VDD_B.t38 733.841874404479
Riso1072 VDD_B.t105 VDD_B.t39 1022.05524696501
Riso1073 VDD_B.t105 VDD_B.t4 732.473721879656
Riso1074 VDD_B.t105 VDD_B.t41 552.533448661905
Riso1075 VDD_B.t105 VDD_B.t42 103.332821684366
Riso1076 VDD_B.t105 VDD_B.t43 40.0450314987865
Riso1077 VDD_B.t105 VDD_B.t44 19850.3737787636
Riso1078 VDD_B.t105 VDD_B.t45 58272.9712573662
Riso1079 VDD_B.t105 VDD_B.t46 1142.07378979784
Riso1080 VDD_B.t105 VDD_B.t47 1121.58186855572
Riso1081 VDD_B.t105 VDD_B.t48 208.055493016744
Riso1082 VDD_B.t105 VDD_B.t49 372.270782434245
Riso1083 VDD_B.t105 VDD_B.t50 620.198117342694
Riso1084 VDD_B.t105 VDD_B.t51 72.5526989064646
Riso1085 VDD_B.t105 VDD_B.t52 372.270782434245
Riso1086 VDD_B.t105 VDD_B.t53 512.991553658014
Riso1087 VDD_B.t105 VDD_B.t55 654.682989996584
Riso1088 VDD_B.t105 VDD_B.t56 159.975835950957
Riso1089 VDD_B.t105 VDD_B.t57 234.941735586855
Riso1090 VDD_B.t105 VDD_B.t58 46096.9958596667
Riso1091 VDD_B.t105 VDD_B.t59 264.204565541222
Riso1092 VDD_B.t105 VDD_B.t6 596.287950441313
Riso1093 VDD_B.t105 VDD_B.t60 1075.41647154352
Riso1094 VDD_B.t105 VDD_B.t61 39.8054278236201
Riso1095 VDD_B.t105 VDD_B.t62 63.5961097939839
Riso1096 VDD_B.t105 VDD_B.t63 103.332821684366
Riso1097 VDD_B.t105 VDD_B.t64 23.7832404222887
Riso1098 VDD_B.t105 VDD_B.t66 559.068442353038
Riso1099 VDD_B.t105 VDD_B.t67 1175.28802686327
Riso1100 VDD_B.t105 VDD_B.t68 1193.2422138575
Riso1101 VDD_B.t105 VDD_B.t69 55.0462365727559
Riso1102 VDD_B.t105 VDD_B.t70 75.2994506603556
Riso1103 VDD_B.t105 VDD_B.t71 8258.58812159096
Riso1104 VDD_B.t105 VDD_B.t73 552.533448661905
Riso1105 VDD_B.t105 VDD_B.t75 559.068442353038
Riso1106 VDD_B.t105 VDD_B.t76 791.01659413903
Riso1107 VDD_B.t105 VDD_B.t77 565.481619137645
Riso1108 VDD_B.t105 VDD_B.t78 620.198117342694
Riso1109 VDD_B.t105 VDD_B.t79 1022.05524696501
Riso1110 VDD_B.t105 VDD_B.t8 891.535015408939
Riso1111 VDD_B.t105 VDD_B.t80 208.055493016744
Riso1112 VDD_B.t105 VDD_B.t81 21008.379413966
Riso1113 VDD_B.t105 VDD_B.t82 3236.68718003831
Riso1114 VDD_B.t105 VDD_B.t83 1158.39299539474
Riso1115 VDD_B.t105 VDD_B.t85 944.252872166634
Riso1116 VDD_B.t105 VDD_B.t86 676.572848626249
Riso1117 VDD_B.t105 VDD_B.t87 81.5182986995822
Riso1118 VDD_B.t105 VDD_B.t88 565.481619137645
Riso1119 VDD_B.t105 VDD_B.t89 139.03250573893
Riso1120 VDD_B.t105 VDD_B.t9 416.1707973372
Riso1121 VDD_B.t105 VDD_B.t90 63.5961097939839
Riso1122 VDD_B.t105 VDD_B.t91 88.4166567448977
Riso1123 VDD_B.t105 VDD_B.t92 463.131570765431
Riso1124 VDD_B.t105 VDD_B.t94 850.277143960162
Riso1125 VDD_B.t105 VDD_B.t95 169.645674653703
Riso1126 VDD_B.t105 VDD_B.t96 4344.29250368044
Riso1127 VDD_B.t105 VDD_B.t97 6236.0710425683
Riso1128 VDD_B.t105 VDD_B.t99 850.277143960162
Riso1129 VDD_B.t106 VDD_B.t107 77.3711031012669
Riso1130 VDD_B.t106 VDD_B.t108 113.024992184948
Riso1131 VDD_B.t106 VDD_B.t109 791.01659413903
Riso1132 VDD_B.t106 VDD_B.t11 4567.8685499347
Riso1133 VDD_B.t106 VDD_B.t110 204.066265477054
Riso1134 VDD_B.t106 VDD_B.t111 263.79600539143
Riso1135 VDD_B.t106 VDD_B.t112 284.675543330612
Riso1136 VDD_B.t106 VDD_B.t114 6402.6436436184
Riso1137 VDD_B.t106 VDD_B.t115 113.024992184948
Riso1138 VDD_B.t106 VDD_B.t116 917.156367384221
Riso1139 VDD_B.t106 VDD_B.t117 104.407077306238
Riso1140 VDD_B.t106 VDD_B.t118 461.472663733068
Riso1141 VDD_B.t106 VDD_B.t119 854.581657081732
Riso1142 VDD_B.t106 VDD_B.t120 133.667697620118
Riso1143 VDD_B.t106 VDD_B.t122 6402.6436436184
Riso1144 VDD_B.t106 VDD_B.t123 69.2129071852871
Riso1145 VDD_B.t106 VDD_B.t124 508.175705284665
Riso1146 VDD_B.t106 VDD_B.t125 45160.4825992924
Riso1147 VDD_B.t106 VDD_B.t126 19.823788161025
Riso1148 VDD_B.t106 VDD_B.t127 293560.819355714
Riso1149 VDD_B.t106 VDD_B.t128 1812.30034386162
Riso1150 VDD_B.t106 VDD_B.t13 5755.46032526998
Riso1151 VDD_B.t106 VDD_B.t130 3780.15627402821
Riso1152 VDD_B.t106 VDD_B.t132 3780.15627402821
Riso1153 VDD_B.t106 VDD_B.t134 3907.2330377826
Riso1154 VDD_B.t106 VDD_B.t135 297.865452168809
Riso1155 VDD_B.t106 VDD_B.t136 1139.48192105903
Riso1156 VDD_B.t106 VDD_B.t137 1139.48192105903
Riso1157 VDD_B.t106 VDD_B.t139 6746.60798991481
Riso1158 VDD_B.t106 VDD_B.t140 71.0455665511807
Riso1159 VDD_B.t106 VDD_B.t141 47.2842410931188
Riso1160 VDD_B.t106 VDD_B.t143 6455.4526314342
Riso1161 VDD_B.t106 VDD_B.t144 102.848120146156
Riso1162 VDD_B.t106 VDD_B.t145 129.096756728179
Riso1163 VDD_B.t106 VDD_B.t147 5755.46032526998
Riso1164 VDD_B.t106 VDD_B.t149 6746.60798991481
Riso1165 VDD_B.t106 VDD_B.t15 2345.87649508736
Riso1166 VDD_B.t106 VDD_B.t150 122.004214673235
Riso1167 VDD_B.t106 VDD_B.t151 334.766279402891
Riso1168 VDD_B.t106 VDD_B.t152 66889.2032337124
Riso1169 VDD_B.t106 VDD_B.t153 90.1733346564786
Riso1170 VDD_B.t106 VDD_B.t154 374.445047604797
Riso1171 VDD_B.t106 VDD_B.t17 3907.2330377826
Riso1172 VDD_B.t106 VDD_B.t18 91.2220807453754
Riso1173 VDD_B.t106 VDD_B.t2 5233.33835052928
Riso1174 VDD_B.t106 VDD_B.t20 3850.95874433657
Riso1175 VDD_B.t106 VDD_B.t22 6285.95539472171
Riso1176 VDD_B.t106 VDD_B.t23 374.445047604797
Riso1177 VDD_B.t106 VDD_B.t24 144764.805086218
Riso1178 VDD_B.t106 VDD_B.t25 6763.88815608854
Riso1179 VDD_B.t106 VDD_B.t26 917.156367384221
Riso1180 VDD_B.t106 VDD_B.t27 39.7497280668417
Riso1181 VDD_B.t106 VDD_B.t28 92.1200427679123
Riso1182 VDD_B.t106 VDD_B.t3 265963.595758559
Riso1183 VDD_B.t106 VDD_B.t30 3850.95874433657
Riso1184 VDD_B.t106 VDD_B.t31 1078.93465399877
Riso1185 VDD_B.t106 VDD_B.t32 37306.2250540183
Riso1186 VDD_B.t106 VDD_B.t33 976.93610203862
Riso1187 VDD_B.t106 VDD_B.t34 727.875881690861
Riso1188 VDD_B.t106 VDD_B.t35 62379.0075769578
Riso1189 VDD_B.t106 VDD_B.t36 65834.2758296203
Riso1190 VDD_B.t106 VDD_B.t37 26.9073107231071
Riso1191 VDD_B.t106 VDD_B.t38 39.7497280668417
Riso1192 VDD_B.t106 VDD_B.t39 61.3893765559523
Riso1193 VDD_B.t106 VDD_B.t4 6763.88815608854
Riso1194 VDD_B.t106 VDD_B.t41 2768.18499926195
Riso1195 VDD_B.t106 VDD_B.t42 416.763816278014
Riso1196 VDD_B.t106 VDD_B.t43 854.581657081732
Riso1197 VDD_B.t106 VDD_B.t44 85801.4792114887
Riso1198 VDD_B.t106 VDD_B.t45 251879.747336527
Riso1199 VDD_B.t106 VDD_B.t46 133.667697620118
Riso1200 VDD_B.t106 VDD_B.t47 81.3824084705324
Riso1201 VDD_B.t106 VDD_B.t48 232.548353443667
Riso1202 VDD_B.t106 VDD_B.t49 119.995852336775
Riso1203 VDD_B.t106 VDD_B.t50 55.9981285599394
Riso1204 VDD_B.t106 VDD_B.t51 1078.93465399877
Riso1205 VDD_B.t106 VDD_B.t52 119.995852336775
Riso1206 VDD_B.t106 VDD_B.t53 77.3711031012669
Riso1207 VDD_B.t106 VDD_B.t55 6285.95539472171
Riso1208 VDD_B.t106 VDD_B.t56 297.865452168809
Riso1209 VDD_B.t106 VDD_B.t57 204.066265477054
Riso1210 VDD_B.t106 VDD_B.t58 225840.921388403
Riso1211 VDD_B.t106 VDD_B.t59 1299.21658398545
Riso1212 VDD_B.t106 VDD_B.t6 4567.8685499347
Riso1213 VDD_B.t106 VDD_B.t60 71.0455665511807
Riso1214 VDD_B.t106 VDD_B.t61 727.875881690861
Riso1215 VDD_B.t106 VDD_B.t62 1031.71610663939
Riso1216 VDD_B.t106 VDD_B.t63 416.763816278014
Riso1217 VDD_B.t106 VDD_B.t64 340.932999014875
Riso1218 VDD_B.t106 VDD_B.t66 3982.61478290965
Riso1219 VDD_B.t106 VDD_B.t67 129.096756728179
Riso1220 VDD_B.t106 VDD_B.t68 122.004214673235
Riso1221 VDD_B.t106 VDD_B.t69 976.93610203862
Riso1222 VDD_B.t106 VDD_B.t70 508.175705284665
Riso1223 VDD_B.t106 VDD_B.t71 35697.0143196504
Riso1224 VDD_B.t106 VDD_B.t73 2768.18499926195
Riso1225 VDD_B.t106 VDD_B.t75 3982.61478290965
Riso1226 VDD_B.t106 VDD_B.t76 0.066960197532176
Riso1227 VDD_B.t106 VDD_B.t77 65.9977652110945
Riso1228 VDD_B.t106 VDD_B.t78 55.9981285599394
Riso1229 VDD_B.t106 VDD_B.t79 61.3893765559523
Riso1230 VDD_B.t106 VDD_B.t8 5233.33835052928
Riso1231 VDD_B.t106 VDD_B.t80 232.548353443667
Riso1232 VDD_B.t106 VDD_B.t81 90806.8558126038
Riso1233 VDD_B.t106 VDD_B.t82 13990.2931243166
Riso1234 VDD_B.t106 VDD_B.t83 92.1200427679123
Riso1235 VDD_B.t106 VDD_B.t85 6455.4526314342
Riso1236 VDD_B.t106 VDD_B.t86 47.2842410931188
Riso1237 VDD_B.t106 VDD_B.t87 1115.79455147991
Riso1238 VDD_B.t106 VDD_B.t88 65.9977652110945
Riso1239 VDD_B.t106 VDD_B.t89 334.766279402891
Riso1240 VDD_B.t106 VDD_B.t9 104.407077306238
Riso1241 VDD_B.t106 VDD_B.t90 1031.71610663939
Riso1242 VDD_B.t106 VDD_B.t91 461.472663733068
Riso1243 VDD_B.t106 VDD_B.t92 90.1733346564786
Riso1244 VDD_B.t106 VDD_B.t94 6895.89034505393
Riso1245 VDD_B.t106 VDD_B.t95 69.9803584485665
Riso1246 VDD_B.t106 VDD_B.t96 18777.8188510454
Riso1247 VDD_B.t106 VDD_B.t97 26954.8637161037
Riso1248 VDD_B.t106 VDD_B.t99 6895.89034505393
Riso1249 VDD_B.t107 VDD_B.t108 214.490858949063
Riso1250 VDD_B.t107 VDD_B.t109 512.991553658014
Riso1251 VDD_B.t107 VDD_B.t11 3612.74254819908
Riso1252 VDD_B.t107 VDD_B.t110 104.719655127377
Riso1253 VDD_B.t107 VDD_B.t111 141.274193231314
Riso1254 VDD_B.t107 VDD_B.t112 173.351152878462
Riso1255 VDD_B.t107 VDD_B.t114 4989.24471878795
Riso1256 VDD_B.t107 VDD_B.t115 214.490858949063
Riso1257 VDD_B.t107 VDD_B.t116 613.683441940686
Riso1258 VDD_B.t107 VDD_B.t117 48.6363324302585
Riso1259 VDD_B.t107 VDD_B.t118 272.246827493601
Riso1260 VDD_B.t107 VDD_B.t119 562.98341506506
Riso1261 VDD_B.t107 VDD_B.t120 239.452844778716
Riso1262 VDD_B.t107 VDD_B.t122 4989.24471878795
Riso1263 VDD_B.t107 VDD_B.t123 122.310476588042
Riso1264 VDD_B.t107 VDD_B.t124 304.788213404466
Riso1265 VDD_B.t107 VDD_B.t125 44914.7015969844
Riso1266 VDD_B.t107 VDD_B.t126 45.2616314999763
Riso1267 VDD_B.t107 VDD_B.t127 311562.459215255
Riso1268 VDD_B.t107 VDD_B.t128 1845.76712671721
Riso1269 VDD_B.t107 VDD_B.t13 4534.13568063325
Riso1270 VDD_B.t107 VDD_B.t130 3530.61252334092
Riso1271 VDD_B.t107 VDD_B.t132 3530.61252334092
Riso1272 VDD_B.t107 VDD_B.t134 3330.19064141061
Riso1273 VDD_B.t107 VDD_B.t135 162.868371593627
Riso1274 VDD_B.t107 VDD_B.t136 823.55295231481
Riso1275 VDD_B.t107 VDD_B.t137 823.55295231481
Riso1276 VDD_B.t107 VDD_B.t139 5290.89416272296
Riso1277 VDD_B.t107 VDD_B.t140 148.47272685887
Riso1278 VDD_B.t107 VDD_B.t141 57.4034092010417
Riso1279 VDD_B.t107 VDD_B.t143 5119.4859963894
Riso1280 VDD_B.t107 VDD_B.t144 199.742992982124
Riso1281 VDD_B.t107 VDD_B.t145 235.161528588896
Riso1282 VDD_B.t107 VDD_B.t147 4534.13568063325
Riso1283 VDD_B.t107 VDD_B.t149 5290.89416272296
Riso1284 VDD_B.t107 VDD_B.t15 1873.7663950723
Riso1285 VDD_B.t107 VDD_B.t150 226.594590021552
Riso1286 VDD_B.t107 VDD_B.t151 186.780690835071
Riso1287 VDD_B.t107 VDD_B.t152 66525.1660386221
Riso1288 VDD_B.t107 VDD_B.t153 41.2053257384006
Riso1289 VDD_B.t107 VDD_B.t154 213.031225003816
Riso1290 VDD_B.t107 VDD_B.t17 3330.19064141061
Riso1291 VDD_B.t107 VDD_B.t18 45.8112990021311
Riso1292 VDD_B.t107 VDD_B.t2 4179.77469338731
Riso1293 VDD_B.t107 VDD_B.t20 3088.78268562239
Riso1294 VDD_B.t107 VDD_B.t22 4887.60783314019
Riso1295 VDD_B.t107 VDD_B.t23 213.031225003816
Riso1296 VDD_B.t107 VDD_B.t24 112902.118977469
Riso1297 VDD_B.t107 VDD_B.t25 5276.36976211128
Riso1298 VDD_B.t107 VDD_B.t26 613.683441940686
Riso1299 VDD_B.t107 VDD_B.t27 66.949923758641
Riso1300 VDD_B.t107 VDD_B.t28 183.274104258269
Riso1301 VDD_B.t107 VDD_B.t3 207425.095582623
Riso1302 VDD_B.t107 VDD_B.t30 3088.78268562239
Riso1303 VDD_B.t107 VDD_B.t31 756.280915938284
Riso1304 VDD_B.t107 VDD_B.t32 37103.1899919827
Riso1305 VDD_B.t107 VDD_B.t33 663.897246192005
Riso1306 VDD_B.t107 VDD_B.t34 464.5865169346
Riso1307 VDD_B.t107 VDD_B.t35 62039.5166299437
Riso1308 VDD_B.t107 VDD_B.t36 65475.9799618989
Riso1309 VDD_B.t107 VDD_B.t37 58.9921546880129
Riso1310 VDD_B.t107 VDD_B.t38 66.949923758641
Riso1311 VDD_B.t107 VDD_B.t39 131.445007397423
Riso1312 VDD_B.t107 VDD_B.t4 5276.36976211128
Riso1313 VDD_B.t107 VDD_B.t41 2224.96530765422
Riso1314 VDD_B.t107 VDD_B.t42 241.569088670328
Riso1315 VDD_B.t107 VDD_B.t43 562.98341506506
Riso1316 VDD_B.t107 VDD_B.t44 85334.5140165588
Riso1317 VDD_B.t107 VDD_B.t45 250508.919276278
Riso1318 VDD_B.t107 VDD_B.t46 239.452844778716
Riso1319 VDD_B.t107 VDD_B.t47 165.940875239316
Riso1320 VDD_B.t107 VDD_B.t48 121.926977238574
Riso1321 VDD_B.t107 VDD_B.t49 56.9633774977882
Riso1322 VDD_B.t107 VDD_B.t50 48.8371511613795
Riso1323 VDD_B.t107 VDD_B.t51 756.280915938284
Riso1324 VDD_B.t107 VDD_B.t52 56.9633774977882
Riso1325 VDD_B.t107 VDD_B.t53 0.0669656548916217
Riso1326 VDD_B.t107 VDD_B.t55 4887.60783314019
Riso1327 VDD_B.t107 VDD_B.t56 162.868371593627
Riso1328 VDD_B.t107 VDD_B.t57 104.719655127377
Riso1329 VDD_B.t107 VDD_B.t58 181671.661998326
Riso1330 VDD_B.t107 VDD_B.t59 1044.97770516464
Riso1331 VDD_B.t107 VDD_B.t6 3612.74254819908
Riso1332 VDD_B.t107 VDD_B.t60 148.47272685887
Riso1333 VDD_B.t107 VDD_B.t61 464.5865169346
Riso1334 VDD_B.t107 VDD_B.t62 712.071722925605
Riso1335 VDD_B.t107 VDD_B.t63 241.569088670328
Riso1336 VDD_B.t107 VDD_B.t64 214.103763192313
Riso1337 VDD_B.t107 VDD_B.t66 3239.97849025458
Riso1338 VDD_B.t107 VDD_B.t67 235.161528588896
Riso1339 VDD_B.t107 VDD_B.t68 226.594590021552
Riso1340 VDD_B.t107 VDD_B.t69 663.897246192005
Riso1341 VDD_B.t107 VDD_B.t70 304.788213404466
Riso1342 VDD_B.t107 VDD_B.t71 35502.7372115703
Riso1343 VDD_B.t107 VDD_B.t73 2224.96530765422
Riso1344 VDD_B.t107 VDD_B.t75 3239.97849025458
Riso1345 VDD_B.t107 VDD_B.t76 77.3711031012669
Riso1346 VDD_B.t107 VDD_B.t77 41.2746361723095
Riso1347 VDD_B.t107 VDD_B.t78 48.8371511613795
Riso1348 VDD_B.t107 VDD_B.t79 131.445007397423
Riso1349 VDD_B.t107 VDD_B.t8 4179.77469338731
Riso1350 VDD_B.t107 VDD_B.t80 121.926977238574
Riso1351 VDD_B.t107 VDD_B.t81 90312.649401302
Riso1352 VDD_B.t107 VDD_B.t82 13914.1524794703
Riso1353 VDD_B.t107 VDD_B.t83 183.274104258269
Riso1354 VDD_B.t107 VDD_B.t85 5119.4859963894
Riso1355 VDD_B.t107 VDD_B.t86 57.4034092010417
Riso1356 VDD_B.t107 VDD_B.t87 794.26544619251
Riso1357 VDD_B.t107 VDD_B.t88 41.2746361723095
Riso1358 VDD_B.t107 VDD_B.t89 186.780690835071
Riso1359 VDD_B.t107 VDD_B.t9 48.6363324302585
Riso1360 VDD_B.t107 VDD_B.t90 712.071722925605
Riso1361 VDD_B.t107 VDD_B.t91 272.246827493601
Riso1362 VDD_B.t107 VDD_B.t92 41.2053257384006
Riso1363 VDD_B.t107 VDD_B.t94 5418.41009254307
Riso1364 VDD_B.t107 VDD_B.t95 33.8208261170467
Riso1365 VDD_B.t107 VDD_B.t96 18675.6226194569
Riso1366 VDD_B.t107 VDD_B.t97 26808.1648094511
Riso1367 VDD_B.t107 VDD_B.t99 5418.41009254307
Riso1368 VDD_B.t108 VDD_B.t109 1195.8291901637
Riso1369 VDD_B.t108 VDD_B.t11 4087.941074462
Riso1370 VDD_B.t108 VDD_B.t110 444.268266799069
Riso1371 VDD_B.t108 VDD_B.t111 538.531083339674
Riso1372 VDD_B.t108 VDD_B.t112 480.848302599957
Riso1373 VDD_B.t108 VDD_B.t114 6465.93270674221
Riso1374 VDD_B.t108 VDD_B.t115 0.0669425653843742
Riso1375 VDD_B.t108 VDD_B.t116 1300.41585111879
Riso1376 VDD_B.t108 VDD_B.t117 268.219148433972
Riso1377 VDD_B.t108 VDD_B.t118 819.103581178592
Riso1378 VDD_B.t108 VDD_B.t119 1252.15683408358
Riso1379 VDD_B.t108 VDD_B.t120 38.9101946685691
Riso1380 VDD_B.t108 VDD_B.t122 6465.93270674221
Riso1381 VDD_B.t108 VDD_B.t123 20.7365962304243
Riso1382 VDD_B.t108 VDD_B.t124 879.594815763515
Riso1383 VDD_B.t108 VDD_B.t125 27265.758066741
Riso1384 VDD_B.t108 VDD_B.t126 50.1942747907588
Riso1385 VDD_B.t108 VDD_B.t127 159625.603457743
Riso1386 VDD_B.t108 VDD_B.t128 1035.00203096386
Riso1387 VDD_B.t108 VDD_B.t13 5252.33008604362
Riso1388 VDD_B.t108 VDD_B.t130 2433.19257124787
Riso1389 VDD_B.t108 VDD_B.t132 2433.19257124787
Riso1390 VDD_B.t108 VDD_B.t134 2947.82332953378
Riso1391 VDD_B.t108 VDD_B.t135 589.988964430952
Riso1392 VDD_B.t108 VDD_B.t136 1343.19371285315
Riso1393 VDD_B.t108 VDD_B.t137 1343.19371285315
Riso1394 VDD_B.t108 VDD_B.t139 6331.83419939879
Riso1395 VDD_B.t108 VDD_B.t140 56.1529915436498
Riso1396 VDD_B.t108 VDD_B.t141 148.054341589368
Riso1397 VDD_B.t108 VDD_B.t143 6682.37956405113
Riso1398 VDD_B.t108 VDD_B.t144 34.8785525112217
Riso1399 VDD_B.t108 VDD_B.t145 36.3214211445903
Riso1400 VDD_B.t108 VDD_B.t147 5252.33008604362
Riso1401 VDD_B.t108 VDD_B.t149 6331.83419939879
Riso1402 VDD_B.t108 VDD_B.t15 2042.16138747408
Riso1403 VDD_B.t108 VDD_B.t150 33.0546148645204
Riso1404 VDD_B.t108 VDD_B.t151 644.131059187578
Riso1405 VDD_B.t108 VDD_B.t152 40384.5292981002
Riso1406 VDD_B.t108 VDD_B.t153 240.441390890883
Riso1407 VDD_B.t108 VDD_B.t154 700.674687566599
Riso1408 VDD_B.t108 VDD_B.t17 2947.82332953378
Riso1409 VDD_B.t108 VDD_B.t18 205.498616214681
Riso1410 VDD_B.t108 VDD_B.t2 5469.8640141262
Riso1411 VDD_B.t108 VDD_B.t20 4048.43778451937
Riso1412 VDD_B.t108 VDD_B.t22 6264.24986392129
Riso1413 VDD_B.t108 VDD_B.t23 700.674687566599
Riso1414 VDD_B.t108 VDD_B.t24 140865.913154152
Riso1415 VDD_B.t108 VDD_B.t25 6567.43030498894
Riso1416 VDD_B.t108 VDD_B.t26 1300.41585111879
Riso1417 VDD_B.t108 VDD_B.t27 129.652903030868
Riso1418 VDD_B.t108 VDD_B.t28 41.1266460139111
Riso1419 VDD_B.t108 VDD_B.t3 258800.505827215
Riso1420 VDD_B.t108 VDD_B.t30 4048.43778451937
Riso1421 VDD_B.t108 VDD_B.t31 1373.25633565876
Riso1422 VDD_B.t108 VDD_B.t32 22523.7297779053
Riso1423 VDD_B.t108 VDD_B.t33 1338.2065606042
Riso1424 VDD_B.t108 VDD_B.t34 1133.71674438197
Riso1425 VDD_B.t108 VDD_B.t35 37661.4870157163
Riso1426 VDD_B.t108 VDD_B.t36 39747.6141518834
Riso1427 VDD_B.t108 VDD_B.t37 38.0600910885906
Riso1428 VDD_B.t108 VDD_B.t38 129.652903030868
Riso1429 VDD_B.t108 VDD_B.t39 64.9079674196179
Riso1430 VDD_B.t108 VDD_B.t4 6567.43030498894
Riso1431 VDD_B.t108 VDD_B.t41 2918.49092258635
Riso1432 VDD_B.t108 VDD_B.t42 759.197091519178
Riso1433 VDD_B.t108 VDD_B.t43 1252.15683408358
Riso1434 VDD_B.t108 VDD_B.t44 51802.8647901475
Riso1435 VDD_B.t108 VDD_B.t45 152073.048326928
Riso1436 VDD_B.t108 VDD_B.t46 38.9101946685691
Riso1437 VDD_B.t108 VDD_B.t47 48.2141135044291
Riso1438 VDD_B.t108 VDD_B.t48 489.928986636548
Riso1439 VDD_B.t108 VDD_B.t49 297.682456915047
Riso1440 VDD_B.t108 VDD_B.t50 168.299407601315
Riso1441 VDD_B.t108 VDD_B.t51 1373.25633565876
Riso1442 VDD_B.t108 VDD_B.t52 297.682456915047
Riso1443 VDD_B.t108 VDD_B.t53 214.490858949063
Riso1444 VDD_B.t108 VDD_B.t55 6264.24986392129
Riso1445 VDD_B.t108 VDD_B.t56 589.988964430952
Riso1446 VDD_B.t108 VDD_B.t57 444.268266799069
Riso1447 VDD_B.t108 VDD_B.t58 238358.014577272
Riso1448 VDD_B.t108 VDD_B.t59 1371.04327315417
Riso1449 VDD_B.t108 VDD_B.t6 4087.941074462
Riso1450 VDD_B.t108 VDD_B.t60 56.1529915436498
Riso1451 VDD_B.t108 VDD_B.t61 1133.71674438197
Riso1452 VDD_B.t108 VDD_B.t62 1363.18033209605
Riso1453 VDD_B.t108 VDD_B.t63 759.197091519178
Riso1454 VDD_B.t108 VDD_B.t64 546.473545419999
Riso1455 VDD_B.t108 VDD_B.t66 3317.26879251307
Riso1456 VDD_B.t108 VDD_B.t67 36.3214211445903
Riso1457 VDD_B.t108 VDD_B.t68 33.0546148645204
Riso1458 VDD_B.t108 VDD_B.t69 1338.2065606042
Riso1459 VDD_B.t108 VDD_B.t70 879.594815763515
Riso1460 VDD_B.t108 VDD_B.t71 21552.1646387327
Riso1461 VDD_B.t108 VDD_B.t73 2918.49092258635
Riso1462 VDD_B.t108 VDD_B.t75 3317.26879251307
Riso1463 VDD_B.t108 VDD_B.t76 113.024992184948
Riso1464 VDD_B.t108 VDD_B.t77 190.437762542689
Riso1465 VDD_B.t108 VDD_B.t78 168.299407601315
Riso1466 VDD_B.t108 VDD_B.t79 64.9079674196179
Riso1467 VDD_B.t108 VDD_B.t8 5469.8640141262
Riso1468 VDD_B.t108 VDD_B.t80 489.928986636548
Riso1469 VDD_B.t108 VDD_B.t81 54824.8738472667
Riso1470 VDD_B.t108 VDD_B.t82 8446.67562556963
Riso1471 VDD_B.t108 VDD_B.t83 41.1266460139111
Riso1472 VDD_B.t108 VDD_B.t85 6682.37956405113
Riso1473 VDD_B.t108 VDD_B.t86 148.054341589368
Riso1474 VDD_B.t108 VDD_B.t87 1366.86682360743
Riso1475 VDD_B.t108 VDD_B.t88 190.437762542689
Riso1476 VDD_B.t108 VDD_B.t89 644.131059187578
Riso1477 VDD_B.t108 VDD_B.t9 268.219148433972
Riso1478 VDD_B.t108 VDD_B.t90 1363.18033209605
Riso1479 VDD_B.t108 VDD_B.t91 819.103581178592
Riso1480 VDD_B.t108 VDD_B.t92 240.441390890883
Riso1481 VDD_B.t108 VDD_B.t94 7049.04827981158
Riso1482 VDD_B.t108 VDD_B.t95 168.154494069416
Riso1483 VDD_B.t108 VDD_B.t96 11337.1566543382
Riso1484 VDD_B.t108 VDD_B.t97 16274.0686215956
Riso1485 VDD_B.t108 VDD_B.t99 7049.04827981158
Riso1486 VDD_B.t109 VDD_B.t11 596.287950441313
Riso1487 VDD_B.t109 VDD_B.t110 234.941735586855
Riso1488 VDD_B.t109 VDD_B.t111 183.007474749623
Riso1489 VDD_B.t109 VDD_B.t112 32.6705850082792
Riso1490 VDD_B.t109 VDD_B.t114 691.000205820859
Riso1491 VDD_B.t109 VDD_B.t115 1195.8291901637
Riso1492 VDD_B.t109 VDD_B.t116 47.1525644659047
Riso1493 VDD_B.t109 VDD_B.t117 416.1707973372
Riso1494 VDD_B.t109 VDD_B.t118 88.4166567448977
Riso1495 VDD_B.t109 VDD_B.t119 40.0450314987865
Riso1496 VDD_B.t109 VDD_B.t120 1142.07378979784
Riso1497 VDD_B.t109 VDD_B.t122 691.000205820859
Riso1498 VDD_B.t109 VDD_B.t123 560.137659885222
Riso1499 VDD_B.t109 VDD_B.t124 75.2994506603556
Riso1500 VDD_B.t109 VDD_B.t125 10447.9837394839
Riso1501 VDD_B.t109 VDD_B.t126 433.372119007247
Riso1502 VDD_B.t109 VDD_B.t127 75558.5803060191
Riso1503 VDD_B.t109 VDD_B.t128 418.729465701152
Riso1504 VDD_B.t109 VDD_B.t13 718.049717073617
Riso1505 VDD_B.t109 VDD_B.t130 709.769992849425
Riso1506 VDD_B.t109 VDD_B.t132 709.769992849425
Riso1507 VDD_B.t109 VDD_B.t134 602.999997963375
Riso1508 VDD_B.t109 VDD_B.t135 159.975835950957
Riso1509 VDD_B.t109 VDD_B.t136 89.9365826099478
Riso1510 VDD_B.t109 VDD_B.t137 89.9365826099478
Riso1511 VDD_B.t109 VDD_B.t139 786.706132441119
Riso1512 VDD_B.t109 VDD_B.t140 1075.41647154352
Riso1513 VDD_B.t109 VDD_B.t141 676.572848626249
Riso1514 VDD_B.t109 VDD_B.t143 944.252872166634
Riso1515 VDD_B.t109 VDD_B.t144 1183.75525240334
Riso1516 VDD_B.t109 VDD_B.t145 1175.28802686327
Riso1517 VDD_B.t109 VDD_B.t147 718.049717073617
Riso1518 VDD_B.t109 VDD_B.t149 786.706132441119
Riso1519 VDD_B.t109 VDD_B.t15 316.345662552968
Riso1520 VDD_B.t109 VDD_B.t150 1193.2422138575
Riso1521 VDD_B.t109 VDD_B.t151 139.03250573893
Riso1522 VDD_B.t109 VDD_B.t152 15474.9743029498
Riso1523 VDD_B.t109 VDD_B.t153 463.131570765431
Riso1524 VDD_B.t109 VDD_B.t154 120.171799705782
Riso1525 VDD_B.t109 VDD_B.t17 602.999997963375
Riso1526 VDD_B.t109 VDD_B.t18 134.764580692341
Riso1527 VDD_B.t109 VDD_B.t2 891.535015408939
Riso1528 VDD_B.t109 VDD_B.t20 727.495398203887
Riso1529 VDD_B.t109 VDD_B.t22 654.682989996584
Riso1530 VDD_B.t109 VDD_B.t23 120.171799705782
Riso1531 VDD_B.t109 VDD_B.t24 15605.1878922316
Riso1532 VDD_B.t109 VDD_B.t25 732.473721879656
Riso1533 VDD_B.t109 VDD_B.t26 47.1525644659047
Riso1534 VDD_B.t109 VDD_B.t27 733.841874404479
Riso1535 VDD_B.t109 VDD_B.t28 1158.39299539474
Riso1536 VDD_B.t109 VDD_B.t3 28670.0340033201
Riso1537 VDD_B.t109 VDD_B.t30 727.495398203887
Riso1538 VDD_B.t109 VDD_B.t31 72.5526989064646
Riso1539 VDD_B.t109 VDD_B.t32 8630.88280531392
Riso1540 VDD_B.t109 VDD_B.t33 55.0462365727559
Riso1541 VDD_B.t109 VDD_B.t34 39.8054278236201
Riso1542 VDD_B.t109 VDD_B.t35 14431.5299424947
Riso1543 VDD_B.t109 VDD_B.t36 15230.914369798
Riso1544 VDD_B.t109 VDD_B.t37 493.095660740461
Riso1545 VDD_B.t109 VDD_B.t38 733.841874404479
Riso1546 VDD_B.t109 VDD_B.t39 1022.05524696501
Riso1547 VDD_B.t109 VDD_B.t4 732.473721879656
Riso1548 VDD_B.t109 VDD_B.t41 552.533448661905
Riso1549 VDD_B.t109 VDD_B.t42 103.332821684366
Riso1550 VDD_B.t109 VDD_B.t43 40.0450314987865
Riso1551 VDD_B.t109 VDD_B.t44 19850.3737787636
Riso1552 VDD_B.t109 VDD_B.t45 58272.9712573662
Riso1553 VDD_B.t109 VDD_B.t46 1142.07378979784
Riso1554 VDD_B.t109 VDD_B.t47 1121.58186855572
Riso1555 VDD_B.t109 VDD_B.t48 208.055493016744
Riso1556 VDD_B.t109 VDD_B.t49 372.270782434245
Riso1557 VDD_B.t109 VDD_B.t50 620.198117342694
Riso1558 VDD_B.t109 VDD_B.t51 72.5526989064646
Riso1559 VDD_B.t109 VDD_B.t52 372.270782434245
Riso1560 VDD_B.t109 VDD_B.t53 512.991553658014
Riso1561 VDD_B.t109 VDD_B.t55 654.682989996584
Riso1562 VDD_B.t109 VDD_B.t56 159.975835950957
Riso1563 VDD_B.t109 VDD_B.t57 234.941735586855
Riso1564 VDD_B.t109 VDD_B.t58 46096.9958596667
Riso1565 VDD_B.t109 VDD_B.t59 264.204565541222
Riso1566 VDD_B.t109 VDD_B.t6 596.287950441313
Riso1567 VDD_B.t109 VDD_B.t60 1075.41647154352
Riso1568 VDD_B.t109 VDD_B.t61 39.8054278236201
Riso1569 VDD_B.t109 VDD_B.t62 63.5961097939839
Riso1570 VDD_B.t109 VDD_B.t63 103.332821684366
Riso1571 VDD_B.t109 VDD_B.t64 23.7832404222887
Riso1572 VDD_B.t109 VDD_B.t66 559.068442353038
Riso1573 VDD_B.t109 VDD_B.t67 1175.28802686327
Riso1574 VDD_B.t109 VDD_B.t68 1193.2422138575
Riso1575 VDD_B.t109 VDD_B.t69 55.0462365727559
Riso1576 VDD_B.t109 VDD_B.t70 75.2994506603556
Riso1577 VDD_B.t109 VDD_B.t71 8258.58812159096
Riso1578 VDD_B.t109 VDD_B.t73 552.533448661905
Riso1579 VDD_B.t109 VDD_B.t75 559.068442353038
Riso1580 VDD_B.t109 VDD_B.t76 791.01659413903
Riso1581 VDD_B.t109 VDD_B.t77 565.481619137645
Riso1582 VDD_B.t109 VDD_B.t78 620.198117342694
Riso1583 VDD_B.t109 VDD_B.t79 1022.05524696501
Riso1584 VDD_B.t109 VDD_B.t8 891.535015408939
Riso1585 VDD_B.t109 VDD_B.t80 208.055493016744
Riso1586 VDD_B.t109 VDD_B.t81 21008.379413966
Riso1587 VDD_B.t109 VDD_B.t82 3236.68718003831
Riso1588 VDD_B.t109 VDD_B.t83 1158.39299539474
Riso1589 VDD_B.t109 VDD_B.t85 944.252872166634
Riso1590 VDD_B.t109 VDD_B.t86 676.572848626249
Riso1591 VDD_B.t109 VDD_B.t87 81.5182986995822
Riso1592 VDD_B.t109 VDD_B.t88 565.481619137645
Riso1593 VDD_B.t109 VDD_B.t89 139.03250573893
Riso1594 VDD_B.t109 VDD_B.t9 416.1707973372
Riso1595 VDD_B.t109 VDD_B.t90 63.5961097939839
Riso1596 VDD_B.t109 VDD_B.t91 88.4166567448977
Riso1597 VDD_B.t109 VDD_B.t92 463.131570765431
Riso1598 VDD_B.t109 VDD_B.t94 850.277143960162
Riso1599 VDD_B.t109 VDD_B.t95 169.645674653703
Riso1600 VDD_B.t109 VDD_B.t96 4344.29250368044
Riso1601 VDD_B.t109 VDD_B.t97 6236.0710425683
Riso1602 VDD_B.t109 VDD_B.t99 850.277143960162
Riso1603 VDD_B.t11 VDD_B.t110 2109.07322322493
Riso1604 VDD_B.t11 VDD_B.t111 1776.73201368253
Riso1605 VDD_B.t11 VDD_B.t112 458.666404277629
Riso1606 VDD_B.t11 VDD_B.t114 317.301611571871
Riso1607 VDD_B.t11 VDD_B.t115 4087.941074462
Riso1608 VDD_B.t11 VDD_B.t116 479.317875969705
Riso1609 VDD_B.t11 VDD_B.t117 3144.16548350801
Riso1610 VDD_B.t11 VDD_B.t118 1102.15039058509
Riso1611 VDD_B.t11 VDD_B.t119 535.581887327304
Riso1612 VDD_B.t11 VDD_B.t120 3260.52280503279
Riso1613 VDD_B.t11 VDD_B.t122 317.301611571871
Riso1614 VDD_B.t11 VDD_B.t123 1518.28695113792
Riso1615 VDD_B.t11 VDD_B.t124 994.942310609999
Riso1616 VDD_B.t11 VDD_B.t125 4773.91074296925
Riso1617 VDD_B.t11 VDD_B.t126 2388.63608035019
Riso1618 VDD_B.t11 VDD_B.t127 20018.2881152651
Riso1619 VDD_B.t11 VDD_B.t128 99.6970535203702
Riso1620 VDD_B.t11 VDD_B.t13 53.8266484552416
Riso1621 VDD_B.t11 VDD_B.t130 145.05037179205
Riso1622 VDD_B.t11 VDD_B.t132 145.05037179205
Riso1623 VDD_B.t11 VDD_B.t134 109.15919207108
Riso1624 VDD_B.t11 VDD_B.t135 1623.08256251083
Riso1625 VDD_B.t11 VDD_B.t136 261.480064779972
Riso1626 VDD_B.t11 VDD_B.t137 261.480064779972
Riso1627 VDD_B.t11 VDD_B.t139 83.2674374601055
Riso1628 VDD_B.t11 VDD_B.t140 4752.73779026102
Riso1629 VDD_B.t11 VDD_B.t141 4255.68791110627
Riso1630 VDD_B.t11 VDD_B.t143 640.631791416729
Riso1631 VDD_B.t11 VDD_B.t144 4317.33758027708
Riso1632 VDD_B.t11 VDD_B.t145 3550.69587617647
Riso1633 VDD_B.t11 VDD_B.t147 53.8266484552416
Riso1634 VDD_B.t11 VDD_B.t149 83.2674374601055
Riso1635 VDD_B.t11 VDD_B.t15 32.4875624666552
Riso1636 VDD_B.t11 VDD_B.t150 3829.41585898366
Riso1637 VDD_B.t11 VDD_B.t151 1478.68071966304
Riso1638 VDD_B.t11 VDD_B.t152 7070.85193795241
Riso1639 VDD_B.t11 VDD_B.t153 3378.80555528526
Riso1640 VDD_B.t11 VDD_B.t154 1343.76317638053
Riso1641 VDD_B.t11 VDD_B.t17 109.15919207108
Riso1642 VDD_B.t11 VDD_B.t18 1169.44477020178
Riso1643 VDD_B.t11 VDD_B.t2 829.099684498729
Riso1644 VDD_B.t11 VDD_B.t20 947.039711732903
Riso1645 VDD_B.t11 VDD_B.t22 215.874985774212
Riso1646 VDD_B.t11 VDD_B.t23 1343.76317638053
Riso1647 VDD_B.t11 VDD_B.t24 2996.55050361299
Riso1648 VDD_B.t11 VDD_B.t25 133.720083242536
Riso1649 VDD_B.t11 VDD_B.t26 479.317875969705
Riso1650 VDD_B.t11 VDD_B.t27 4428.2452779483
Riso1651 VDD_B.t11 VDD_B.t28 4509.14082502388
Riso1652 VDD_B.t11 VDD_B.t3 5505.29768847047
Riso1653 VDD_B.t11 VDD_B.t30 947.039711732903
Riso1654 VDD_B.t11 VDD_B.t31 336.585540761763
Riso1655 VDD_B.t11 VDD_B.t32 3943.63785137666
Riso1656 VDD_B.t11 VDD_B.t33 427.477744596284
Riso1657 VDD_B.t11 VDD_B.t34 661.326016101953
Riso1658 VDD_B.t11 VDD_B.t35 6594.07954183521
Riso1659 VDD_B.t11 VDD_B.t36 6959.33565252799
Riso1660 VDD_B.t11 VDD_B.t37 2449.04886472678
Riso1661 VDD_B.t11 VDD_B.t38 4428.2452779483
Riso1662 VDD_B.t11 VDD_B.t39 4796.09214619394
Riso1663 VDD_B.t11 VDD_B.t4 133.720083242536
Riso1664 VDD_B.t11 VDD_B.t41 934.448435905108
Riso1665 VDD_B.t11 VDD_B.t42 1218.31751522826
Riso1666 VDD_B.t11 VDD_B.t43 535.581887327304
Riso1667 VDD_B.t11 VDD_B.t44 9070.06700979756
Riso1668 VDD_B.t11 VDD_B.t45 26626.1864917508
Riso1669 VDD_B.t11 VDD_B.t46 3260.52280503279
Riso1670 VDD_B.t11 VDD_B.t47 4656.07704379451
Riso1671 VDD_B.t11 VDD_B.t48 1939.06084880104
Riso1672 VDD_B.t11 VDD_B.t49 2912.87855427483
Riso1673 VDD_B.t11 VDD_B.t50 4057.51618882136
Riso1674 VDD_B.t11 VDD_B.t51 336.585540761763
Riso1675 VDD_B.t11 VDD_B.t52 2912.87855427483
Riso1676 VDD_B.t11 VDD_B.t53 3612.74254819908
Riso1677 VDD_B.t11 VDD_B.t55 215.874985774212
Riso1678 VDD_B.t11 VDD_B.t56 1623.08256251083
Riso1679 VDD_B.t11 VDD_B.t57 2109.07322322493
Riso1680 VDD_B.t11 VDD_B.t58 87898.474316144
Riso1681 VDD_B.t11 VDD_B.t59 499.100708681504
Riso1682 VDD_B.t11 VDD_B.t6 0.826704818955046
Riso1683 VDD_B.t11 VDD_B.t60 4752.73779026102
Riso1684 VDD_B.t11 VDD_B.t61 661.326016101953
Riso1685 VDD_B.t11 VDD_B.t62 379.955159424618
Riso1686 VDD_B.t11 VDD_B.t63 1218.31751522826
Riso1687 VDD_B.t11 VDD_B.t64 373.776725603589
Riso1688 VDD_B.t11 VDD_B.t66 80.2998669021003
Riso1689 VDD_B.t11 VDD_B.t67 3550.69587617647
Riso1690 VDD_B.t11 VDD_B.t68 3829.41585898366
Riso1691 VDD_B.t11 VDD_B.t69 427.477744596284
Riso1692 VDD_B.t11 VDD_B.t70 994.942310609999
Riso1693 VDD_B.t11 VDD_B.t71 3773.52832263967
Riso1694 VDD_B.t11 VDD_B.t73 934.448435905108
Riso1695 VDD_B.t11 VDD_B.t75 80.2998669021003
Riso1696 VDD_B.t11 VDD_B.t76 4567.8685499347
Riso1697 VDD_B.t11 VDD_B.t77 3840.95993824727
Riso1698 VDD_B.t11 VDD_B.t78 4057.51618882136
Riso1699 VDD_B.t11 VDD_B.t79 4796.09214619394
Riso1700 VDD_B.t11 VDD_B.t8 829.099684498729
Riso1701 VDD_B.t11 VDD_B.t80 1939.06084880104
Riso1702 VDD_B.t11 VDD_B.t81 9599.18494108035
Riso1703 VDD_B.t11 VDD_B.t82 1478.91268647581
Riso1704 VDD_B.t11 VDD_B.t83 4509.14082502388
Riso1705 VDD_B.t11 VDD_B.t85 640.631791416729
Riso1706 VDD_B.t11 VDD_B.t86 4255.68791110627
Riso1707 VDD_B.t11 VDD_B.t87 297.167847432962
Riso1708 VDD_B.t11 VDD_B.t88 3840.95993824727
Riso1709 VDD_B.t11 VDD_B.t89 1478.68071966304
Riso1710 VDD_B.t11 VDD_B.t9 3144.16548350801
Riso1711 VDD_B.t11 VDD_B.t90 379.955159424618
Riso1712 VDD_B.t11 VDD_B.t91 1102.15039058509
Riso1713 VDD_B.t11 VDD_B.t92 3378.80555528526
Riso1714 VDD_B.t11 VDD_B.t94 458.586147308415
Riso1715 VDD_B.t11 VDD_B.t95 1375.59560703552
Riso1716 VDD_B.t11 VDD_B.t96 1985.00162050839
Riso1717 VDD_B.t11 VDD_B.t97 2849.3963319957
Riso1718 VDD_B.t11 VDD_B.t99 458.586147308415
Riso1719 VDD_B.t110 VDD_B.t111 48.3346565738348
Riso1720 VDD_B.t110 VDD_B.t112 71.7070414986966
Riso1721 VDD_B.t110 VDD_B.t114 2908.94194306815
Riso1722 VDD_B.t110 VDD_B.t115 444.268266799069
Riso1723 VDD_B.t110 VDD_B.t116 295.21089921818
Riso1724 VDD_B.t110 VDD_B.t117 76.6283258798225
Riso1725 VDD_B.t110 VDD_B.t118 107.131630596703
Riso1726 VDD_B.t110 VDD_B.t119 264.364454111805
Riso1727 VDD_B.t110 VDD_B.t120 468.748400508824
Riso1728 VDD_B.t110 VDD_B.t122 2908.94194306815
Riso1729 VDD_B.t110 VDD_B.t123 236.304694119709
Riso1730 VDD_B.t110 VDD_B.t124 123.084447404108
Riso1731 VDD_B.t110 VDD_B.t125 32156.0589472308
Riso1732 VDD_B.t110 VDD_B.t126 116.375853803623
Riso1733 VDD_B.t110 VDD_B.t127 232971.867173117
Riso1734 VDD_B.t110 VDD_B.t128 1321.43378136403
Riso1735 VDD_B.t110 VDD_B.t13 2639.11109882649
Riso1736 VDD_B.t110 VDD_B.t130 2331.96680828033
Riso1737 VDD_B.t110 VDD_B.t132 2331.96680828033
Riso1738 VDD_B.t110 VDD_B.t134 2046.41748180214
Riso1739 VDD_B.t110 VDD_B.t135 57.3081010506099
Riso1740 VDD_B.t110 VDD_B.t136 439.911808410001
Riso1741 VDD_B.t110 VDD_B.t137 439.911808410001
Riso1742 VDD_B.t110 VDD_B.t139 3068.41753282792
Riso1743 VDD_B.t110 VDD_B.t140 341.260689685434
Riso1744 VDD_B.t110 VDD_B.t141 159.832418010433
Riso1745 VDD_B.t110 VDD_B.t143 3169.80427257127
Riso1746 VDD_B.t110 VDD_B.t144 423.612411146204
Riso1747 VDD_B.t110 VDD_B.t145 467.825231444376
Riso1748 VDD_B.t110 VDD_B.t147 2639.11109882649
Riso1749 VDD_B.t110 VDD_B.t149 3068.41753282792
Riso1750 VDD_B.t110 VDD_B.t15 1101.05783034811
Riso1751 VDD_B.t110 VDD_B.t150 459.386310049506
Riso1752 VDD_B.t110 VDD_B.t151 67.6116675155874
Riso1753 VDD_B.t110 VDD_B.t152 47627.7718553489
Riso1754 VDD_B.t110 VDD_B.t153 89.8237517697841
Riso1755 VDD_B.t110 VDD_B.t154 79.3304376476345
Riso1756 VDD_B.t110 VDD_B.t17 2046.41748180214
Riso1757 VDD_B.t110 VDD_B.t18 20.3386927694067
Riso1758 VDD_B.t110 VDD_B.t2 2654.79584131428
Riso1759 VDD_B.t110 VDD_B.t20 1992.89776763278
Riso1760 VDD_B.t110 VDD_B.t22 2820.21569597943
Riso1761 VDD_B.t110 VDD_B.t23 79.3304376476345
Riso1762 VDD_B.t110 VDD_B.t24 65192.2341235372
Riso1763 VDD_B.t110 VDD_B.t25 3047.13524691727
Riso1764 VDD_B.t110 VDD_B.t26 295.21089921818
Riso1765 VDD_B.t110 VDD_B.t27 181.37425508793
Riso1766 VDD_B.t110 VDD_B.t28 398.708258118159
Riso1767 VDD_B.t110 VDD_B.t3 119771.936229275
Riso1768 VDD_B.t110 VDD_B.t30 1992.89776763278
Riso1769 VDD_B.t110 VDD_B.t31 388.821234441287
Riso1770 VDD_B.t110 VDD_B.t32 26563.5153321959
Riso1771 VDD_B.t110 VDD_B.t33 326.863238510299
Riso1772 VDD_B.t110 VDD_B.t34 207.351631817083
Riso1773 VDD_B.t110 VDD_B.t35 44416.3332467541
Riso1774 VDD_B.t110 VDD_B.t36 46876.6216054275
Riso1775 VDD_B.t110 VDD_B.t37 143.729229549927
Riso1776 VDD_B.t110 VDD_B.t38 181.37425508793
Riso1777 VDD_B.t110 VDD_B.t39 310.975042715586
Riso1778 VDD_B.t110 VDD_B.t4 3047.13524691727
Riso1779 VDD_B.t110 VDD_B.t41 1446.88762081331
Riso1780 VDD_B.t110 VDD_B.t42 92.5097092801871
Riso1781 VDD_B.t110 VDD_B.t43 264.364454111805
Riso1782 VDD_B.t110 VDD_B.t44 61094.0642013302
Riso1783 VDD_B.t110 VDD_B.t45 179348.393480053
Riso1784 VDD_B.t110 VDD_B.t46 468.748400508824
Riso1785 VDD_B.t110 VDD_B.t47 370.855388422495
Riso1786 VDD_B.t110 VDD_B.t48 40.5835127895311
Riso1787 VDD_B.t110 VDD_B.t49 65.0420364872093
Riso1788 VDD_B.t110 VDD_B.t50 139.767452979804
Riso1789 VDD_B.t110 VDD_B.t51 388.821234441287
Riso1790 VDD_B.t110 VDD_B.t52 65.0420364872093
Riso1791 VDD_B.t110 VDD_B.t53 104.719655127377
Riso1792 VDD_B.t110 VDD_B.t55 2820.21569597943
Riso1793 VDD_B.t110 VDD_B.t56 57.3081010506099
Riso1794 VDD_B.t110 VDD_B.t57 0.0669628029220334
Riso1795 VDD_B.t110 VDD_B.t58 118505.143766734
Riso1796 VDD_B.t110 VDD_B.t59 681.305120325379
Riso1797 VDD_B.t110 VDD_B.t6 2109.07322322493
Riso1798 VDD_B.t110 VDD_B.t60 341.260689685434
Riso1799 VDD_B.t110 VDD_B.t61 207.351631817083
Riso1800 VDD_B.t110 VDD_B.t62 358.451346833996
Riso1801 VDD_B.t110 VDD_B.t63 92.5097092801871
Riso1802 VDD_B.t110 VDD_B.t64 93.05361734914
Riso1803 VDD_B.t110 VDD_B.t66 1927.20330461878
Riso1804 VDD_B.t110 VDD_B.t67 467.825231444376
Riso1805 VDD_B.t110 VDD_B.t68 459.386310049506
Riso1806 VDD_B.t110 VDD_B.t69 326.863238510299
Riso1807 VDD_B.t110 VDD_B.t70 123.084447404108
Riso1808 VDD_B.t110 VDD_B.t71 25417.6933158106
Riso1809 VDD_B.t110 VDD_B.t73 1446.88762081331
Riso1810 VDD_B.t110 VDD_B.t75 1927.20330461878
Riso1811 VDD_B.t110 VDD_B.t76 204.066265477054
Riso1812 VDD_B.t110 VDD_B.t77 121.36883749847
Riso1813 VDD_B.t110 VDD_B.t78 139.767452979804
Riso1814 VDD_B.t110 VDD_B.t79 310.975042715586
Riso1815 VDD_B.t110 VDD_B.t8 2654.79584131428
Riso1816 VDD_B.t110 VDD_B.t80 40.5835127895311
Riso1817 VDD_B.t110 VDD_B.t81 64658.091328026
Riso1818 VDD_B.t110 VDD_B.t82 9961.64488290054
Riso1819 VDD_B.t110 VDD_B.t83 398.708258118159
Riso1820 VDD_B.t110 VDD_B.t85 3169.80427257127
Riso1821 VDD_B.t110 VDD_B.t86 159.832418010433
Riso1822 VDD_B.t110 VDD_B.t87 416.533006028838
Riso1823 VDD_B.t110 VDD_B.t88 121.36883749847
Riso1824 VDD_B.t110 VDD_B.t89 67.6116675155874
Riso1825 VDD_B.t110 VDD_B.t9 76.6283258798225
Riso1826 VDD_B.t110 VDD_B.t90 358.451346833996
Riso1827 VDD_B.t110 VDD_B.t91 107.131630596703
Riso1828 VDD_B.t110 VDD_B.t92 89.8237517697841
Riso1829 VDD_B.t110 VDD_B.t94 3248.87048401795
Riso1830 VDD_B.t110 VDD_B.t95 28.119594706761
Riso1831 VDD_B.t110 VDD_B.t96 13370.5535264607
Riso1832 VDD_B.t110 VDD_B.t97 19192.93454546
Riso1833 VDD_B.t110 VDD_B.t99 3248.87048401795
Riso1834 VDD_B.t111 VDD_B.t112 54.1588199415015
Riso1835 VDD_B.t111 VDD_B.t114 2434.19636195603
Riso1836 VDD_B.t111 VDD_B.t115 538.531083339674
Riso1837 VDD_B.t111 VDD_B.t116 233.578271805828
Riso1838 VDD_B.t111 VDD_B.t117 105.20099522932
Riso1839 VDD_B.t111 VDD_B.t118 79.7777098963471
Riso1840 VDD_B.t111 VDD_B.t119 207.563921413136
Riso1841 VDD_B.t111 VDD_B.t120 560.17926434636
Riso1842 VDD_B.t111 VDD_B.t122 2434.19636195603
Riso1843 VDD_B.t111 VDD_B.t123 281.422346764431
Riso1844 VDD_B.t111 VDD_B.t124 92.325551190587
Riso1845 VDD_B.t111 VDD_B.t125 28069.0625886836
Riso1846 VDD_B.t111 VDD_B.t126 149.329421833191
Riso1847 VDD_B.t111 VDD_B.t127 203993.155889391
Riso1848 VDD_B.t111 VDD_B.t128 1148.50294929869
Riso1849 VDD_B.t111 VDD_B.t13 2218.82521851524
Riso1850 VDD_B.t111 VDD_B.t130 2000.92229739554
Riso1851 VDD_B.t111 VDD_B.t132 2000.92229739554
Riso1852 VDD_B.t111 VDD_B.t134 1737.49472108486
Riso1853 VDD_B.t111 VDD_B.t135 41.4458598043465
Riso1854 VDD_B.t111 VDD_B.t136 359.753408714003
Riso1855 VDD_B.t111 VDD_B.t137 359.753408714003
Riso1856 VDD_B.t111 VDD_B.t139 2571.80618795833
Riso1857 VDD_B.t111 VDD_B.t140 424.713903504756
Riso1858 VDD_B.t111 VDD_B.t141 210.023041959906
Riso1859 VDD_B.t111 VDD_B.t143 2717.15449430018
Riso1860 VDD_B.t111 VDD_B.t144 516.52895645885
Riso1861 VDD_B.t111 VDD_B.t145 561.384012915692
Riso1862 VDD_B.t111 VDD_B.t147 2218.82521851524
Riso1863 VDD_B.t111 VDD_B.t149 2571.80618795833
Riso1864 VDD_B.t111 VDD_B.t15 928.886821693964
Riso1865 VDD_B.t111 VDD_B.t150 553.8853517228
Riso1866 VDD_B.t111 VDD_B.t151 49.2449176195882
Riso1867 VDD_B.t111 VDD_B.t152 41574.339422663
Riso1868 VDD_B.t111 VDD_B.t153 122.250739801903
Riso1869 VDD_B.t111 VDD_B.t154 58.2036758327039
Riso1870 VDD_B.t111 VDD_B.t17 1737.49472108486
Riso1871 VDD_B.t111 VDD_B.t18 28.7896698323926
Riso1872 VDD_B.t111 VDD_B.t2 2300.55329394035
Riso1873 VDD_B.t111 VDD_B.t20 1738.92054784117
Riso1874 VDD_B.t111 VDD_B.t22 2351.59577303427
Riso1875 VDD_B.t111 VDD_B.t23 58.2036758327039
Riso1876 VDD_B.t111 VDD_B.t24 54435.4826241731
Riso1877 VDD_B.t111 VDD_B.t25 2544.90505741211
Riso1878 VDD_B.t111 VDD_B.t26 233.578271805828
Riso1879 VDD_B.t111 VDD_B.t27 236.339169164131
Riso1880 VDD_B.t111 VDD_B.t28 489.278731298717
Riso1881 VDD_B.t111 VDD_B.t3 100009.506364168
Riso1882 VDD_B.t111 VDD_B.t30 1738.92054784117
Riso1883 VDD_B.t111 VDD_B.t31 314.251227821598
Riso1884 VDD_B.t111 VDD_B.t32 23187.3245306099
Riso1885 VDD_B.t111 VDD_B.t33 260.555640068099
Riso1886 VDD_B.t111 VDD_B.t34 160.218825958488
Riso1887 VDD_B.t111 VDD_B.t35 38771.0707928757
Riso1888 VDD_B.t111 VDD_B.t36 40918.659464707
Riso1889 VDD_B.t111 VDD_B.t37 181.669474586233
Riso1890 VDD_B.t111 VDD_B.t38 236.339169164131
Riso1891 VDD_B.t111 VDD_B.t39 389.96971543242
Riso1892 VDD_B.t111 VDD_B.t4 2544.90505741211
Riso1893 VDD_B.t111 VDD_B.t41 1266.93342377786
Riso1894 VDD_B.t111 VDD_B.t42 68.3792305774904
Riso1895 VDD_B.t111 VDD_B.t43 207.563921413136
Riso1896 VDD_B.t111 VDD_B.t44 53329.0822323198
Riso1897 VDD_B.t111 VDD_B.t45 156553.428703208
Riso1898 VDD_B.t111 VDD_B.t46 560.17926434636
Riso1899 VDD_B.t111 VDD_B.t47 458.219770125129
Riso1900 VDD_B.t111 VDD_B.t48 41.1267560623616
Riso1901 VDD_B.t111 VDD_B.t49 90.0552070357102
Riso1902 VDD_B.t111 VDD_B.t50 185.254398587144
Riso1903 VDD_B.t111 VDD_B.t51 314.251227821598
Riso1904 VDD_B.t111 VDD_B.t52 90.0552070357102
Riso1905 VDD_B.t111 VDD_B.t53 141.274193231314
Riso1906 VDD_B.t111 VDD_B.t55 2351.59577303427
Riso1907 VDD_B.t111 VDD_B.t56 41.4458598043465
Riso1908 VDD_B.t111 VDD_B.t57 48.3346565738348
Riso1909 VDD_B.t111 VDD_B.t58 103910.557769753
Riso1910 VDD_B.t111 VDD_B.t59 597.263428786214
Riso1911 VDD_B.t111 VDD_B.t6 1776.73201368253
Riso1912 VDD_B.t111 VDD_B.t60 424.713903504756
Riso1913 VDD_B.t111 VDD_B.t61 160.218825958488
Riso1914 VDD_B.t111 VDD_B.t62 287.774016990459
Riso1915 VDD_B.t111 VDD_B.t63 68.3792305774904
Riso1916 VDD_B.t111 VDD_B.t64 71.318151563764
Riso1917 VDD_B.t111 VDD_B.t66 1628.82652426141
Riso1918 VDD_B.t111 VDD_B.t67 561.384012915692
Riso1919 VDD_B.t111 VDD_B.t68 553.8853517228
Riso1920 VDD_B.t111 VDD_B.t69 260.555640068099
Riso1921 VDD_B.t111 VDD_B.t70 92.325551190587
Riso1922 VDD_B.t111 VDD_B.t71 22187.135112305
Riso1923 VDD_B.t111 VDD_B.t73 1266.93342377786
Riso1924 VDD_B.t111 VDD_B.t75 1628.82652426141
Riso1925 VDD_B.t111 VDD_B.t76 263.79600539143
Riso1926 VDD_B.t111 VDD_B.t77 162.29151905161
Riso1927 VDD_B.t111 VDD_B.t78 185.254398587144
Riso1928 VDD_B.t111 VDD_B.t79 389.96971543242
Riso1929 VDD_B.t111 VDD_B.t8 2300.55329394035
Riso1930 VDD_B.t111 VDD_B.t80 41.1267560623616
Riso1931 VDD_B.t111 VDD_B.t81 56440.1258042686
Riso1932 VDD_B.t111 VDD_B.t82 8695.53181760339
Riso1933 VDD_B.t111 VDD_B.t83 489.278731298717
Riso1934 VDD_B.t111 VDD_B.t85 2717.15449430018
Riso1935 VDD_B.t111 VDD_B.t86 210.023041959906
Riso1936 VDD_B.t111 VDD_B.t87 338.737166292046
Riso1937 VDD_B.t111 VDD_B.t88 162.29151905161
Riso1938 VDD_B.t111 VDD_B.t89 49.2449176195882
Riso1939 VDD_B.t111 VDD_B.t9 105.20099522932
Riso1940 VDD_B.t111 VDD_B.t90 287.774016990459
Riso1941 VDD_B.t111 VDD_B.t91 79.7777098963471
Riso1942 VDD_B.t111 VDD_B.t92 122.250739801903
Riso1943 VDD_B.t111 VDD_B.t94 2748.57674434576
Riso1944 VDD_B.t111 VDD_B.t95 39.2550665952779
Riso1945 VDD_B.t111 VDD_B.t96 11671.1722787748
Riso1946 VDD_B.t111 VDD_B.t97 16753.5356836202
Riso1947 VDD_B.t111 VDD_B.t99 2748.57674434576
Riso1948 VDD_B.t112 VDD_B.t114 578.658260545001
Riso1949 VDD_B.t112 VDD_B.t115 480.848302599957
Riso1950 VDD_B.t112 VDD_B.t116 44.3391117069588
Riso1951 VDD_B.t112 VDD_B.t117 136.665491780237
Riso1952 VDD_B.t112 VDD_B.t118 24.1325054014622
Riso1953 VDD_B.t112 VDD_B.t119 38.2080834153085
Riso1954 VDD_B.t112 VDD_B.t120 476.332614587025
Riso1955 VDD_B.t112 VDD_B.t122 578.658260545001
Riso1956 VDD_B.t112 VDD_B.t123 236.150906026753
Riso1957 VDD_B.t112 VDD_B.t124 20.2409091117935
Riso1958 VDD_B.t112 VDD_B.t125 7846.08770737965
Riso1959 VDD_B.t112 VDD_B.t126 157.717186467308
Riso1960 VDD_B.t112 VDD_B.t127 56806.6242700963
Riso1961 VDD_B.t112 VDD_B.t128 315.577791977466
Riso1962 VDD_B.t112 VDD_B.t13 562.495158663652
Riso1963 VDD_B.t112 VDD_B.t130 537.348051175802
Riso1964 VDD_B.t112 VDD_B.t132 537.348051175802
Riso1965 VDD_B.t112 VDD_B.t134 458.157055429311
Riso1966 VDD_B.t112 VDD_B.t135 46.580694323059
Riso1967 VDD_B.t112 VDD_B.t136 78.5495186866152
Riso1968 VDD_B.t112 VDD_B.t137 78.5495186866152
Riso1969 VDD_B.t112 VDD_B.t139 633.582553931597
Riso1970 VDD_B.t112 VDD_B.t140 410.774357411012
Riso1971 VDD_B.t112 VDD_B.t141 237.772114071658
Riso1972 VDD_B.t112 VDD_B.t143 729.733843024351
Riso1973 VDD_B.t112 VDD_B.t144 469.902928591919
Riso1974 VDD_B.t112 VDD_B.t145 484.51821439977
Riso1975 VDD_B.t112 VDD_B.t147 562.495158663652
Riso1976 VDD_B.t112 VDD_B.t149 633.582553931597
Riso1977 VDD_B.t112 VDD_B.t15 241.652799844197
Riso1978 VDD_B.t112 VDD_B.t150 485.925550014142
Riso1979 VDD_B.t112 VDD_B.t151 39.8239323816012
Riso1980 VDD_B.t112 VDD_B.t152 11621.1901432752
Riso1981 VDD_B.t112 VDD_B.t153 154.317030661511
Riso1982 VDD_B.t112 VDD_B.t154 33.8629832281758
Riso1983 VDD_B.t112 VDD_B.t17 458.157055429311
Riso1984 VDD_B.t112 VDD_B.t18 41.7092862296863
Riso1985 VDD_B.t112 VDD_B.t2 657.081625548985
Riso1986 VDD_B.t112 VDD_B.t20 517.707070344409
Riso1987 VDD_B.t112 VDD_B.t22 551.576080830561
Riso1988 VDD_B.t112 VDD_B.t23 33.8629832281758
Riso1989 VDD_B.t112 VDD_B.t24 12962.9962703511
Riso1990 VDD_B.t112 VDD_B.t25 607.300690375895
Riso1991 VDD_B.t112 VDD_B.t26 44.3391117069588
Riso1992 VDD_B.t112 VDD_B.t27 261.041150229376
Riso1993 VDD_B.t112 VDD_B.t28 453.930474030472
Riso1994 VDD_B.t112 VDD_B.t3 23815.7686035225
Riso1995 VDD_B.t112 VDD_B.t30 517.707070344409
Riso1996 VDD_B.t112 VDD_B.t31 65.1937999675329
Riso1997 VDD_B.t112 VDD_B.t32 6481.50544364772
Riso1998 VDD_B.t112 VDD_B.t33 50.9903962928721
Riso1999 VDD_B.t112 VDD_B.t34 27.7491974945901
Riso2000 VDD_B.t112 VDD_B.t35 10837.5981915609
Riso2001 VDD_B.t112 VDD_B.t36 11437.9092644842
Riso2002 VDD_B.t112 VDD_B.t37 183.699678598096
Riso2003 VDD_B.t112 VDD_B.t38 261.041150229376
Riso2004 VDD_B.t112 VDD_B.t39 385.5187639277
Riso2005 VDD_B.t112 VDD_B.t4 607.300690375895
Riso2006 VDD_B.t112 VDD_B.t41 385.547362359505
Riso2007 VDD_B.t112 VDD_B.t42 28.6518522108665
Riso2008 VDD_B.t112 VDD_B.t43 38.2080834153085
Riso2009 VDD_B.t112 VDD_B.t44 14906.9693805
Riso2010 VDD_B.t112 VDD_B.t45 43761.0600145796
Riso2011 VDD_B.t112 VDD_B.t46 476.332614587025
Riso2012 VDD_B.t112 VDD_B.t47 433.891897133333
Riso2013 VDD_B.t112 VDD_B.t48 62.5519983806942
Riso2014 VDD_B.t112 VDD_B.t49 120.424977708007
Riso2015 VDD_B.t112 VDD_B.t50 215.234465430468
Riso2016 VDD_B.t112 VDD_B.t51 65.1937999675329
Riso2017 VDD_B.t112 VDD_B.t52 120.424977708007
Riso2018 VDD_B.t112 VDD_B.t53 173.351152878462
Riso2019 VDD_B.t112 VDD_B.t55 551.576080830561
Riso2020 VDD_B.t112 VDD_B.t56 46.580694323059
Riso2021 VDD_B.t112 VDD_B.t57 71.7070414986966
Riso2022 VDD_B.t112 VDD_B.t58 31902.9992511199
Riso2023 VDD_B.t112 VDD_B.t59 183.104884816638
Riso2024 VDD_B.t112 VDD_B.t6 458.666404277629
Riso2025 VDD_B.t112 VDD_B.t60 410.774357411012
Riso2026 VDD_B.t112 VDD_B.t61 27.7491974945901
Riso2027 VDD_B.t112 VDD_B.t62 58.0190745092252
Riso2028 VDD_B.t112 VDD_B.t63 28.6518522108665
Riso2029 VDD_B.t112 VDD_B.t64 11.9910516883134
Riso2030 VDD_B.t112 VDD_B.t66 425.841521294713
Riso2031 VDD_B.t112 VDD_B.t67 484.51821439977
Riso2032 VDD_B.t112 VDD_B.t68 485.925550014142
Riso2033 VDD_B.t112 VDD_B.t69 50.9903962928721
Riso2034 VDD_B.t112 VDD_B.t70 20.2409091117935
Riso2035 VDD_B.t112 VDD_B.t71 6201.92453939703
Riso2036 VDD_B.t112 VDD_B.t73 385.547362359505
Riso2037 VDD_B.t112 VDD_B.t75 425.841521294713
Riso2038 VDD_B.t112 VDD_B.t76 284.675543330612
Riso2039 VDD_B.t112 VDD_B.t77 193.697883054296
Riso2040 VDD_B.t112 VDD_B.t78 215.234465430468
Riso2041 VDD_B.t112 VDD_B.t79 385.5187639277
Riso2042 VDD_B.t112 VDD_B.t8 657.081625548985
Riso2043 VDD_B.t112 VDD_B.t80 62.5519983806942
Riso2044 VDD_B.t112 VDD_B.t81 15776.5930328706
Riso2045 VDD_B.t112 VDD_B.t82 2430.64423999441
Riso2046 VDD_B.t112 VDD_B.t83 453.930474030472
Riso2047 VDD_B.t112 VDD_B.t85 729.733843024351
Riso2048 VDD_B.t112 VDD_B.t86 237.772114071658
Riso2049 VDD_B.t112 VDD_B.t87 72.1815712993305
Riso2050 VDD_B.t112 VDD_B.t88 193.697883054296
Riso2051 VDD_B.t112 VDD_B.t89 39.8239323816012
Riso2052 VDD_B.t112 VDD_B.t9 136.665491780237
Riso2053 VDD_B.t112 VDD_B.t90 58.0190745092252
Riso2054 VDD_B.t112 VDD_B.t91 24.1325054014622
Riso2055 VDD_B.t112 VDD_B.t92 154.317030661511
Riso2056 VDD_B.t112 VDD_B.t94 689.021505593813
Riso2057 VDD_B.t112 VDD_B.t95 54.0353060756921
Riso2058 VDD_B.t112 VDD_B.t96 3262.41893750041
Riso2059 VDD_B.t112 VDD_B.t97 4683.08159444533
Riso2060 VDD_B.t112 VDD_B.t99 689.021505593813
Riso2061 VDD_B.t113 VDD_B.t121 158.648
Riso2062 VDD_B.t113 VDD_B.t93 158.648
Riso2063 VDD_B.t114 VDD_B.t115 6465.93270674221
Riso2064 VDD_B.t114 VDD_B.t116 522.99263293282
Riso2065 VDD_B.t114 VDD_B.t117 4343.58558864812
Riso2066 VDD_B.t114 VDD_B.t118 1439.59620419716
Riso2067 VDD_B.t114 VDD_B.t119 603.160138257991
Riso2068 VDD_B.t114 VDD_B.t120 5443.92124231084
Riso2069 VDD_B.t114 VDD_B.t122 0.825864407743075
Riso2070 VDD_B.t114 VDD_B.t123 2577.45089517487
Riso2071 VDD_B.t114 VDD_B.t124 1278.78097287732
Riso2072 VDD_B.t114 VDD_B.t125 7852.84785424367
Riso2073 VDD_B.t114 VDD_B.t126 3373.67932219177
Riso2074 VDD_B.t114 VDD_B.t127 92369.5550472499
Riso2075 VDD_B.t114 VDD_B.t128 513.942147553343
Riso2076 VDD_B.t114 VDD_B.t13 200.871241587671
Riso2077 VDD_B.t114 VDD_B.t130 825.82858117857
Riso2078 VDD_B.t114 VDD_B.t132 825.82858117857
Riso2079 VDD_B.t114 VDD_B.t134 668.568508992471
Riso2080 VDD_B.t114 VDD_B.t135 2211.13601833249
Riso2081 VDD_B.t114 VDD_B.t136 235.661608530512
Riso2082 VDD_B.t114 VDD_B.t137 235.661608530512
Riso2083 VDD_B.t114 VDD_B.t139 129.103960831441
Riso2084 VDD_B.t114 VDD_B.t140 7022.91241839962
Riso2085 VDD_B.t114 VDD_B.t141 5905.83215459876
Riso2086 VDD_B.t114 VDD_B.t143 75.7721723274013
Riso2087 VDD_B.t114 VDD_B.t144 6705.147159617
Riso2088 VDD_B.t114 VDD_B.t145 5825.36535781457
Riso2089 VDD_B.t114 VDD_B.t147 200.871241587671
Riso2090 VDD_B.t114 VDD_B.t149 129.103960831441
Riso2091 VDD_B.t114 VDD_B.t15 253.856565663084
Riso2092 VDD_B.t114 VDD_B.t150 6169.59843290312
Riso2093 VDD_B.t114 VDD_B.t151 1999.48333854118
Riso2094 VDD_B.t114 VDD_B.t152 11631.2028980434
Riso2095 VDD_B.t114 VDD_B.t153 4666.1921528166
Riso2096 VDD_B.t114 VDD_B.t154 1800.06385569784
Riso2097 VDD_B.t114 VDD_B.t17 668.568508992471
Riso2098 VDD_B.t114 VDD_B.t18 1615.2112828857
Riso2099 VDD_B.t114 VDD_B.t2 113.756550274744
Riso2100 VDD_B.t114 VDD_B.t20 170.203019642591
Riso2101 VDD_B.t114 VDD_B.t22 54.8340703076816
Riso2102 VDD_B.t114 VDD_B.t23 1800.06385569784
Riso2103 VDD_B.t114 VDD_B.t24 1766.86213184829
Riso2104 VDD_B.t114 VDD_B.t25 84.5510398618789
Riso2105 VDD_B.t114 VDD_B.t26 522.99263293282
Riso2106 VDD_B.t114 VDD_B.t27 6170.94042940996
Riso2107 VDD_B.t114 VDD_B.t28 6880.17138240372
Riso2108 VDD_B.t114 VDD_B.t3 3246.09980662175
Riso2109 VDD_B.t114 VDD_B.t30 170.203019642591
Riso2110 VDD_B.t114 VDD_B.t31 329.170334212533
Riso2111 VDD_B.t114 VDD_B.t32 6487.08987379089
Riso2112 VDD_B.t114 VDD_B.t33 450.704696402669
Riso2113 VDD_B.t114 VDD_B.t34 785.883852717378
Riso2114 VDD_B.t114 VDD_B.t35 10846.9358077284
Riso2115 VDD_B.t114 VDD_B.t36 11447.7641054354
Riso2116 VDD_B.t114 VDD_B.t37 3527.63842289961
Riso2117 VDD_B.t114 VDD_B.t38 6170.94042940996
Riso2118 VDD_B.t114 VDD_B.t39 6990.52677452005
Riso2119 VDD_B.t114 VDD_B.t4 84.5510398618789
Riso2120 VDD_B.t114 VDD_B.t41 248.678789179025
Riso2121 VDD_B.t114 VDD_B.t42 1613.36174346033
Riso2122 VDD_B.t114 VDD_B.t43 603.160138257991
Riso2123 VDD_B.t114 VDD_B.t44 14919.8131449426
Riso2124 VDD_B.t114 VDD_B.t45 43798.7643079366
Riso2125 VDD_B.t114 VDD_B.t46 5443.92124231084
Riso2126 VDD_B.t114 VDD_B.t47 6986.59240490015
Riso2127 VDD_B.t114 VDD_B.t48 2667.40244007403
Riso2128 VDD_B.t114 VDD_B.t49 4025.55284159813
Riso2129 VDD_B.t114 VDD_B.t50 5615.52177489692
Riso2130 VDD_B.t114 VDD_B.t51 329.170334212533
Riso2131 VDD_B.t114 VDD_B.t52 4025.55284159813
Riso2132 VDD_B.t114 VDD_B.t53 4989.24471878795
Riso2133 VDD_B.t114 VDD_B.t55 54.8340703076816
Riso2134 VDD_B.t114 VDD_B.t56 2211.13601833249
Riso2135 VDD_B.t114 VDD_B.t57 2908.94194306815
Riso2136 VDD_B.t114 VDD_B.t58 34715.0064753531
Riso2137 VDD_B.t114 VDD_B.t59 176.138804546583
Riso2138 VDD_B.t114 VDD_B.t6 317.301611571871
Riso2139 VDD_B.t114 VDD_B.t60 7022.91241839962
Riso2140 VDD_B.t114 VDD_B.t61 785.883852717378
Riso2141 VDD_B.t114 VDD_B.t62 386.199774775053
Riso2142 VDD_B.t114 VDD_B.t63 1613.36174346033
Riso2143 VDD_B.t114 VDD_B.t64 453.714516711203
Riso2144 VDD_B.t114 VDD_B.t66 549.583995360986
Riso2145 VDD_B.t114 VDD_B.t67 5825.36535781457
Riso2146 VDD_B.t114 VDD_B.t68 6169.59843290312
Riso2147 VDD_B.t114 VDD_B.t69 450.704696402669
Riso2148 VDD_B.t114 VDD_B.t70 1278.78097287732
Riso2149 VDD_B.t114 VDD_B.t71 6207.26808414054
Riso2150 VDD_B.t114 VDD_B.t73 248.678789179025
Riso2151 VDD_B.t114 VDD_B.t75 549.583995360986
Riso2152 VDD_B.t114 VDD_B.t76 6402.6436436184
Riso2153 VDD_B.t114 VDD_B.t77 5307.68930190398
Riso2154 VDD_B.t114 VDD_B.t78 5615.52177489692
Riso2155 VDD_B.t114 VDD_B.t79 6990.52677452005
Riso2156 VDD_B.t114 VDD_B.t8 113.756550274744
Riso2157 VDD_B.t114 VDD_B.t80 2667.40244007403
Riso2158 VDD_B.t114 VDD_B.t81 15790.1860603632
Riso2159 VDD_B.t114 VDD_B.t82 2432.73846996601
Riso2160 VDD_B.t114 VDD_B.t83 6880.17138240372
Riso2161 VDD_B.t114 VDD_B.t85 75.7721723274013
Riso2162 VDD_B.t114 VDD_B.t86 5905.83215459876
Riso2163 VDD_B.t114 VDD_B.t87 279.168837973868
Riso2164 VDD_B.t114 VDD_B.t88 5307.68930190398
Riso2165 VDD_B.t114 VDD_B.t89 1999.48333854118
Riso2166 VDD_B.t114 VDD_B.t9 4343.58558864812
Riso2167 VDD_B.t114 VDD_B.t90 386.199774775053
Riso2168 VDD_B.t114 VDD_B.t91 1439.59620419716
Riso2169 VDD_B.t114 VDD_B.t92 4666.1921528166
Riso2170 VDD_B.t114 VDD_B.t94 50.3950237040206
Riso2171 VDD_B.t114 VDD_B.t95 1901.29546505402
Riso2172 VDD_B.t114 VDD_B.t96 3265.2298200666
Riso2173 VDD_B.t114 VDD_B.t97 4687.1165122968
Riso2174 VDD_B.t114 VDD_B.t99 50.3950237040206
Riso2175 VDD_B.t115 VDD_B.t116 1300.41585111879
Riso2176 VDD_B.t115 VDD_B.t117 268.219148433972
Riso2177 VDD_B.t115 VDD_B.t118 819.103581178592
Riso2178 VDD_B.t115 VDD_B.t119 1252.15683408358
Riso2179 VDD_B.t115 VDD_B.t120 38.9101946685691
Riso2180 VDD_B.t115 VDD_B.t122 6465.93270674221
Riso2181 VDD_B.t115 VDD_B.t123 20.7365962304243
Riso2182 VDD_B.t115 VDD_B.t124 879.594815763515
Riso2183 VDD_B.t115 VDD_B.t125 27265.758066741
Riso2184 VDD_B.t115 VDD_B.t126 50.1942747907588
Riso2185 VDD_B.t115 VDD_B.t127 159625.603457743
Riso2186 VDD_B.t115 VDD_B.t128 1035.00203096386
Riso2187 VDD_B.t115 VDD_B.t13 5252.33008604362
Riso2188 VDD_B.t115 VDD_B.t130 2433.19257124787
Riso2189 VDD_B.t115 VDD_B.t132 2433.19257124787
Riso2190 VDD_B.t115 VDD_B.t134 2947.82332953378
Riso2191 VDD_B.t115 VDD_B.t135 589.988964430952
Riso2192 VDD_B.t115 VDD_B.t136 1343.19371285315
Riso2193 VDD_B.t115 VDD_B.t137 1343.19371285315
Riso2194 VDD_B.t115 VDD_B.t139 6331.83419939879
Riso2195 VDD_B.t115 VDD_B.t140 56.1529915436498
Riso2196 VDD_B.t115 VDD_B.t141 148.054341589368
Riso2197 VDD_B.t115 VDD_B.t143 6682.37956405113
Riso2198 VDD_B.t115 VDD_B.t144 34.8785525112217
Riso2199 VDD_B.t115 VDD_B.t145 36.3214211445903
Riso2200 VDD_B.t115 VDD_B.t147 5252.33008604362
Riso2201 VDD_B.t115 VDD_B.t149 6331.83419939879
Riso2202 VDD_B.t115 VDD_B.t15 2042.16138747408
Riso2203 VDD_B.t115 VDD_B.t150 33.0546148645204
Riso2204 VDD_B.t115 VDD_B.t151 644.131059187578
Riso2205 VDD_B.t115 VDD_B.t152 40384.5292981002
Riso2206 VDD_B.t115 VDD_B.t153 240.441390890883
Riso2207 VDD_B.t115 VDD_B.t154 700.674687566599
Riso2208 VDD_B.t115 VDD_B.t17 2947.82332953378
Riso2209 VDD_B.t115 VDD_B.t18 205.498616214681
Riso2210 VDD_B.t115 VDD_B.t2 5469.8640141262
Riso2211 VDD_B.t115 VDD_B.t20 4048.43778451937
Riso2212 VDD_B.t115 VDD_B.t22 6264.24986392129
Riso2213 VDD_B.t115 VDD_B.t23 700.674687566599
Riso2214 VDD_B.t115 VDD_B.t24 140865.913154152
Riso2215 VDD_B.t115 VDD_B.t25 6567.43030498894
Riso2216 VDD_B.t115 VDD_B.t26 1300.41585111879
Riso2217 VDD_B.t115 VDD_B.t27 129.652903030868
Riso2218 VDD_B.t115 VDD_B.t28 41.1266460139111
Riso2219 VDD_B.t115 VDD_B.t3 258800.505827215
Riso2220 VDD_B.t115 VDD_B.t30 4048.43778451937
Riso2221 VDD_B.t115 VDD_B.t31 1373.25633565876
Riso2222 VDD_B.t115 VDD_B.t32 22523.7297779053
Riso2223 VDD_B.t115 VDD_B.t33 1338.2065606042
Riso2224 VDD_B.t115 VDD_B.t34 1133.71674438197
Riso2225 VDD_B.t115 VDD_B.t35 37661.4870157163
Riso2226 VDD_B.t115 VDD_B.t36 39747.6141518834
Riso2227 VDD_B.t115 VDD_B.t37 38.0600910885906
Riso2228 VDD_B.t115 VDD_B.t38 129.652903030868
Riso2229 VDD_B.t115 VDD_B.t39 64.9079674196179
Riso2230 VDD_B.t115 VDD_B.t4 6567.43030498894
Riso2231 VDD_B.t115 VDD_B.t41 2918.49092258635
Riso2232 VDD_B.t115 VDD_B.t42 759.197091519178
Riso2233 VDD_B.t115 VDD_B.t43 1252.15683408358
Riso2234 VDD_B.t115 VDD_B.t44 51802.8647901475
Riso2235 VDD_B.t115 VDD_B.t45 152073.048326928
Riso2236 VDD_B.t115 VDD_B.t46 38.9101946685691
Riso2237 VDD_B.t115 VDD_B.t47 48.2141135044291
Riso2238 VDD_B.t115 VDD_B.t48 489.928986636548
Riso2239 VDD_B.t115 VDD_B.t49 297.682456915047
Riso2240 VDD_B.t115 VDD_B.t50 168.299407601315
Riso2241 VDD_B.t115 VDD_B.t51 1373.25633565876
Riso2242 VDD_B.t115 VDD_B.t52 297.682456915047
Riso2243 VDD_B.t115 VDD_B.t53 214.490858949063
Riso2244 VDD_B.t115 VDD_B.t55 6264.24986392129
Riso2245 VDD_B.t115 VDD_B.t56 589.988964430952
Riso2246 VDD_B.t115 VDD_B.t57 444.268266799069
Riso2247 VDD_B.t115 VDD_B.t58 238358.014577272
Riso2248 VDD_B.t115 VDD_B.t59 1371.04327315417
Riso2249 VDD_B.t115 VDD_B.t6 4087.941074462
Riso2250 VDD_B.t115 VDD_B.t60 56.1529915436498
Riso2251 VDD_B.t115 VDD_B.t61 1133.71674438197
Riso2252 VDD_B.t115 VDD_B.t62 1363.18033209605
Riso2253 VDD_B.t115 VDD_B.t63 759.197091519178
Riso2254 VDD_B.t115 VDD_B.t64 546.473545419999
Riso2255 VDD_B.t115 VDD_B.t66 3317.26879251307
Riso2256 VDD_B.t115 VDD_B.t67 36.3214211445903
Riso2257 VDD_B.t115 VDD_B.t68 33.0546148645204
Riso2258 VDD_B.t115 VDD_B.t69 1338.2065606042
Riso2259 VDD_B.t115 VDD_B.t70 879.594815763515
Riso2260 VDD_B.t115 VDD_B.t71 21552.1646387327
Riso2261 VDD_B.t115 VDD_B.t73 2918.49092258635
Riso2262 VDD_B.t115 VDD_B.t75 3317.26879251307
Riso2263 VDD_B.t115 VDD_B.t76 113.024992184948
Riso2264 VDD_B.t115 VDD_B.t77 190.437762542689
Riso2265 VDD_B.t115 VDD_B.t78 168.299407601315
Riso2266 VDD_B.t115 VDD_B.t79 64.9079674196179
Riso2267 VDD_B.t115 VDD_B.t8 5469.8640141262
Riso2268 VDD_B.t115 VDD_B.t80 489.928986636548
Riso2269 VDD_B.t115 VDD_B.t81 54824.8738472667
Riso2270 VDD_B.t115 VDD_B.t82 8446.67562556963
Riso2271 VDD_B.t115 VDD_B.t83 41.1266460139111
Riso2272 VDD_B.t115 VDD_B.t85 6682.37956405113
Riso2273 VDD_B.t115 VDD_B.t86 148.054341589368
Riso2274 VDD_B.t115 VDD_B.t87 1366.86682360743
Riso2275 VDD_B.t115 VDD_B.t88 190.437762542689
Riso2276 VDD_B.t115 VDD_B.t89 644.131059187578
Riso2277 VDD_B.t115 VDD_B.t9 268.219148433972
Riso2278 VDD_B.t115 VDD_B.t90 1363.18033209605
Riso2279 VDD_B.t115 VDD_B.t91 819.103581178592
Riso2280 VDD_B.t115 VDD_B.t92 240.441390890883
Riso2281 VDD_B.t115 VDD_B.t94 7049.04827981158
Riso2282 VDD_B.t115 VDD_B.t95 168.154494069416
Riso2283 VDD_B.t115 VDD_B.t96 11337.1566543382
Riso2284 VDD_B.t115 VDD_B.t97 16274.0686215956
Riso2285 VDD_B.t115 VDD_B.t99 7049.04827981158
Riso2286 VDD_B.t116 VDD_B.t117 504.679876698707
Riso2287 VDD_B.t116 VDD_B.t118 117.911430756381
Riso2288 VDD_B.t116 VDD_B.t119 39.9666675060675
Riso2289 VDD_B.t116 VDD_B.t120 1214.30158066139
Riso2290 VDD_B.t116 VDD_B.t122 522.99263293282
Riso2291 VDD_B.t116 VDD_B.t123 591.608651517063
Riso2292 VDD_B.t116 VDD_B.t124 101.310050512238
Riso2293 VDD_B.t116 VDD_B.t125 8470.76817056889
Riso2294 VDD_B.t116 VDD_B.t126 499.464787348945
Riso2295 VDD_B.t116 VDD_B.t127 61384.527119196
Riso2296 VDD_B.t116 VDD_B.t128 340.03045456973
Riso2297 VDD_B.t116 VDD_B.t13 569.552176679536
Riso2298 VDD_B.t116 VDD_B.t130 575.726322512865
Riso2299 VDD_B.t116 VDD_B.t132 575.726322512865
Riso2300 VDD_B.t116 VDD_B.t134 488.667717381578
Riso2301 VDD_B.t116 VDD_B.t135 205.913139082023
Riso2302 VDD_B.t116 VDD_B.t136 66.6723941743448
Riso2303 VDD_B.t116 VDD_B.t137 66.6723941743448
Riso2304 VDD_B.t116 VDD_B.t139 611.976281875173
Riso2305 VDD_B.t116 VDD_B.t140 1206.13781541047
Riso2306 VDD_B.t116 VDD_B.t141 794.085530059845
Riso2307 VDD_B.t116 VDD_B.t143 748.307968882745
Riso2308 VDD_B.t116 VDD_B.t144 1297.45238728643
Riso2309 VDD_B.t116 VDD_B.t145 1258.62195038939
Riso2310 VDD_B.t116 VDD_B.t147 569.552176679536
Riso2311 VDD_B.t116 VDD_B.t149 611.976281875173
Riso2312 VDD_B.t116 VDD_B.t15 255.58028994634
Riso2313 VDD_B.t116 VDD_B.t150 1287.54249265844
Riso2314 VDD_B.t116 VDD_B.t151 180.520421687464
Riso2315 VDD_B.t116 VDD_B.t152 12546.4322145158
Riso2316 VDD_B.t116 VDD_B.t153 557.758256205885
Riso2317 VDD_B.t116 VDD_B.t154 157.42144870003
Riso2318 VDD_B.t116 VDD_B.t17 488.667717381578
Riso2319 VDD_B.t116 VDD_B.t18 168.166411893166
Riso2320 VDD_B.t116 VDD_B.t2 728.12867679719
Riso2321 VDD_B.t116 VDD_B.t20 608.486907216966
Riso2322 VDD_B.t116 VDD_B.t22 494.195418979469
Riso2323 VDD_B.t116 VDD_B.t23 157.42144870003
Riso2324 VDD_B.t116 VDD_B.t24 11890.1607444859
Riso2325 VDD_B.t116 VDD_B.t25 558.796497242216
Riso2326 VDD_B.t116 VDD_B.t26 0.066961709663171
Riso2327 VDD_B.t116 VDD_B.t27 856.039443662533
Riso2328 VDD_B.t116 VDD_B.t28 1279.63022329726
Riso2329 VDD_B.t116 VDD_B.t3 21844.7426076201
Riso2330 VDD_B.t116 VDD_B.t30 608.486907216966
Riso2331 VDD_B.t116 VDD_B.t31 52.9846070083475
Riso2332 VDD_B.t116 VDD_B.t32 6997.54222193829
Riso2333 VDD_B.t116 VDD_B.t33 39.5838280750919
Riso2334 VDD_B.t116 VDD_B.t34 55.2010235358109
Riso2335 VDD_B.t116 VDD_B.t35 11700.4531723682
Riso2336 VDD_B.t116 VDD_B.t36 12348.5590970797
Riso2337 VDD_B.t116 VDD_B.t37 560.973117519277
Riso2338 VDD_B.t116 VDD_B.t38 856.039443662533
Riso2339 VDD_B.t116 VDD_B.t39 1154.63111927026
Riso2340 VDD_B.t116 VDD_B.t4 558.796497242216
Riso2341 VDD_B.t116 VDD_B.t41 468.657990415764
Riso2342 VDD_B.t116 VDD_B.t42 136.578525030784
Riso2343 VDD_B.t116 VDD_B.t43 39.9666675060675
Riso2344 VDD_B.t116 VDD_B.t44 16093.814708344
Riso2345 VDD_B.t116 VDD_B.t45 47245.1759535141
Riso2346 VDD_B.t116 VDD_B.t46 1214.30158066139
Riso2347 VDD_B.t116 VDD_B.t47 1248.53101019061
Riso2348 VDD_B.t116 VDD_B.t48 263.414040803762
Riso2349 VDD_B.t116 VDD_B.t49 454.685622005334
Riso2350 VDD_B.t116 VDD_B.t50 732.461150170541
Riso2351 VDD_B.t116 VDD_B.t51 52.9846070083475
Riso2352 VDD_B.t116 VDD_B.t52 454.685622005334
Riso2353 VDD_B.t116 VDD_B.t53 613.683441940686
Riso2354 VDD_B.t116 VDD_B.t55 494.195418979469
Riso2355 VDD_B.t116 VDD_B.t56 205.913139082023
Riso2356 VDD_B.t116 VDD_B.t57 295.21089921818
Riso2357 VDD_B.t116 VDD_B.t58 39334.0897052422
Riso2358 VDD_B.t116 VDD_B.t59 225.212948640209
Riso2359 VDD_B.t116 VDD_B.t6 479.317875969705
Riso2360 VDD_B.t116 VDD_B.t60 1206.13781541047
Riso2361 VDD_B.t116 VDD_B.t61 55.2010235358109
Riso2362 VDD_B.t116 VDD_B.t62 46.0837815558315
Riso2363 VDD_B.t116 VDD_B.t63 136.578525030784
Riso2364 VDD_B.t116 VDD_B.t64 32.7610914743486
Riso2365 VDD_B.t116 VDD_B.t66 452.541274015357
Riso2366 VDD_B.t116 VDD_B.t67 1258.62195038939
Riso2367 VDD_B.t116 VDD_B.t68 1287.54249265844
Riso2368 VDD_B.t116 VDD_B.t69 39.5838280750919
Riso2369 VDD_B.t116 VDD_B.t70 101.310050512238
Riso2370 VDD_B.t116 VDD_B.t71 6695.70197834807
Riso2371 VDD_B.t116 VDD_B.t73 468.657990415764
Riso2372 VDD_B.t116 VDD_B.t75 452.541274015357
Riso2373 VDD_B.t116 VDD_B.t76 917.156367384221
Riso2374 VDD_B.t116 VDD_B.t77 672.091219289448
Riso2375 VDD_B.t116 VDD_B.t78 732.461150170541
Riso2376 VDD_B.t116 VDD_B.t79 1154.63111927026
Riso2377 VDD_B.t116 VDD_B.t8 728.12867679719
Riso2378 VDD_B.t116 VDD_B.t80 263.414040803762
Riso2379 VDD_B.t116 VDD_B.t81 17032.6750205919
Riso2380 VDD_B.t116 VDD_B.t82 2624.16437720367
Riso2381 VDD_B.t116 VDD_B.t83 1279.63022329726
Riso2382 VDD_B.t116 VDD_B.t85 748.307968882745
Riso2383 VDD_B.t116 VDD_B.t86 794.085530059845
Riso2384 VDD_B.t116 VDD_B.t87 59.9913776020765
Riso2385 VDD_B.t116 VDD_B.t88 672.091219289448
Riso2386 VDD_B.t116 VDD_B.t89 180.520421687464
Riso2387 VDD_B.t116 VDD_B.t9 504.679876698707
Riso2388 VDD_B.t116 VDD_B.t90 46.0837815558315
Riso2389 VDD_B.t116 VDD_B.t91 117.911430756381
Riso2390 VDD_B.t116 VDD_B.t92 557.758256205885
Riso2391 VDD_B.t116 VDD_B.t94 655.294604097211
Riso2392 VDD_B.t116 VDD_B.t95 208.744267885036
Riso2393 VDD_B.t116 VDD_B.t96 3522.16232159211
Riso2394 VDD_B.t116 VDD_B.t97 5055.93360536788
Riso2395 VDD_B.t116 VDD_B.t99 655.294604097211
Riso2396 VDD_B.t117 VDD_B.t118 211.550646063621
Riso2397 VDD_B.t117 VDD_B.t119 459.899801970358
Riso2398 VDD_B.t117 VDD_B.t120 293.880653239758
Riso2399 VDD_B.t117 VDD_B.t122 4343.58558864812
Riso2400 VDD_B.t117 VDD_B.t123 149.464673684121
Riso2401 VDD_B.t117 VDD_B.t124 238.629528730753
Riso2402 VDD_B.t117 VDD_B.t125 42062.908281791
Riso2403 VDD_B.t117 VDD_B.t126 60.6162249794129
Riso2404 VDD_B.t117 VDD_B.t127 297281.021790113
Riso2405 VDD_B.t117 VDD_B.t128 1734.61485520325
Riso2406 VDD_B.t117 VDD_B.t13 3943.30305273302
Riso2407 VDD_B.t117 VDD_B.t130 3222.27938049246
Riso2408 VDD_B.t117 VDD_B.t132 3222.27938049246
Riso2409 VDD_B.t117 VDD_B.t134 2956.89875634346
Riso2410 VDD_B.t117 VDD_B.t135 122.355721588228
Riso2411 VDD_B.t117 VDD_B.t136 697.791433129478
Riso2412 VDD_B.t117 VDD_B.t137 697.791433129478
Riso2413 VDD_B.t117 VDD_B.t139 4598.48973541717
Riso2414 VDD_B.t117 VDD_B.t140 192.060293434033
Riso2415 VDD_B.t117 VDD_B.t141 78.6938083719541
Riso2416 VDD_B.t117 VDD_B.t143 4518.63342067666
Riso2417 VDD_B.t117 VDD_B.t144 251.732093268587
Riso2418 VDD_B.t117 VDD_B.t145 290.158016329461
Riso2419 VDD_B.t117 VDD_B.t147 3943.30305273302
Riso2420 VDD_B.t117 VDD_B.t149 4598.48973541717
Riso2421 VDD_B.t117 VDD_B.t15 1634.73164243162
Riso2422 VDD_B.t117 VDD_B.t150 281.348299017911
Riso2423 VDD_B.t117 VDD_B.t151 141.554943063187
Riso2424 VDD_B.t117 VDD_B.t152 62301.2478769614
Riso2425 VDD_B.t117 VDD_B.t153 40.9496334545207
Riso2426 VDD_B.t117 VDD_B.t154 162.846338096345
Riso2427 VDD_B.t117 VDD_B.t17 2956.89875634346
Riso2428 VDD_B.t117 VDD_B.t18 33.2377072878846
Riso2429 VDD_B.t117 VDD_B.t2 3710.06102689503
Riso2430 VDD_B.t117 VDD_B.t20 2751.05240283671
Riso2431 VDD_B.t117 VDD_B.t22 4244.53906980745
Riso2432 VDD_B.t117 VDD_B.t23 162.846338096345
Riso2433 VDD_B.t117 VDD_B.t24 98053.2627783651
Riso2434 VDD_B.t117 VDD_B.t25 4582.43535858069
Riso2435 VDD_B.t117 VDD_B.t26 504.679876698707
Riso2436 VDD_B.t117 VDD_B.t27 91.0574041308907
Riso2437 VDD_B.t117 VDD_B.t28 232.910942717714
Riso2438 VDD_B.t117 VDD_B.t3 180144.603026
Riso2439 VDD_B.t117 VDD_B.t30 2751.05240283671
Riso2440 VDD_B.t117 VDD_B.t31 633.678702739493
Riso2441 VDD_B.t117 VDD_B.t32 34747.3771861688
Riso2442 VDD_B.t117 VDD_B.t33 549.512017645556
Riso2443 VDD_B.t117 VDD_B.t34 374.210447745653
Riso2444 VDD_B.t117 VDD_B.t35 58100.4082197259
Riso2445 VDD_B.t117 VDD_B.t36 61318.6783363301
Riso2446 VDD_B.t117 VDD_B.t37 77.7204092124238
Riso2447 VDD_B.t117 VDD_B.t38 91.0574041308907
Riso2448 VDD_B.t117 VDD_B.t39 171.59443552587
Riso2449 VDD_B.t117 VDD_B.t4 4582.43535858069
Riso2450 VDD_B.t117 VDD_B.t41 1985.04566139556
Riso2451 VDD_B.t117 VDD_B.t42 186.213572902435
Riso2452 VDD_B.t117 VDD_B.t43 459.899801970358
Riso2453 VDD_B.t117 VDD_B.t44 79916.3238032223
Riso2454 VDD_B.t117 VDD_B.t45 234603.221676444
Riso2455 VDD_B.t117 VDD_B.t46 293.880653239758
Riso2456 VDD_B.t117 VDD_B.t47 212.733777281075
Riso2457 VDD_B.t117 VDD_B.t48 89.9988743869116
Riso2458 VDD_B.t117 VDD_B.t49 40.4635901850547
Riso2459 VDD_B.t117 VDD_B.t50 67.4747308681969
Riso2460 VDD_B.t117 VDD_B.t51 633.678702739493
Riso2461 VDD_B.t117 VDD_B.t52 40.4635901850547
Riso2462 VDD_B.t117 VDD_B.t53 48.6363324302585
Riso2463 VDD_B.t117 VDD_B.t55 4244.53906980745
Riso2464 VDD_B.t117 VDD_B.t56 122.355721588228
Riso2465 VDD_B.t117 VDD_B.t57 76.6283258798225
Riso2466 VDD_B.t117 VDD_B.t58 162189.066091354
Riso2467 VDD_B.t117 VDD_B.t59 932.814587160631
Riso2468 VDD_B.t117 VDD_B.t6 3144.16548350801
Riso2469 VDD_B.t117 VDD_B.t60 192.060293434033
Riso2470 VDD_B.t117 VDD_B.t61 374.210447745653
Riso2471 VDD_B.t117 VDD_B.t62 593.070328988428
Riso2472 VDD_B.t117 VDD_B.t63 186.213572902435
Riso2473 VDD_B.t117 VDD_B.t64 171.180062558322
Riso2474 VDD_B.t117 VDD_B.t66 2840.25218025019
Riso2475 VDD_B.t117 VDD_B.t67 290.158016329461
Riso2476 VDD_B.t117 VDD_B.t68 281.348299017911
Riso2477 VDD_B.t117 VDD_B.t69 549.512017645556
Riso2478 VDD_B.t117 VDD_B.t70 238.629528730753
Riso2479 VDD_B.t117 VDD_B.t71 33248.5428152789
Riso2480 VDD_B.t117 VDD_B.t73 1985.04566139556
Riso2481 VDD_B.t117 VDD_B.t75 2840.25218025019
Riso2482 VDD_B.t117 VDD_B.t76 104.407077306238
Riso2483 VDD_B.t117 VDD_B.t77 57.4591687892165
Riso2484 VDD_B.t117 VDD_B.t78 67.4747308681969
Riso2485 VDD_B.t117 VDD_B.t79 171.59443552587
Riso2486 VDD_B.t117 VDD_B.t8 3710.06102689503
Riso2487 VDD_B.t117 VDD_B.t80 89.9988743869116
Riso2488 VDD_B.t117 VDD_B.t81 84578.3797594588
Riso2489 VDD_B.t117 VDD_B.t82 13030.6937094759
Riso2490 VDD_B.t117 VDD_B.t83 232.910942717714
Riso2491 VDD_B.t117 VDD_B.t85 4518.63342067666
Riso2492 VDD_B.t117 VDD_B.t86 78.6938083719541
Riso2493 VDD_B.t117 VDD_B.t87 669.332384385857
Riso2494 VDD_B.t117 VDD_B.t88 57.4591687892165
Riso2495 VDD_B.t117 VDD_B.t89 141.554943063187
Riso2496 VDD_B.t117 VDD_B.t9 0.0669642614047921
Riso2497 VDD_B.t117 VDD_B.t90 593.070328988428
Riso2498 VDD_B.t117 VDD_B.t91 211.550646063621
Riso2499 VDD_B.t117 VDD_B.t92 40.9496334545207
Riso2500 VDD_B.t117 VDD_B.t94 4747.88630800611
Riso2501 VDD_B.t117 VDD_B.t95 24.1829735187471
Riso2502 VDD_B.t117 VDD_B.t96 17489.8412639192
Riso2503 VDD_B.t117 VDD_B.t97 25106.0195768681
Riso2504 VDD_B.t117 VDD_B.t99 4747.88630800611
Riso2505 VDD_B.t118 VDD_B.t119 102.510625682154
Riso2506 VDD_B.t118 VDD_B.t120 823.409042058134
Riso2507 VDD_B.t118 VDD_B.t122 1439.59620419716
Riso2508 VDD_B.t118 VDD_B.t123 409.946119322265
Riso2509 VDD_B.t118 VDD_B.t124 40.4447158719027
Riso2510 VDD_B.t118 VDD_B.t125 18533.637409038
Riso2511 VDD_B.t118 VDD_B.t126 257.041176125338
Riso2512 VDD_B.t118 VDD_B.t127 134428.437583661
Riso2513 VDD_B.t118 VDD_B.t128 748.494579793109
Riso2514 VDD_B.t118 VDD_B.t13 1361.6360696866
Riso2515 VDD_B.t118 VDD_B.t130 1279.56400774347
Riso2516 VDD_B.t118 VDD_B.t132 1279.56400774347
Riso2517 VDD_B.t118 VDD_B.t134 1094.41224043306
Riso2518 VDD_B.t118 VDD_B.t135 68.1202504788932
Riso2519 VDD_B.t118 VDD_B.t136 200.253499562139
Riso2520 VDD_B.t118 VDD_B.t137 200.253499562139
Riso2521 VDD_B.t118 VDD_B.t139 1551.49116574055
Riso2522 VDD_B.t118 VDD_B.t140 684.591880602263
Riso2523 VDD_B.t118 VDD_B.t141 380.926546696641
Riso2524 VDD_B.t118 VDD_B.t143 1743.58032704201
Riso2525 VDD_B.t118 VDD_B.t144 796.20936395615
Riso2526 VDD_B.t118 VDD_B.t145 833.709464325643
Riso2527 VDD_B.t118 VDD_B.t147 1361.6360696866
Riso2528 VDD_B.t118 VDD_B.t149 1551.49116574055
Riso2529 VDD_B.t118 VDD_B.t15 579.018163686968
Riso2530 VDD_B.t118 VDD_B.t150 832.029142007966
Riso2531 VDD_B.t118 VDD_B.t151 57.8232925129455
Riso2532 VDD_B.t118 VDD_B.t152 27450.9962684167
Riso2533 VDD_B.t118 VDD_B.t153 240.631817454669
Riso2534 VDD_B.t118 VDD_B.t154 48.8252232543145
Riso2535 VDD_B.t118 VDD_B.t17 1094.41224043306
Riso2536 VDD_B.t118 VDD_B.t18 62.7237200674222
Riso2537 VDD_B.t118 VDD_B.t2 1536.33134575777
Riso2538 VDD_B.t118 VDD_B.t20 1192.32317750969
Riso2539 VDD_B.t118 VDD_B.t22 1377.37747272439
Riso2540 VDD_B.t118 VDD_B.t23 48.8252232543145
Riso2541 VDD_B.t118 VDD_B.t24 32172.2232489922
Riso2542 VDD_B.t118 VDD_B.t25 1505.97516830973
Riso2543 VDD_B.t118 VDD_B.t26 117.911430756381
Riso2544 VDD_B.t118 VDD_B.t27 420.745146015028
Riso2545 VDD_B.t118 VDD_B.t28 764.972058937407
Riso2546 VDD_B.t118 VDD_B.t3 59107.1854360804
Riso2547 VDD_B.t118 VDD_B.t30 1192.32317750969
Riso2548 VDD_B.t118 VDD_B.t31 168.843613905278
Riso2549 VDD_B.t118 VDD_B.t32 15310.2891832687
Riso2550 VDD_B.t118 VDD_B.t33 134.393340920908
Riso2551 VDD_B.t118 VDD_B.t34 75.7311391634842
Riso2552 VDD_B.t118 VDD_B.t35 25600.0344067422
Riso2553 VDD_B.t118 VDD_B.t36 27018.0593094878
Riso2554 VDD_B.t118 VDD_B.t37 302.685730117834
Riso2555 VDD_B.t118 VDD_B.t38 420.745146015028
Riso2556 VDD_B.t118 VDD_B.t39 638.877364666105
Riso2557 VDD_B.t118 VDD_B.t4 1505.97516830973
Riso2558 VDD_B.t118 VDD_B.t41 880.7522491079
Riso2559 VDD_B.t118 VDD_B.t42 41.0331913276019
Riso2560 VDD_B.t118 VDD_B.t43 102.510625682154
Riso2561 VDD_B.t118 VDD_B.t44 35212.5002510437
Riso2562 VDD_B.t118 VDD_B.t45 103370.195337293
Riso2563 VDD_B.t118 VDD_B.t46 823.409042058134
Riso2564 VDD_B.t118 VDD_B.t47 727.174073727447
Riso2565 VDD_B.t118 VDD_B.t48 92.8051382314512
Riso2566 VDD_B.t118 VDD_B.t49 185.019291688917
Riso2567 VDD_B.t118 VDD_B.t50 342.633297850902
Riso2568 VDD_B.t118 VDD_B.t51 168.843613905278
Riso2569 VDD_B.t118 VDD_B.t52 185.019291688917
Riso2570 VDD_B.t118 VDD_B.t53 272.246827493601
Riso2571 VDD_B.t118 VDD_B.t55 1377.37747272439
Riso2572 VDD_B.t118 VDD_B.t56 68.1202504788932
Riso2573 VDD_B.t118 VDD_B.t57 107.131630596703
Riso2574 VDD_B.t118 VDD_B.t58 72637.9697302635
Riso2575 VDD_B.t118 VDD_B.t59 417.131772523135
Riso2576 VDD_B.t118 VDD_B.t6 1102.15039058509
Riso2577 VDD_B.t118 VDD_B.t60 684.591880602263
Riso2578 VDD_B.t118 VDD_B.t61 75.7311391634842
Riso2579 VDD_B.t118 VDD_B.t62 151.567174872951
Riso2580 VDD_B.t118 VDD_B.t63 41.0331913276019
Riso2581 VDD_B.t118 VDD_B.t64 32.990189722719
Riso2582 VDD_B.t118 VDD_B.t66 1018.94074082064
Riso2583 VDD_B.t118 VDD_B.t67 833.709464325643
Riso2584 VDD_B.t118 VDD_B.t68 832.029142007966
Riso2585 VDD_B.t118 VDD_B.t69 134.393340920908
Riso2586 VDD_B.t118 VDD_B.t70 40.4447158719027
Riso2587 VDD_B.t118 VDD_B.t71 14649.8771028634
Riso2588 VDD_B.t118 VDD_B.t73 880.7522491079
Riso2589 VDD_B.t118 VDD_B.t75 1018.94074082064
Riso2590 VDD_B.t118 VDD_B.t76 461.472663733068
Riso2591 VDD_B.t118 VDD_B.t77 306.307547366975
Riso2592 VDD_B.t118 VDD_B.t78 342.633297850902
Riso2593 VDD_B.t118 VDD_B.t79 638.877364666105
Riso2594 VDD_B.t118 VDD_B.t8 1536.33134575777
Riso2595 VDD_B.t118 VDD_B.t80 92.8051382314512
Riso2596 VDD_B.t118 VDD_B.t81 37266.6819090184
Riso2597 VDD_B.t118 VDD_B.t82 5741.54670384994
Riso2598 VDD_B.t118 VDD_B.t83 764.972058937407
Riso2599 VDD_B.t118 VDD_B.t85 1743.58032704201
Riso2600 VDD_B.t118 VDD_B.t86 380.926546696641
Riso2601 VDD_B.t118 VDD_B.t87 185.411933196581
Riso2602 VDD_B.t118 VDD_B.t88 306.307547366975
Riso2603 VDD_B.t118 VDD_B.t89 57.8232925129455
Riso2604 VDD_B.t118 VDD_B.t9 211.550646063621
Riso2605 VDD_B.t118 VDD_B.t90 151.567174872951
Riso2606 VDD_B.t118 VDD_B.t91 0.0669643491712357
Riso2607 VDD_B.t118 VDD_B.t92 240.631817454669
Riso2608 VDD_B.t118 VDD_B.t94 1685.01496537059
Riso2609 VDD_B.t118 VDD_B.t95 82.3890163872586
Riso2610 VDD_B.t118 VDD_B.t96 7706.32344667031
Riso2611 VDD_B.t118 VDD_B.t97 11062.1419827814
Riso2612 VDD_B.t118 VDD_B.t99 1685.01496537059
Riso2613 VDD_B.t119 VDD_B.t120 1182.89065080842
Riso2614 VDD_B.t119 VDD_B.t122 603.160138257991
Riso2615 VDD_B.t119 VDD_B.t123 578.284783754616
Riso2616 VDD_B.t119 VDD_B.t124 87.6858063015415
Riso2617 VDD_B.t119 VDD_B.t125 9426.96999288713
Riso2618 VDD_B.t119 VDD_B.t126 466.809318443477
Riso2619 VDD_B.t119 VDD_B.t127 68225.5512678732
Riso2620 VDD_B.t119 VDD_B.t128 377.987999737277
Riso2621 VDD_B.t119 VDD_B.t13 640.91542505597
Riso2622 VDD_B.t119 VDD_B.t130 640.304774619426
Riso2623 VDD_B.t119 VDD_B.t132 640.304774619426
Riso2624 VDD_B.t119 VDD_B.t134 543.702279632381
Riso2625 VDD_B.t119 VDD_B.t135 182.216445000381
Riso2626 VDD_B.t119 VDD_B.t136 77.689180928591
Riso2627 VDD_B.t119 VDD_B.t137 77.689180928591
Riso2628 VDD_B.t119 VDD_B.t139 695.73764952199
Riso2629 VDD_B.t119 VDD_B.t140 1143.05845264111
Riso2630 VDD_B.t119 VDD_B.t141 735.394482847858
Riso2631 VDD_B.t119 VDD_B.t143 843.028368179205
Riso2632 VDD_B.t119 VDD_B.t144 1244.2452380906
Riso2633 VDD_B.t119 VDD_B.t145 1221.53730480182
Riso2634 VDD_B.t119 VDD_B.t147 640.91542505597
Riso2635 VDD_B.t119 VDD_B.t149 695.73764952199
Riso2636 VDD_B.t119 VDD_B.t15 284.815269631352
Riso2637 VDD_B.t119 VDD_B.t150 1244.74727447657
Riso2638 VDD_B.t119 VDD_B.t151 159.056474678991
Riso2639 VDD_B.t119 VDD_B.t152 13962.7053441234
Riso2640 VDD_B.t119 VDD_B.t153 509.996514282912
Riso2641 VDD_B.t119 VDD_B.t154 138.091970591533
Riso2642 VDD_B.t119 VDD_B.t17 543.702279632381
Riso2643 VDD_B.t119 VDD_B.t18 151.109260521731
Riso2644 VDD_B.t119 VDD_B.t2 807.574592495743
Riso2645 VDD_B.t119 VDD_B.t20 666.474886073863
Riso2646 VDD_B.t119 VDD_B.t22 570.68270695557
Riso2647 VDD_B.t119 VDD_B.t23 138.091970591533
Riso2648 VDD_B.t119 VDD_B.t24 13664.2108850038
Riso2649 VDD_B.t119 VDD_B.t25 641.754643339989
Riso2650 VDD_B.t119 VDD_B.t26 39.9666675060675
Riso2651 VDD_B.t119 VDD_B.t27 795.203617997064
Riso2652 VDD_B.t119 VDD_B.t28 1222.21303182606
Riso2653 VDD_B.t119 VDD_B.t3 25104.0483079741
Riso2654 VDD_B.t119 VDD_B.t30 666.474886073863
Riso2655 VDD_B.t119 VDD_B.t31 62.2058663726203
Riso2656 VDD_B.t119 VDD_B.t32 7787.44255796848
Riso2657 VDD_B.t119 VDD_B.t33 46.8317310473358
Riso2658 VDD_B.t119 VDD_B.t34 47.04742990776
Riso2659 VDD_B.t119 VDD_B.t35 13021.2300393635
Riso2660 VDD_B.t119 VDD_B.t36 13742.4958066991
Riso2661 VDD_B.t119 VDD_B.t37 527.771546250669
Riso2662 VDD_B.t119 VDD_B.t38 795.203617997064
Riso2663 VDD_B.t119 VDD_B.t39 1090.18678301823
Riso2664 VDD_B.t119 VDD_B.t4 641.754643339989
Riso2665 VDD_B.t119 VDD_B.t41 509.524837149119
Riso2666 VDD_B.t119 VDD_B.t42 119.273400956248
Riso2667 VDD_B.t119 VDD_B.t43 0.0669623559023411
Riso2668 VDD_B.t119 VDD_B.t44 17910.5253823108
Riso2669 VDD_B.t119 VDD_B.t45 52578.3313926461
Riso2670 VDD_B.t119 VDD_B.t46 1182.89065080842
Riso2671 VDD_B.t119 VDD_B.t47 1187.7966646101
Riso2672 VDD_B.t119 VDD_B.t48 235.011518435468
Riso2673 VDD_B.t119 VDD_B.t49 412.890131074196
Riso2674 VDD_B.t119 VDD_B.t50 676.228696049545
Riso2675 VDD_B.t119 VDD_B.t51 62.2058663726203
Riso2676 VDD_B.t119 VDD_B.t52 412.890131074196
Riso2677 VDD_B.t119 VDD_B.t53 562.98341506506
Riso2678 VDD_B.t119 VDD_B.t55 570.68270695557
Riso2679 VDD_B.t119 VDD_B.t56 182.216445000381
Riso2680 VDD_B.t119 VDD_B.t57 264.364454111805
Riso2681 VDD_B.t119 VDD_B.t58 42627.8205423887
Riso2682 VDD_B.t119 VDD_B.t59 244.204791402687
Riso2683 VDD_B.t119 VDD_B.t6 535.581887327304
Riso2684 VDD_B.t119 VDD_B.t60 1143.05845264111
Riso2685 VDD_B.t119 VDD_B.t61 47.04742990776
Riso2686 VDD_B.t119 VDD_B.t62 54.3145058406859
Riso2687 VDD_B.t119 VDD_B.t63 119.273400956248
Riso2688 VDD_B.t119 VDD_B.t64 28.0181519169638
Riso2689 VDD_B.t119 VDD_B.t66 503.800473198831
Riso2690 VDD_B.t119 VDD_B.t67 1221.53730480182
Riso2691 VDD_B.t119 VDD_B.t68 1244.74727447657
Riso2692 VDD_B.t119 VDD_B.t69 46.8317310473358
Riso2693 VDD_B.t119 VDD_B.t70 87.6858063015415
Riso2694 VDD_B.t119 VDD_B.t71 7451.52982116888
Riso2695 VDD_B.t119 VDD_B.t73 509.524837149119
Riso2696 VDD_B.t119 VDD_B.t75 503.800473198831
Riso2697 VDD_B.t119 VDD_B.t76 854.581657081732
Riso2698 VDD_B.t119 VDD_B.t77 618.546963611092
Riso2699 VDD_B.t119 VDD_B.t78 676.228696049545
Riso2700 VDD_B.t119 VDD_B.t79 1090.18678301823
Riso2701 VDD_B.t119 VDD_B.t8 807.574592495743
Riso2702 VDD_B.t119 VDD_B.t80 235.011518435468
Riso2703 VDD_B.t119 VDD_B.t81 18955.3666308087
Riso2704 VDD_B.t119 VDD_B.t82 2920.3867160776
Riso2705 VDD_B.t119 VDD_B.t83 1222.21303182606
Riso2706 VDD_B.t119 VDD_B.t85 843.028368179205
Riso2707 VDD_B.t119 VDD_B.t86 735.394482847858
Riso2708 VDD_B.t119 VDD_B.t87 70.1615262061326
Riso2709 VDD_B.t119 VDD_B.t88 618.546963611092
Riso2710 VDD_B.t119 VDD_B.t89 159.056474678991
Riso2711 VDD_B.t119 VDD_B.t9 459.899801970358
Riso2712 VDD_B.t119 VDD_B.t90 54.3145058406859
Riso2713 VDD_B.t119 VDD_B.t91 102.510625682154
Riso2714 VDD_B.t119 VDD_B.t92 509.996514282912
Riso2715 VDD_B.t119 VDD_B.t94 748.856878481855
Riso2716 VDD_B.t119 VDD_B.t95 188.868471237304
Riso2717 VDD_B.t119 VDD_B.t96 3919.7529488635
Riso2718 VDD_B.t119 VDD_B.t97 5626.6602301113
Riso2719 VDD_B.t119 VDD_B.t99 748.856878481855
Riso2720 VDD_B.t12 VDD_B.t146 158.648
Riso2721 VDD_B.t120 VDD_B.t122 5443.92124231084
Riso2722 VDD_B.t120 VDD_B.t123 12.7007990197665
Riso2723 VDD_B.t120 VDD_B.t124 877.875351770822
Riso2724 VDD_B.t120 VDD_B.t125 20155.425704556
Riso2725 VDD_B.t120 VDD_B.t126 60.1337537300492
Riso2726 VDD_B.t120 VDD_B.t127 115672.637105716
Riso2727 VDD_B.t120 VDD_B.t128 755.315692909071
Riso2728 VDD_B.t120 VDD_B.t13 4220.84287387213
Riso2729 VDD_B.t120 VDD_B.t130 1809.68832052827
Riso2730 VDD_B.t120 VDD_B.t132 1809.68832052827
Riso2731 VDD_B.t120 VDD_B.t134 2258.4914694006
Riso2732 VDD_B.t120 VDD_B.t135 609.521114357658
Riso2733 VDD_B.t120 VDD_B.t136 1176.80809071514
Riso2734 VDD_B.t120 VDD_B.t137 1176.80809071514
Riso2735 VDD_B.t120 VDD_B.t139 5148.82191408844
Riso2736 VDD_B.t120 VDD_B.t140 70.5330285157058
Riso2737 VDD_B.t120 VDD_B.t141 170.830208185722
Riso2738 VDD_B.t120 VDD_B.t143 5736.55402399576
Riso2739 VDD_B.t120 VDD_B.t144 45.5351783824288
Riso2740 VDD_B.t120 VDD_B.t145 27.9996315515264
Riso2741 VDD_B.t120 VDD_B.t147 4220.84287387213
Riso2742 VDD_B.t120 VDD_B.t149 5148.82191408844
Riso2743 VDD_B.t120 VDD_B.t15 1616.25693908539
Riso2744 VDD_B.t120 VDD_B.t150 33.08388586534
Riso2745 VDD_B.t120 VDD_B.t151 660.97206460934
Riso2746 VDD_B.t120 VDD_B.t152 29853.0991835583
Riso2747 VDD_B.t120 VDD_B.t153 265.826951320732
Riso2748 VDD_B.t120 VDD_B.t154 714.152537789558
Riso2749 VDD_B.t120 VDD_B.t17 2258.4914694006
Riso2750 VDD_B.t120 VDD_B.t18 218.459182879369
Riso2751 VDD_B.t120 VDD_B.t2 4732.99175164582
Riso2752 VDD_B.t120 VDD_B.t20 3520.00802913324
Riso2753 VDD_B.t120 VDD_B.t22 5233.8111804537
Riso2754 VDD_B.t120 VDD_B.t23 714.152537789558
Riso2755 VDD_B.t120 VDD_B.t24 116396.881519123
Riso2756 VDD_B.t120 VDD_B.t25 5420.96024127099
Riso2757 VDD_B.t120 VDD_B.t26 1214.30158066139
Riso2758 VDD_B.t120 VDD_B.t27 151.419892268732
Riso2759 VDD_B.t120 VDD_B.t28 53.0030566254856
Riso2760 VDD_B.t120 VDD_B.t3 213845.714263709
Riso2761 VDD_B.t120 VDD_B.t30 3520.00802913324
Riso2762 VDD_B.t120 VDD_B.t31 1234.60932912171
Riso2763 VDD_B.t120 VDD_B.t32 16650.0179828789
Riso2764 VDD_B.t120 VDD_B.t33 1234.40706803717
Riso2765 VDD_B.t120 VDD_B.t34 1093.83975794761
Riso2766 VDD_B.t120 VDD_B.t35 27840.1686690789
Riso2767 VDD_B.t120 VDD_B.t36 29382.2780210489
Riso2768 VDD_B.t120 VDD_B.t37 46.6896882408974
Riso2769 VDD_B.t120 VDD_B.t38 151.419892268732
Riso2770 VDD_B.t120 VDD_B.t39 80.5373243605827
Riso2771 VDD_B.t120 VDD_B.t4 5420.96024127099
Riso2772 VDD_B.t120 VDD_B.t41 2543.65465044876
Riso2773 VDD_B.t120 VDD_B.t42 768.533272286051
Riso2774 VDD_B.t120 VDD_B.t43 1182.89065080842
Riso2775 VDD_B.t120 VDD_B.t44 38293.7745580083
Riso2776 VDD_B.t120 VDD_B.t45 112415.617409794
Riso2777 VDD_B.t120 VDD_B.t46 0.0669049354328404
Riso2778 VDD_B.t120 VDD_B.t47 61.3378808219145
Riso2779 VDD_B.t120 VDD_B.t48 513.202659108967
Riso2780 VDD_B.t120 VDD_B.t49 323.490581907348
Riso2781 VDD_B.t120 VDD_B.t50 191.951853962472
Riso2782 VDD_B.t120 VDD_B.t51 1234.60932912171
Riso2783 VDD_B.t120 VDD_B.t52 323.490581907348
Riso2784 VDD_B.t120 VDD_B.t53 239.452844778716
Riso2785 VDD_B.t120 VDD_B.t55 5233.8111804537
Riso2786 VDD_B.t120 VDD_B.t56 609.521114357658
Riso2787 VDD_B.t120 VDD_B.t57 468.748400508824
Riso2788 VDD_B.t120 VDD_B.t58 207934.329927149
Riso2789 VDD_B.t120 VDD_B.t59 1195.89505466038
Riso2790 VDD_B.t120 VDD_B.t6 3260.52280503279
Riso2791 VDD_B.t120 VDD_B.t60 70.5330285157058
Riso2792 VDD_B.t120 VDD_B.t61 1093.83975794761
Riso2793 VDD_B.t120 VDD_B.t62 1241.57120409661
Riso2794 VDD_B.t120 VDD_B.t63 768.533272286051
Riso2795 VDD_B.t120 VDD_B.t64 532.271754705587
Riso2796 VDD_B.t120 VDD_B.t66 2597.25862726329
Riso2797 VDD_B.t120 VDD_B.t67 27.9996315515264
Riso2798 VDD_B.t120 VDD_B.t68 33.08388586534
Riso2799 VDD_B.t120 VDD_B.t69 1234.40706803717
Riso2800 VDD_B.t120 VDD_B.t70 877.875351770822
Riso2801 VDD_B.t120 VDD_B.t71 15931.8164594958
Riso2802 VDD_B.t120 VDD_B.t73 2543.65465044876
Riso2803 VDD_B.t120 VDD_B.t75 2597.25862726329
Riso2804 VDD_B.t120 VDD_B.t76 133.667697620118
Riso2805 VDD_B.t120 VDD_B.t77 214.82155380833
Riso2806 VDD_B.t120 VDD_B.t78 191.951853962472
Riso2807 VDD_B.t120 VDD_B.t79 80.5373243605827
Riso2808 VDD_B.t120 VDD_B.t8 4732.99175164582
Riso2809 VDD_B.t120 VDD_B.t80 513.202659108967
Riso2810 VDD_B.t120 VDD_B.t81 40527.7076428749
Riso2811 VDD_B.t120 VDD_B.t82 6243.96147742983
Riso2812 VDD_B.t120 VDD_B.t83 53.0030566254856
Riso2813 VDD_B.t120 VDD_B.t85 5736.55402399576
Riso2814 VDD_B.t120 VDD_B.t86 170.830208185722
Riso2815 VDD_B.t120 VDD_B.t87 1212.96009175209
Riso2816 VDD_B.t120 VDD_B.t88 214.82155380833
Riso2817 VDD_B.t120 VDD_B.t89 660.97206460934
Riso2818 VDD_B.t120 VDD_B.t9 293.880653239758
Riso2819 VDD_B.t120 VDD_B.t90 1241.57120409661
Riso2820 VDD_B.t120 VDD_B.t91 823.409042058134
Riso2821 VDD_B.t120 VDD_B.t92 265.826951320732
Riso2822 VDD_B.t120 VDD_B.t94 5990.43022766224
Riso2823 VDD_B.t120 VDD_B.t95 181.387517153135
Riso2824 VDD_B.t120 VDD_B.t96 8380.66625868578
Riso2825 VDD_B.t120 VDD_B.t97 12030.1361220368
Riso2826 VDD_B.t120 VDD_B.t99 5990.43022766224
Riso2827 VDD_B.t121 VDD_B.t21 158.648
Riso2828 VDD_B.t122 VDD_B.t123 2577.45089517487
Riso2829 VDD_B.t122 VDD_B.t124 1278.78097287732
Riso2830 VDD_B.t122 VDD_B.t125 7852.84785424367
Riso2831 VDD_B.t122 VDD_B.t126 3373.67932219177
Riso2832 VDD_B.t122 VDD_B.t127 92369.5550472499
Riso2833 VDD_B.t122 VDD_B.t128 513.942147553343
Riso2834 VDD_B.t122 VDD_B.t13 200.871241587671
Riso2835 VDD_B.t122 VDD_B.t130 825.82858117857
Riso2836 VDD_B.t122 VDD_B.t132 825.82858117857
Riso2837 VDD_B.t122 VDD_B.t134 668.568508992471
Riso2838 VDD_B.t122 VDD_B.t135 2211.13601833249
Riso2839 VDD_B.t122 VDD_B.t136 235.661608530512
Riso2840 VDD_B.t122 VDD_B.t137 235.661608530512
Riso2841 VDD_B.t122 VDD_B.t139 129.103960831441
Riso2842 VDD_B.t122 VDD_B.t140 7022.91241839962
Riso2843 VDD_B.t122 VDD_B.t141 5905.83215459876
Riso2844 VDD_B.t122 VDD_B.t143 75.7721723274013
Riso2845 VDD_B.t122 VDD_B.t144 6705.147159617
Riso2846 VDD_B.t122 VDD_B.t145 5825.36535781457
Riso2847 VDD_B.t122 VDD_B.t147 200.871241587671
Riso2848 VDD_B.t122 VDD_B.t149 129.103960831441
Riso2849 VDD_B.t122 VDD_B.t15 253.856565663084
Riso2850 VDD_B.t122 VDD_B.t150 6169.59843290312
Riso2851 VDD_B.t122 VDD_B.t151 1999.48333854118
Riso2852 VDD_B.t122 VDD_B.t152 11631.2028980434
Riso2853 VDD_B.t122 VDD_B.t153 4666.1921528166
Riso2854 VDD_B.t122 VDD_B.t154 1800.06385569784
Riso2855 VDD_B.t122 VDD_B.t17 668.568508992471
Riso2856 VDD_B.t122 VDD_B.t18 1615.2112828857
Riso2857 VDD_B.t122 VDD_B.t2 113.756550274744
Riso2858 VDD_B.t122 VDD_B.t20 170.203019642591
Riso2859 VDD_B.t122 VDD_B.t22 54.8340703076816
Riso2860 VDD_B.t122 VDD_B.t23 1800.06385569784
Riso2861 VDD_B.t122 VDD_B.t24 1766.86213184829
Riso2862 VDD_B.t122 VDD_B.t25 84.5510398618789
Riso2863 VDD_B.t122 VDD_B.t26 522.99263293282
Riso2864 VDD_B.t122 VDD_B.t27 6170.94042940996
Riso2865 VDD_B.t122 VDD_B.t28 6880.17138240372
Riso2866 VDD_B.t122 VDD_B.t3 3246.09980662175
Riso2867 VDD_B.t122 VDD_B.t30 170.203019642591
Riso2868 VDD_B.t122 VDD_B.t31 329.170334212533
Riso2869 VDD_B.t122 VDD_B.t32 6487.08987379089
Riso2870 VDD_B.t122 VDD_B.t33 450.704696402669
Riso2871 VDD_B.t122 VDD_B.t34 785.883852717378
Riso2872 VDD_B.t122 VDD_B.t35 10846.9358077284
Riso2873 VDD_B.t122 VDD_B.t36 11447.7641054354
Riso2874 VDD_B.t122 VDD_B.t37 3527.63842289961
Riso2875 VDD_B.t122 VDD_B.t38 6170.94042940996
Riso2876 VDD_B.t122 VDD_B.t39 6990.52677452005
Riso2877 VDD_B.t122 VDD_B.t4 84.5510398618789
Riso2878 VDD_B.t122 VDD_B.t41 248.678789179025
Riso2879 VDD_B.t122 VDD_B.t42 1613.36174346033
Riso2880 VDD_B.t122 VDD_B.t43 603.160138257991
Riso2881 VDD_B.t122 VDD_B.t44 14919.8131449426
Riso2882 VDD_B.t122 VDD_B.t45 43798.7643079366
Riso2883 VDD_B.t122 VDD_B.t46 5443.92124231084
Riso2884 VDD_B.t122 VDD_B.t47 6986.59240490015
Riso2885 VDD_B.t122 VDD_B.t48 2667.40244007403
Riso2886 VDD_B.t122 VDD_B.t49 4025.55284159813
Riso2887 VDD_B.t122 VDD_B.t50 5615.52177489692
Riso2888 VDD_B.t122 VDD_B.t51 329.170334212533
Riso2889 VDD_B.t122 VDD_B.t52 4025.55284159813
Riso2890 VDD_B.t122 VDD_B.t53 4989.24471878795
Riso2891 VDD_B.t122 VDD_B.t55 54.8340703076816
Riso2892 VDD_B.t122 VDD_B.t56 2211.13601833249
Riso2893 VDD_B.t122 VDD_B.t57 2908.94194306815
Riso2894 VDD_B.t122 VDD_B.t58 34715.0064753531
Riso2895 VDD_B.t122 VDD_B.t59 176.138804546583
Riso2896 VDD_B.t122 VDD_B.t6 317.301611571871
Riso2897 VDD_B.t122 VDD_B.t60 7022.91241839962
Riso2898 VDD_B.t122 VDD_B.t61 785.883852717378
Riso2899 VDD_B.t122 VDD_B.t62 386.199774775053
Riso2900 VDD_B.t122 VDD_B.t63 1613.36174346033
Riso2901 VDD_B.t122 VDD_B.t64 453.714516711203
Riso2902 VDD_B.t122 VDD_B.t66 549.583995360986
Riso2903 VDD_B.t122 VDD_B.t67 5825.36535781457
Riso2904 VDD_B.t122 VDD_B.t68 6169.59843290312
Riso2905 VDD_B.t122 VDD_B.t69 450.704696402669
Riso2906 VDD_B.t122 VDD_B.t70 1278.78097287732
Riso2907 VDD_B.t122 VDD_B.t71 6207.26808414054
Riso2908 VDD_B.t122 VDD_B.t73 248.678789179025
Riso2909 VDD_B.t122 VDD_B.t75 549.583995360986
Riso2910 VDD_B.t122 VDD_B.t76 6402.6436436184
Riso2911 VDD_B.t122 VDD_B.t77 5307.68930190398
Riso2912 VDD_B.t122 VDD_B.t78 5615.52177489692
Riso2913 VDD_B.t122 VDD_B.t79 6990.52677452005
Riso2914 VDD_B.t122 VDD_B.t8 113.756550274744
Riso2915 VDD_B.t122 VDD_B.t80 2667.40244007403
Riso2916 VDD_B.t122 VDD_B.t81 15790.1860603632
Riso2917 VDD_B.t122 VDD_B.t82 2432.73846996601
Riso2918 VDD_B.t122 VDD_B.t83 6880.17138240372
Riso2919 VDD_B.t122 VDD_B.t85 75.7721723274013
Riso2920 VDD_B.t122 VDD_B.t86 5905.83215459876
Riso2921 VDD_B.t122 VDD_B.t87 279.168837973868
Riso2922 VDD_B.t122 VDD_B.t88 5307.68930190398
Riso2923 VDD_B.t122 VDD_B.t89 1999.48333854118
Riso2924 VDD_B.t122 VDD_B.t9 4343.58558864812
Riso2925 VDD_B.t122 VDD_B.t90 386.199774775053
Riso2926 VDD_B.t122 VDD_B.t91 1439.59620419716
Riso2927 VDD_B.t122 VDD_B.t92 4666.1921528166
Riso2928 VDD_B.t122 VDD_B.t94 50.3950237040206
Riso2929 VDD_B.t122 VDD_B.t95 1901.29546505402
Riso2930 VDD_B.t122 VDD_B.t96 3265.2298200666
Riso2931 VDD_B.t122 VDD_B.t97 4687.1165122968
Riso2932 VDD_B.t122 VDD_B.t99 50.3950237040206
Riso2933 VDD_B.t123 VDD_B.t124 436.16928097204
Riso2934 VDD_B.t123 VDD_B.t125 9214.66558745522
Riso2935 VDD_B.t123 VDD_B.t126 31.2355496781825
Riso2936 VDD_B.t123 VDD_B.t127 52618.5971344643
Riso2937 VDD_B.t123 VDD_B.t128 344.142530072047
Riso2938 VDD_B.t123 VDD_B.t13 1969.80463401548
Riso2939 VDD_B.t123 VDD_B.t130 828.198115578868
Riso2940 VDD_B.t123 VDD_B.t132 828.198115578868
Riso2941 VDD_B.t123 VDD_B.t134 1040.98745877692
Riso2942 VDD_B.t123 VDD_B.t135 305.685450875803
Riso2943 VDD_B.t123 VDD_B.t136 562.890458453134
Riso2944 VDD_B.t123 VDD_B.t137 562.890458453134
Riso2945 VDD_B.t123 VDD_B.t139 2411.43466180845
Riso2946 VDD_B.t123 VDD_B.t140 37.0777358955988
Riso2947 VDD_B.t123 VDD_B.t141 87.9345363708672
Riso2948 VDD_B.t123 VDD_B.t143 2733.88948350828
Riso2949 VDD_B.t123 VDD_B.t144 24.1831370736629
Riso2950 VDD_B.t123 VDD_B.t145 15.0234998792292
Riso2951 VDD_B.t123 VDD_B.t147 1969.80463401548
Riso2952 VDD_B.t123 VDD_B.t149 2411.43466180845
Riso2953 VDD_B.t123 VDD_B.t15 751.064351082408
Riso2954 VDD_B.t123 VDD_B.t150 17.6921209050029
Riso2955 VDD_B.t123 VDD_B.t151 330.913198013558
Riso2956 VDD_B.t123 VDD_B.t152 13648.2518284613
Riso2957 VDD_B.t123 VDD_B.t153 135.477687580004
Riso2958 VDD_B.t123 VDD_B.t154 356.900858172072
Riso2959 VDD_B.t123 VDD_B.t17 1040.98745877692
Riso2960 VDD_B.t123 VDD_B.t18 110.32566067495
Riso2961 VDD_B.t123 VDD_B.t2 2261.77884200068
Riso2962 VDD_B.t123 VDD_B.t20 1684.94791943314
Riso2963 VDD_B.t123 VDD_B.t22 2471.83655499267
Riso2964 VDD_B.t123 VDD_B.t23 356.900858172072
Riso2965 VDD_B.t123 VDD_B.t24 54782.5214435988
Riso2966 VDD_B.t123 VDD_B.t25 2550.5538803089
Riso2967 VDD_B.t123 VDD_B.t26 591.608651517063
Riso2968 VDD_B.t123 VDD_B.t27 78.1681416568452
Riso2969 VDD_B.t123 VDD_B.t28 28.0515338072759
Riso2970 VDD_B.t123 VDD_B.t3 100647.09014862
Riso2971 VDD_B.t123 VDD_B.t30 1684.94791943314
Riso2972 VDD_B.t123 VDD_B.t31 594.892120265559
Riso2973 VDD_B.t123 VDD_B.t32 7612.06188280434
Riso2974 VDD_B.t123 VDD_B.t33 599.247641246682
Riso2975 VDD_B.t123 VDD_B.t34 538.100822410631
Riso2976 VDD_B.t123 VDD_B.t35 12727.979450512
Riso2977 VDD_B.t123 VDD_B.t36 13433.0016210177
Riso2978 VDD_B.t123 VDD_B.t37 24.395815713568
Riso2979 VDD_B.t123 VDD_B.t38 78.1681416568452
Riso2980 VDD_B.t123 VDD_B.t39 42.2035137676095
Riso2981 VDD_B.t123 VDD_B.t4 2550.5538803089
Riso2982 VDD_B.t123 VDD_B.t41 1218.61150645816
Riso2983 VDD_B.t123 VDD_B.t42 383.367938355467
Riso2984 VDD_B.t123 VDD_B.t43 578.284783754616
Riso2985 VDD_B.t123 VDD_B.t44 17507.1631731244
Riso2986 VDD_B.t123 VDD_B.t45 51394.2169430044
Riso2987 VDD_B.t123 VDD_B.t46 12.7007990197665
Riso2988 VDD_B.t123 VDD_B.t47 32.3514952938677
Riso2989 VDD_B.t123 VDD_B.t48 258.265371469922
Riso2990 VDD_B.t123 VDD_B.t49 164.211525678738
Riso2991 VDD_B.t123 VDD_B.t50 98.5373294884114
Riso2992 VDD_B.t123 VDD_B.t51 594.892120265559
Riso2993 VDD_B.t123 VDD_B.t52 164.211525678738
Riso2994 VDD_B.t123 VDD_B.t53 122.310476588042
Riso2995 VDD_B.t123 VDD_B.t55 2471.83655499267
Riso2996 VDD_B.t123 VDD_B.t56 305.685450875803
Riso2997 VDD_B.t123 VDD_B.t57 236.304694119709
Riso2998 VDD_B.t123 VDD_B.t58 99648.8430834394
Riso2999 VDD_B.t123 VDD_B.t59 573.086107082867
Riso3000 VDD_B.t123 VDD_B.t6 1518.28695113792
Riso3001 VDD_B.t123 VDD_B.t60 37.0777358955988
Riso3002 VDD_B.t123 VDD_B.t61 538.100822410631
Riso3003 VDD_B.t123 VDD_B.t62 600.496500589051
Riso3004 VDD_B.t123 VDD_B.t63 383.367938355467
Riso3005 VDD_B.t123 VDD_B.t64 262.576696355382
Riso3006 VDD_B.t123 VDD_B.t66 1203.60230808933
Riso3007 VDD_B.t123 VDD_B.t67 15.0234998792292
Riso3008 VDD_B.t123 VDD_B.t68 17.6921209050029
Riso3009 VDD_B.t123 VDD_B.t69 599.247641246682
Riso3010 VDD_B.t123 VDD_B.t70 436.16928097204
Riso3011 VDD_B.t123 VDD_B.t71 7283.71422300372
Riso3012 VDD_B.t123 VDD_B.t73 1218.61150645816
Riso3013 VDD_B.t123 VDD_B.t75 1203.60230808933
Riso3014 VDD_B.t123 VDD_B.t76 69.2129071852871
Riso3015 VDD_B.t123 VDD_B.t77 109.993899593723
Riso3016 VDD_B.t123 VDD_B.t78 98.5373294884114
Riso3017 VDD_B.t123 VDD_B.t79 42.2035137676095
Riso3018 VDD_B.t123 VDD_B.t8 2261.77884200068
Riso3019 VDD_B.t123 VDD_B.t80 258.265371469922
Riso3020 VDD_B.t123 VDD_B.t81 18528.4735946227
Riso3021 VDD_B.t123 VDD_B.t82 2854.61680635518
Riso3022 VDD_B.t123 VDD_B.t83 28.0515338072759
Riso3023 VDD_B.t123 VDD_B.t85 2733.88948350828
Riso3024 VDD_B.t123 VDD_B.t86 87.9345363708672
Riso3025 VDD_B.t123 VDD_B.t87 582.286315459712
Riso3026 VDD_B.t123 VDD_B.t88 109.993899593723
Riso3027 VDD_B.t123 VDD_B.t89 330.913198013558
Riso3028 VDD_B.t123 VDD_B.t9 149.464673684121
Riso3029 VDD_B.t123 VDD_B.t90 600.496500589051
Riso3030 VDD_B.t123 VDD_B.t91 409.946119322265
Riso3031 VDD_B.t123 VDD_B.t92 135.477687580004
Riso3032 VDD_B.t123 VDD_B.t94 2845.07209939552
Riso3033 VDD_B.t123 VDD_B.t95 91.9183972422526
Riso3034 VDD_B.t123 VDD_B.t96 3831.47635310937
Riso3035 VDD_B.t123 VDD_B.t97 5499.94244532759
Riso3036 VDD_B.t123 VDD_B.t99 2845.07209939552
Riso3037 VDD_B.t124 VDD_B.t125 16882.3311593749
Riso3038 VDD_B.t124 VDD_B.t126 282.272806487867
Riso3039 VDD_B.t124 VDD_B.t127 122334.731634787
Riso3040 VDD_B.t124 VDD_B.t128 680.301427024983
Riso3041 VDD_B.t124 VDD_B.t13 1224.97997418717
Riso3042 VDD_B.t124 VDD_B.t130 1160.46171401355
Riso3043 VDD_B.t124 VDD_B.t132 1160.46171401355
Riso3044 VDD_B.t124 VDD_B.t134 990.843506472818
Riso3045 VDD_B.t124 VDD_B.t135 79.1267619347386
Riso3046 VDD_B.t124 VDD_B.t136 175.715520955557
Riso3047 VDD_B.t124 VDD_B.t137 175.715520955557
Riso3048 VDD_B.t124 VDD_B.t139 1388.28105909338
Riso3049 VDD_B.t124 VDD_B.t140 743.245942885437
Riso3050 VDD_B.t124 VDD_B.t141 422.05261915235
Riso3051 VDD_B.t124 VDD_B.t143 1579.61353774627
Riso3052 VDD_B.t124 VDD_B.t144 857.269704197132
Riso3053 VDD_B.t124 VDD_B.t145 890.856638297177
Riso3054 VDD_B.t124 VDD_B.t147 1224.97997418717
Riso3055 VDD_B.t124 VDD_B.t149 1388.28105909338
Riso3056 VDD_B.t124 VDD_B.t15 523.400583536488
Riso3057 VDD_B.t124 VDD_B.t150 891.207645899146
Riso3058 VDD_B.t124 VDD_B.t151 67.4118804049838
Riso3059 VDD_B.t124 VDD_B.t152 25005.1729960022
Riso3060 VDD_B.t124 VDD_B.t153 270.398290654681
Riso3061 VDD_B.t124 VDD_B.t154 57.1245731791539
Riso3062 VDD_B.t124 VDD_B.t17 990.843506472818
Riso3063 VDD_B.t124 VDD_B.t18 71.8210889210246
Riso3064 VDD_B.t124 VDD_B.t2 1406.40127914736
Riso3065 VDD_B.t124 VDD_B.t20 1099.34358217509
Riso3066 VDD_B.t124 VDD_B.t22 1221.18880426444
Riso3067 VDD_B.t124 VDD_B.t23 57.1245731791539
Riso3068 VDD_B.t124 VDD_B.t24 28606.554161589
Riso3069 VDD_B.t124 VDD_B.t25 1339.5922175676
Riso3070 VDD_B.t124 VDD_B.t26 101.310050512238
Riso3071 VDD_B.t124 VDD_B.t27 464.70374391128
Riso3072 VDD_B.t124 VDD_B.t28 825.875731144083
Riso3073 VDD_B.t124 VDD_B.t3 52556.2964185039
Riso3074 VDD_B.t124 VDD_B.t30 1099.34358217509
Riso3075 VDD_B.t124 VDD_B.t31 147.002291314987
Riso3076 VDD_B.t124 VDD_B.t32 13946.1761570717
Riso3077 VDD_B.t124 VDD_B.t33 115.990000349392
Riso3078 VDD_B.t124 VDD_B.t34 64.2216494213787
Riso3079 VDD_B.t124 VDD_B.t35 23319.1277571479
Riso3080 VDD_B.t124 VDD_B.t36 24610.8097660296
Riso3081 VDD_B.t124 VDD_B.t37 330.532502773391
Riso3082 VDD_B.t124 VDD_B.t38 464.70374391128
Riso3083 VDD_B.t124 VDD_B.t39 695.612159943584
Riso3084 VDD_B.t124 VDD_B.t4 1339.5922175676
Riso3085 VDD_B.t124 VDD_B.t41 815.196284422307
Riso3086 VDD_B.t124 VDD_B.t42 48.1728345616373
Riso3087 VDD_B.t124 VDD_B.t43 87.6858063015415
Riso3088 VDD_B.t124 VDD_B.t44 32075.1440781827
Riso3089 VDD_B.t124 VDD_B.t45 94160.1387346899
Riso3090 VDD_B.t124 VDD_B.t46 877.875351770822
Riso3091 VDD_B.t124 VDD_B.t47 787.249139229879
Riso3092 VDD_B.t124 VDD_B.t48 107.007209533177
Riso3093 VDD_B.t124 VDD_B.t49 209.517441736027
Riso3094 VDD_B.t124 VDD_B.t50 380.886158773004
Riso3095 VDD_B.t124 VDD_B.t51 147.002291314987
Riso3096 VDD_B.t124 VDD_B.t52 209.517441736027
Riso3097 VDD_B.t124 VDD_B.t53 304.788213404466
Riso3098 VDD_B.t124 VDD_B.t55 1221.18880426444
Riso3099 VDD_B.t124 VDD_B.t56 79.1267619347386
Riso3100 VDD_B.t124 VDD_B.t57 123.084447404108
Riso3101 VDD_B.t124 VDD_B.t58 67336.6937861202
Riso3102 VDD_B.t124 VDD_B.t59 386.587729486926
Riso3103 VDD_B.t124 VDD_B.t6 994.942310609999
Riso3104 VDD_B.t124 VDD_B.t60 743.245942885437
Riso3105 VDD_B.t124 VDD_B.t61 64.2216494213787
Riso3106 VDD_B.t124 VDD_B.t62 131.393669676639
Riso3107 VDD_B.t124 VDD_B.t63 48.1728345616373
Riso3108 VDD_B.t124 VDD_B.t64 27.8616748686167
Riso3109 VDD_B.t124 VDD_B.t66 921.691392777901
Riso3110 VDD_B.t124 VDD_B.t67 890.856638297177
Riso3111 VDD_B.t124 VDD_B.t68 891.207645899146
Riso3112 VDD_B.t124 VDD_B.t69 115.990000349392
Riso3113 VDD_B.t124 VDD_B.t70 0.0669623467899509
Riso3114 VDD_B.t124 VDD_B.t71 13344.6053376481
Riso3115 VDD_B.t124 VDD_B.t73 815.196284422307
Riso3116 VDD_B.t124 VDD_B.t75 921.691392777901
Riso3117 VDD_B.t124 VDD_B.t76 508.175705284665
Riso3118 VDD_B.t124 VDD_B.t77 341.687336636814
Riso3119 VDD_B.t124 VDD_B.t78 380.886158773004
Riso3120 VDD_B.t124 VDD_B.t79 695.612159943584
Riso3121 VDD_B.t124 VDD_B.t8 1406.40127914736
Riso3122 VDD_B.t124 VDD_B.t80 107.007209533177
Riso3123 VDD_B.t124 VDD_B.t81 33946.3026773323
Riso3124 VDD_B.t124 VDD_B.t82 5229.98754546386
Riso3125 VDD_B.t124 VDD_B.t83 825.875731144083
Riso3126 VDD_B.t124 VDD_B.t85 1579.61353774627
Riso3127 VDD_B.t124 VDD_B.t86 422.05261915235
Riso3128 VDD_B.t124 VDD_B.t87 162.086657646599
Riso3129 VDD_B.t124 VDD_B.t88 341.687336636814
Riso3130 VDD_B.t124 VDD_B.t89 67.4118804049838
Riso3131 VDD_B.t124 VDD_B.t9 238.629528730753
Riso3132 VDD_B.t124 VDD_B.t90 131.393669676639
Riso3133 VDD_B.t124 VDD_B.t91 40.4447158719027
Riso3134 VDD_B.t124 VDD_B.t92 270.398290654681
Riso3135 VDD_B.t124 VDD_B.t94 1509.43205394979
Riso3136 VDD_B.t124 VDD_B.t95 93.6677855526443
Riso3137 VDD_B.t124 VDD_B.t96 7019.70701037342
Riso3138 VDD_B.t124 VDD_B.t97 10076.5295102982
Riso3139 VDD_B.t124 VDD_B.t99 1509.43205394979
Riso3140 VDD_B.t125 VDD_B.t126 22470.0663994822
Riso3141 VDD_B.t125 VDD_B.t127 207992.398133625
Riso3142 VDD_B.t125 VDD_B.t128 1336.45400140203
Riso3143 VDD_B.t125 VDD_B.t13 6111.49606267698
Riso3144 VDD_B.t125 VDD_B.t130 3068.54114812989
Riso3145 VDD_B.t125 VDD_B.t132 3068.54114812989
Riso3146 VDD_B.t125 VDD_B.t134 3589.67790462952
Riso3147 VDD_B.t125 VDD_B.t135 26035.0674661723
Riso3148 VDD_B.t125 VDD_B.t136 4679.53003704392
Riso3149 VDD_B.t125 VDD_B.t137 4679.53003704392
Riso3150 VDD_B.t125 VDD_B.t139 7331.69113442311
Riso3151 VDD_B.t125 VDD_B.t140 36912.5092819508
Riso3152 VDD_B.t125 VDD_B.t141 46383.2224270732
Riso3153 VDD_B.t125 VDD_B.t143 11057.4779745091
Riso3154 VDD_B.t125 VDD_B.t144 29756.0386782385
Riso3155 VDD_B.t125 VDD_B.t145 22430.8175377455
Riso3156 VDD_B.t125 VDD_B.t147 6111.49606267698
Riso3157 VDD_B.t125 VDD_B.t149 7331.69113442311
Riso3158 VDD_B.t125 VDD_B.t15 2400.93682259086
Riso3159 VDD_B.t125 VDD_B.t150 24810.9625262693
Riso3160 VDD_B.t125 VDD_B.t151 24046.4073776263
Riso3161 VDD_B.t125 VDD_B.t152 43.8208673144471
Riso3162 VDD_B.t125 VDD_B.t153 43643.3386894527
Riso3163 VDD_B.t125 VDD_B.t154 22123.9882529893
Riso3164 VDD_B.t125 VDD_B.t17 3589.67790462952
Riso3165 VDD_B.t125 VDD_B.t18 17466.9234854954
Riso3166 VDD_B.t125 VDD_B.t2 10628.6502802616
Riso3167 VDD_B.t125 VDD_B.t20 8795.37054911095
Riso3168 VDD_B.t125 VDD_B.t22 7243.93844157236
Riso3169 VDD_B.t125 VDD_B.t23 22123.9882529893
Riso3170 VDD_B.t125 VDD_B.t24 162116.926895871
Riso3171 VDD_B.t125 VDD_B.t25 7558.44839075394
Riso3172 VDD_B.t125 VDD_B.t26 8470.76817056889
Riso3173 VDD_B.t125 VDD_B.t27 45993.7736471966
Riso3174 VDD_B.t125 VDD_B.t28 32233.3228082648
Riso3175 VDD_B.t125 VDD_B.t3 297843.117219506
Riso3176 VDD_B.t125 VDD_B.t30 8795.37054911095
Riso3177 VDD_B.t125 VDD_B.t31 6002.51801627347
Riso3178 VDD_B.t125 VDD_B.t32 19.542637238108
Riso3179 VDD_B.t125 VDD_B.t33 7581.34612566423
Riso3180 VDD_B.t125 VDD_B.t34 11529.4693428805
Riso3181 VDD_B.t125 VDD_B.t35 22.0747459292898
Riso3182 VDD_B.t125 VDD_B.t36 44.5422965575793
Riso3183 VDD_B.t125 VDD_B.t37 20866.2815884392
Riso3184 VDD_B.t125 VDD_B.t38 45993.7736471966
Riso3185 VDD_B.t125 VDD_B.t39 38980.7541890445
Riso3186 VDD_B.t125 VDD_B.t4 7558.44839075394
Riso3187 VDD_B.t125 VDD_B.t41 6734.81651363548
Riso3188 VDD_B.t125 VDD_B.t42 20282.9654390809
Riso3189 VDD_B.t125 VDD_B.t43 9426.96999288713
Riso3190 VDD_B.t125 VDD_B.t44 58.0192974898879
Riso3191 VDD_B.t125 VDD_B.t45 183.989386420723
Riso3192 VDD_B.t125 VDD_B.t46 20155.425704556
Riso3193 VDD_B.t125 VDD_B.t47 34640.3293852641
Riso3194 VDD_B.t125 VDD_B.t48 30120.9287735881
Riso3195 VDD_B.t125 VDD_B.t49 40233.4611039427
Riso3196 VDD_B.t125 VDD_B.t50 46321.9500140654
Riso3197 VDD_B.t125 VDD_B.t51 6002.51801627347
Riso3198 VDD_B.t125 VDD_B.t52 40233.4611039427
Riso3199 VDD_B.t125 VDD_B.t53 44914.7015969844
Riso3200 VDD_B.t125 VDD_B.t55 7243.93844157236
Riso3201 VDD_B.t125 VDD_B.t56 26035.0674661723
Riso3202 VDD_B.t125 VDD_B.t57 32156.0589472308
Riso3203 VDD_B.t125 VDD_B.t58 563678.046229715
Riso3204 VDD_B.t125 VDD_B.t59 3229.65569252147
Riso3205 VDD_B.t125 VDD_B.t6 4773.91074296925
Riso3206 VDD_B.t125 VDD_B.t60 36912.5092819508
Riso3207 VDD_B.t125 VDD_B.t61 11529.4693428805
Riso3208 VDD_B.t125 VDD_B.t62 6758.93419328176
Riso3209 VDD_B.t125 VDD_B.t63 20282.9654390809
Riso3210 VDD_B.t125 VDD_B.t64 6480.61721159209
Riso3211 VDD_B.t125 VDD_B.t66 3943.75957862959
Riso3212 VDD_B.t125 VDD_B.t67 22430.8175377455
Riso3213 VDD_B.t125 VDD_B.t68 24810.9625262693
Riso3214 VDD_B.t125 VDD_B.t69 7581.34612566423
Riso3215 VDD_B.t125 VDD_B.t70 16882.3311593749
Riso3216 VDD_B.t125 VDD_B.t71 51.9226705038297
Riso3217 VDD_B.t125 VDD_B.t73 6734.81651363548
Riso3218 VDD_B.t125 VDD_B.t75 3943.75957862959
Riso3219 VDD_B.t125 VDD_B.t76 45160.4825992924
Riso3220 VDD_B.t125 VDD_B.t77 45822.4055168295
Riso3221 VDD_B.t125 VDD_B.t78 46321.9500140654
Riso3222 VDD_B.t125 VDD_B.t79 38980.7541890445
Riso3223 VDD_B.t125 VDD_B.t8 10628.6502802616
Riso3224 VDD_B.t125 VDD_B.t80 30120.9287735881
Riso3225 VDD_B.t125 VDD_B.t81 61.4759675673439
Riso3226 VDD_B.t125 VDD_B.t82 95.0349593985525
Riso3227 VDD_B.t125 VDD_B.t83 32233.3228082648
Riso3228 VDD_B.t125 VDD_B.t85 11057.4779745091
Riso3229 VDD_B.t125 VDD_B.t86 46383.2224270732
Riso3230 VDD_B.t125 VDD_B.t87 5310.2111052715
Riso3231 VDD_B.t125 VDD_B.t88 45822.4055168295
Riso3232 VDD_B.t125 VDD_B.t89 24046.4073776263
Riso3233 VDD_B.t125 VDD_B.t9 42062.908281791
Riso3234 VDD_B.t125 VDD_B.t90 6758.93419328176
Riso3235 VDD_B.t125 VDD_B.t91 18533.637409038
Riso3236 VDD_B.t125 VDD_B.t92 43643.3386894527
Riso3237 VDD_B.t125 VDD_B.t94 9791.36783189634
Riso3238 VDD_B.t125 VDD_B.t95 19556.6819138962
Riso3239 VDD_B.t125 VDD_B.t96 62.293698232852
Riso3240 VDD_B.t125 VDD_B.t97 59.7203187672637
Riso3241 VDD_B.t125 VDD_B.t99 9791.36783189634
Riso3242 VDD_B.t126 VDD_B.t127 144006.330404307
Riso3243 VDD_B.t126 VDD_B.t128 895.823070562989
Riso3244 VDD_B.t126 VDD_B.t13 3014.00573942942
Riso3245 VDD_B.t126 VDD_B.t130 1901.11952614194
Riso3246 VDD_B.t126 VDD_B.t132 1901.11952614194
Riso3247 VDD_B.t126 VDD_B.t134 2005.42863814172
Riso3248 VDD_B.t126 VDD_B.t135 168.022790599014
Riso3249 VDD_B.t126 VDD_B.t136 610.258082689912
Riso3250 VDD_B.t126 VDD_B.t137 610.258082689912
Riso3251 VDD_B.t126 VDD_B.t139 3539.73145788197
Riso3252 VDD_B.t126 VDD_B.t140 30.9287766805385
Riso3253 VDD_B.t126 VDD_B.t141 27.9728179419341
Riso3254 VDD_B.t126 VDD_B.t143 3400.10769228096
Riso3255 VDD_B.t126 VDD_B.t144 45.4483352680896
Riso3256 VDD_B.t126 VDD_B.t145 57.8559114334809
Riso3257 VDD_B.t126 VDD_B.t147 3014.00573942942
Riso3258 VDD_B.t126 VDD_B.t149 3539.73145788197
Riso3259 VDD_B.t126 VDD_B.t15 1223.4231527406
Riso3260 VDD_B.t126 VDD_B.t150 54.4395134722433
Riso3261 VDD_B.t126 VDD_B.t151 188.200065825244
Riso3262 VDD_B.t126 VDD_B.t152 33281.416662574
Riso3263 VDD_B.t126 VDD_B.t153 52.5497615006887
Riso3264 VDD_B.t126 VDD_B.t154 209.825870241004
Riso3265 VDD_B.t126 VDD_B.t17 2005.42863814172
Riso3266 VDD_B.t126 VDD_B.t18 52.2231360976985
Riso3267 VDD_B.t126 VDD_B.t2 2755.91820421393
Riso3268 VDD_B.t126 VDD_B.t20 2027.72742366916
Riso3269 VDD_B.t126 VDD_B.t22 3310.69579519395
Riso3270 VDD_B.t126 VDD_B.t23 209.825870241004
Riso3271 VDD_B.t126 VDD_B.t24 76132.3746777111
Riso3272 VDD_B.t126 VDD_B.t25 3556.70538156184
Riso3273 VDD_B.t126 VDD_B.t26 499.464787348945
Riso3274 VDD_B.t126 VDD_B.t27 23.5982861009974
Riso3275 VDD_B.t126 VDD_B.t28 40.5024717574485
Riso3276 VDD_B.t126 VDD_B.t3 139871.290614197
Riso3277 VDD_B.t126 VDD_B.t30 2027.72742366916
Riso3278 VDD_B.t126 VDD_B.t31 581.853067022372
Riso3279 VDD_B.t126 VDD_B.t32 18562.0991147458
Riso3280 VDD_B.t126 VDD_B.t33 530.346826610145
Riso3281 VDD_B.t126 VDD_B.t34 399.94267042717
Riso3282 VDD_B.t126 VDD_B.t35 31037.3220460227
Riso3283 VDD_B.t126 VDD_B.t36 32756.5265938183
Riso3284 VDD_B.t126 VDD_B.t37 11.6070488777141
Riso3285 VDD_B.t126 VDD_B.t38 23.5982861009974
Riso3286 VDD_B.t126 VDD_B.t39 26.5999110277434
Riso3287 VDD_B.t126 VDD_B.t4 3556.70538156184
Riso3288 VDD_B.t126 VDD_B.t41 1457.51424949112
Riso3289 VDD_B.t126 VDD_B.t42 232.819648900151
Riso3290 VDD_B.t126 VDD_B.t43 466.809318443477
Riso3291 VDD_B.t126 VDD_B.t44 42691.4156822175
Riso3292 VDD_B.t126 VDD_B.t45 125325.380101789
Riso3293 VDD_B.t126 VDD_B.t46 60.1337537300492
Riso3294 VDD_B.t126 VDD_B.t47 35.6024053309566
Riso3295 VDD_B.t126 VDD_B.t48 132.121574710178
Riso3296 VDD_B.t126 VDD_B.t49 69.4149128228061
Riso3297 VDD_B.t126 VDD_B.t50 33.0072093587148
Riso3298 VDD_B.t126 VDD_B.t51 581.853067022372
Riso3299 VDD_B.t126 VDD_B.t52 69.4149128228061
Riso3300 VDD_B.t126 VDD_B.t53 45.2616314999763
Riso3301 VDD_B.t126 VDD_B.t55 3310.69579519395
Riso3302 VDD_B.t126 VDD_B.t56 168.022790599014
Riso3303 VDD_B.t126 VDD_B.t57 116.375853803623
Riso3304 VDD_B.t126 VDD_B.t58 118907.762243683
Riso3305 VDD_B.t126 VDD_B.t59 684.056087125482
Riso3306 VDD_B.t126 VDD_B.t6 2388.63608035019
Riso3307 VDD_B.t126 VDD_B.t60 30.9287766805385
Riso3308 VDD_B.t126 VDD_B.t61 399.94267042717
Riso3309 VDD_B.t126 VDD_B.t62 558.263223101847
Riso3310 VDD_B.t126 VDD_B.t63 232.819648900151
Riso3311 VDD_B.t126 VDD_B.t64 187.871951657853
Riso3312 VDD_B.t126 VDD_B.t66 2067.33456269218
Riso3313 VDD_B.t126 VDD_B.t67 57.8559114334809
Riso3314 VDD_B.t126 VDD_B.t68 54.4395134722433
Riso3315 VDD_B.t126 VDD_B.t69 530.346826610145
Riso3316 VDD_B.t126 VDD_B.t70 282.272806487867
Riso3317 VDD_B.t126 VDD_B.t71 17761.4196274859
Riso3318 VDD_B.t126 VDD_B.t73 1457.51424949112
Riso3319 VDD_B.t126 VDD_B.t75 2067.33456269218
Riso3320 VDD_B.t126 VDD_B.t76 19.823788161025
Riso3321 VDD_B.t126 VDD_B.t77 38.7557181199883
Riso3322 VDD_B.t126 VDD_B.t78 33.0072093587148
Riso3323 VDD_B.t126 VDD_B.t79 26.5999110277434
Riso3324 VDD_B.t126 VDD_B.t8 2755.91820421393
Riso3325 VDD_B.t126 VDD_B.t80 132.121574710178
Riso3326 VDD_B.t126 VDD_B.t81 45181.8927123109
Riso3327 VDD_B.t126 VDD_B.t82 6961.01541343
Riso3328 VDD_B.t126 VDD_B.t83 40.5024717574485
Riso3329 VDD_B.t126 VDD_B.t85 3400.10769228096
Riso3330 VDD_B.t126 VDD_B.t86 27.9728179419341
Riso3331 VDD_B.t126 VDD_B.t87 599.660541549337
Riso3332 VDD_B.t126 VDD_B.t88 38.7557181199883
Riso3333 VDD_B.t126 VDD_B.t89 188.200065825244
Riso3334 VDD_B.t126 VDD_B.t9 60.6162249794129
Riso3335 VDD_B.t126 VDD_B.t90 558.263223101847
Riso3336 VDD_B.t126 VDD_B.t91 257.041176125338
Riso3337 VDD_B.t126 VDD_B.t92 52.5497615006887
Riso3338 VDD_B.t126 VDD_B.t94 3632.95262166593
Riso3339 VDD_B.t126 VDD_B.t95 40.3456360093982
Riso3340 VDD_B.t126 VDD_B.t96 9343.09848201333
Riso3341 VDD_B.t126 VDD_B.t97 13411.6719447842
Riso3342 VDD_B.t126 VDD_B.t99 3632.95262166593
Riso3343 VDD_B.t127 VDD_B.t128 1383.66001391415
Riso3344 VDD_B.t127 VDD_B.t129 158.648
Riso3345 VDD_B.t127 VDD_B.t13 28637.3177498139
Riso3346 VDD_B.t127 VDD_B.t130 3892.52460574315
Riso3347 VDD_B.t127 VDD_B.t132 3892.52460574315
Riso3348 VDD_B.t127 VDD_B.t134 6737.9511775876
Riso3349 VDD_B.t127 VDD_B.t135 189291.342363405
Riso3350 VDD_B.t127 VDD_B.t136 34465.5966305463
Riso3351 VDD_B.t127 VDD_B.t137 34465.5966305463
Riso3352 VDD_B.t127 VDD_B.t139 40796.5270718623
Riso3353 VDD_B.t127 VDD_B.t140 224725.149709972
Riso3354 VDD_B.t127 VDD_B.t141 310081.630031624
Riso3355 VDD_B.t127 VDD_B.t143 158171.079084387
Riso3356 VDD_B.t127 VDD_B.t144 175678.034336638
Riso3357 VDD_B.t127 VDD_B.t145 129478.328727129
Riso3358 VDD_B.t127 VDD_B.t147 28637.3177498139
Riso3359 VDD_B.t127 VDD_B.t149 40796.5270718623
Riso3360 VDD_B.t127 VDD_B.t15 8425.28171555533
Riso3361 VDD_B.t127 VDD_B.t150 144168.440388349
Riso3362 VDD_B.t127 VDD_B.t151 174810.177267333
Riso3363 VDD_B.t127 VDD_B.t152 308066.809499623
Riso3364 VDD_B.t127 VDD_B.t153 305793.2202708
Riso3365 VDD_B.t127 VDD_B.t154 160748.925037937
Riso3366 VDD_B.t127 VDD_B.t17 6737.9511775876
Riso3367 VDD_B.t127 VDD_B.t18 126174.38582015
Riso3368 VDD_B.t127 VDD_B.t2 174828.446043972
Riso3369 VDD_B.t127 VDD_B.t20 164259.518633265
Riso3370 VDD_B.t127 VDD_B.t22 72309.8885505396
Riso3371 VDD_B.t127 VDD_B.t23 160748.925037937
Riso3372 VDD_B.t127 VDD_B.t24 1170644.63896498
Riso3373 VDD_B.t127 VDD_B.t25 54755.8791130092
Riso3374 VDD_B.t127 VDD_B.t26 61384.527119196
Riso3375 VDD_B.t127 VDD_B.t27 303245.149131667
Riso3376 VDD_B.t127 VDD_B.t28 192091.572452306
Riso3377 VDD_B.t127 VDD_B.t3 2150722.0442785
Riso3378 VDD_B.t127 VDD_B.t30 164259.518633265
Riso3379 VDD_B.t127 VDD_B.t31 43831.9050363634
Riso3380 VDD_B.t127 VDD_B.t32 171818.607058454
Riso3381 VDD_B.t127 VDD_B.t33 55043.2316260469
Riso3382 VDD_B.t127 VDD_B.t34 83358.4497193377
Riso3383 VDD_B.t127 VDD_B.t35 287294.524601256
Riso3384 VDD_B.t127 VDD_B.t36 303208.205959425
Riso3385 VDD_B.t127 VDD_B.t37 130149.576999582
Riso3386 VDD_B.t127 VDD_B.t38 303245.149131667
Riso3387 VDD_B.t127 VDD_B.t39 240140.57572091
Riso3388 VDD_B.t127 VDD_B.t4 54755.8791130092
Riso3389 VDD_B.t127 VDD_B.t41 136672.929464505
Riso3390 VDD_B.t127 VDD_B.t42 147254.483197732
Riso3391 VDD_B.t127 VDD_B.t43 68225.5512678732
Riso3392 VDD_B.t127 VDD_B.t44 395169.723560251
Riso3393 VDD_B.t127 VDD_B.t45 1160064.50052057
Riso3394 VDD_B.t127 VDD_B.t46 115672.637105716
Riso3395 VDD_B.t127 VDD_B.t47 208564.213087038
Riso3396 VDD_B.t127 VDD_B.t48 218658.755109732
Riso3397 VDD_B.t127 VDD_B.t49 286418.486977586
Riso3398 VDD_B.t127 VDD_B.t50 313805.349730341
Riso3399 VDD_B.t127 VDD_B.t51 43831.9050363634
Riso3400 VDD_B.t127 VDD_B.t52 286418.486977586
Riso3401 VDD_B.t127 VDD_B.t53 311562.459215255
Riso3402 VDD_B.t127 VDD_B.t55 72309.8885505396
Riso3403 VDD_B.t127 VDD_B.t56 189291.342363405
Riso3404 VDD_B.t127 VDD_B.t57 232971.867173117
Riso3405 VDD_B.t127 VDD_B.t58 11835601.5424491
Riso3406 VDD_B.t127 VDD_B.t59 67615.2801456152
Riso3407 VDD_B.t127 VDD_B.t6 20018.2881152651
Riso3408 VDD_B.t127 VDD_B.t60 224725.149709972
Riso3409 VDD_B.t127 VDD_B.t61 83358.4497193377
Riso3410 VDD_B.t127 VDD_B.t62 49196.8570615134
Riso3411 VDD_B.t127 VDD_B.t63 147254.483197732
Riso3412 VDD_B.t127 VDD_B.t64 46863.2156993053
Riso3413 VDD_B.t127 VDD_B.t66 10876.4173274072
Riso3414 VDD_B.t127 VDD_B.t67 129478.328727129
Riso3415 VDD_B.t127 VDD_B.t68 144168.440388349
Riso3416 VDD_B.t127 VDD_B.t69 55043.2316260469
Riso3417 VDD_B.t127 VDD_B.t70 122334.731634787
Riso3418 VDD_B.t127 VDD_B.t71 164407.180508535
Riso3419 VDD_B.t127 VDD_B.t73 136672.929464505
Riso3420 VDD_B.t127 VDD_B.t75 10876.4173274072
Riso3421 VDD_B.t127 VDD_B.t76 293560.819355714
Riso3422 VDD_B.t127 VDD_B.t77 314290.493748
Riso3423 VDD_B.t127 VDD_B.t78 313805.349730341
Riso3424 VDD_B.t127 VDD_B.t79 240140.57572091
Riso3425 VDD_B.t127 VDD_B.t8 174828.446043972
Riso3426 VDD_B.t127 VDD_B.t80 218658.755109732
Riso3427 VDD_B.t127 VDD_B.t81 418222.627845295
Riso3428 VDD_B.t127 VDD_B.t82 64434.0903824743
Riso3429 VDD_B.t127 VDD_B.t83 192091.572452306
Riso3430 VDD_B.t127 VDD_B.t85 158171.079084387
Riso3431 VDD_B.t127 VDD_B.t86 310081.630031624
Riso3432 VDD_B.t127 VDD_B.t87 38929.1080994829
Riso3433 VDD_B.t127 VDD_B.t88 314290.493748
Riso3434 VDD_B.t127 VDD_B.t89 174810.177267333
Riso3435 VDD_B.t127 VDD_B.t9 297281.021790113
Riso3436 VDD_B.t127 VDD_B.t90 49196.8570615134
Riso3437 VDD_B.t127 VDD_B.t91 134428.437583661
Riso3438 VDD_B.t127 VDD_B.t92 305793.2202708
Riso3439 VDD_B.t127 VDD_B.t94 125042.993569639
Riso3440 VDD_B.t127 VDD_B.t95 140039.791812528
Riso3441 VDD_B.t127 VDD_B.t96 86483.6545083537
Riso3442 VDD_B.t127 VDD_B.t97 124144.084008644
Riso3443 VDD_B.t127 VDD_B.t99 125042.993569639
Riso3444 VDD_B.t128 VDD_B.t13 144.599151880413
Riso3445 VDD_B.t128 VDD_B.t130 18.4161229416952
Riso3446 VDD_B.t128 VDD_B.t132 18.4161229416952
Riso3447 VDD_B.t128 VDD_B.t134 32.1991036656354
Riso3448 VDD_B.t128 VDD_B.t135 1062.54223409654
Riso3449 VDD_B.t128 VDD_B.t136 191.003886262902
Riso3450 VDD_B.t128 VDD_B.t137 191.003886262902
Riso3451 VDD_B.t128 VDD_B.t139 211.697453182307
Riso3452 VDD_B.t128 VDD_B.t140 1433.69059777007
Riso3453 VDD_B.t128 VDD_B.t141 1883.34015459153
Riso3454 VDD_B.t128 VDD_B.t143 884.092221498782
Riso3455 VDD_B.t128 VDD_B.t144 1135.39919144796
Riso3456 VDD_B.t128 VDD_B.t145 843.817131127967
Riso3457 VDD_B.t128 VDD_B.t147 144.599151880413
Riso3458 VDD_B.t128 VDD_B.t149 211.697453182307
Riso3459 VDD_B.t128 VDD_B.t15 41.4040436000222
Riso3460 VDD_B.t128 VDD_B.t150 937.365036479343
Riso3461 VDD_B.t128 VDD_B.t151 978.740935721696
Riso3462 VDD_B.t128 VDD_B.t152 1979.4815769681
Riso3463 VDD_B.t128 VDD_B.t153 1797.47505544569
Riso3464 VDD_B.t128 VDD_B.t154 898.055870629436
Riso3465 VDD_B.t128 VDD_B.t17 32.1991036656354
Riso3466 VDD_B.t128 VDD_B.t18 718.885363454882
Riso3467 VDD_B.t128 VDD_B.t2 980.917546174392
Riso3468 VDD_B.t128 VDD_B.t20 925.275441738159
Riso3469 VDD_B.t128 VDD_B.t22 400.753568841369
Riso3470 VDD_B.t128 VDD_B.t23 898.055870629436
Riso3471 VDD_B.t128 VDD_B.t24 6595.31715806696
Riso3472 VDD_B.t128 VDD_B.t25 300.013891723493
Riso3473 VDD_B.t128 VDD_B.t26 340.03045456973
Riso3474 VDD_B.t128 VDD_B.t27 1857.13793811902
Riso3475 VDD_B.t128 VDD_B.t28 1236.81869984458
Riso3476 VDD_B.t128 VDD_B.t3 12116.9939439556
Riso3477 VDD_B.t128 VDD_B.t30 925.275441738159
Riso3478 VDD_B.t128 VDD_B.t31 242.811895784401
Riso3479 VDD_B.t128 VDD_B.t32 1104.01950734309
Riso3480 VDD_B.t128 VDD_B.t33 304.882754879678
Riso3481 VDD_B.t128 VDD_B.t34 462.136285116347
Riso3482 VDD_B.t128 VDD_B.t35 1846.00937548481
Riso3483 VDD_B.t128 VDD_B.t36 1948.26264684956
Riso3484 VDD_B.t128 VDD_B.t37 820.880789942726
Riso3485 VDD_B.t128 VDD_B.t38 1857.13793811902
Riso3486 VDD_B.t128 VDD_B.t39 1523.71120081673
Riso3487 VDD_B.t128 VDD_B.t4 300.013891723493
Riso3488 VDD_B.t128 VDD_B.t41 772.106387179904
Riso3489 VDD_B.t128 VDD_B.t42 821.161310917859
Riso3490 VDD_B.t128 VDD_B.t43 377.987999737277
Riso3491 VDD_B.t128 VDD_B.t44 2539.16086849354
Riso3492 VDD_B.t128 VDD_B.t45 7453.98801839435
Riso3493 VDD_B.t128 VDD_B.t46 755.315692909071
Riso3494 VDD_B.t128 VDD_B.t47 1337.10109999738
Riso3495 VDD_B.t128 VDD_B.t48 1235.34338433163
Riso3496 VDD_B.t128 VDD_B.t49 1659.86834280553
Riso3497 VDD_B.t128 VDD_B.t50 1890.01446665939
Riso3498 VDD_B.t128 VDD_B.t51 242.811895784401
Riso3499 VDD_B.t128 VDD_B.t52 1659.86834280553
Riso3500 VDD_B.t128 VDD_B.t53 1845.76712671721
Riso3501 VDD_B.t128 VDD_B.t55 400.753568841369
Riso3502 VDD_B.t128 VDD_B.t56 1062.54223409654
Riso3503 VDD_B.t128 VDD_B.t57 1321.43378136403
Riso3504 VDD_B.t128 VDD_B.t58 66958.9921399916
Riso3505 VDD_B.t128 VDD_B.t59 382.419948990783
Riso3506 VDD_B.t128 VDD_B.t6 99.6970535203702
Riso3507 VDD_B.t128 VDD_B.t60 1433.69059777007
Riso3508 VDD_B.t128 VDD_B.t61 462.136285116347
Riso3509 VDD_B.t128 VDD_B.t62 272.504936387164
Riso3510 VDD_B.t128 VDD_B.t63 821.161310917859
Riso3511 VDD_B.t128 VDD_B.t64 259.944661319941
Riso3512 VDD_B.t128 VDD_B.t66 52.7511846854489
Riso3513 VDD_B.t128 VDD_B.t67 843.817131127967
Riso3514 VDD_B.t128 VDD_B.t68 937.365036479343
Riso3515 VDD_B.t128 VDD_B.t69 304.882754879678
Riso3516 VDD_B.t128 VDD_B.t70 680.301427024983
Riso3517 VDD_B.t128 VDD_B.t71 1056.39742712469
Riso3518 VDD_B.t128 VDD_B.t73 772.106387179904
Riso3519 VDD_B.t128 VDD_B.t75 52.7511846854489
Riso3520 VDD_B.t128 VDD_B.t76 1812.30034386162
Riso3521 VDD_B.t128 VDD_B.t77 1877.18298261331
Riso3522 VDD_B.t128 VDD_B.t78 1890.01446665939
Riso3523 VDD_B.t128 VDD_B.t79 1523.71120081673
Riso3524 VDD_B.t128 VDD_B.t8 980.917546174392
Riso3525 VDD_B.t128 VDD_B.t80 1235.34338433163
Riso3526 VDD_B.t128 VDD_B.t81 2687.28717720551
Riso3527 VDD_B.t128 VDD_B.t82 414.020890624252
Riso3528 VDD_B.t128 VDD_B.t83 1236.81869984458
Riso3529 VDD_B.t128 VDD_B.t85 884.092221498782
Riso3530 VDD_B.t128 VDD_B.t86 1883.34015459153
Riso3531 VDD_B.t128 VDD_B.t87 215.689053520179
Riso3532 VDD_B.t128 VDD_B.t88 1877.18298261331
Riso3533 VDD_B.t128 VDD_B.t89 978.740935721696
Riso3534 VDD_B.t128 VDD_B.t9 1734.61485520325
Riso3535 VDD_B.t128 VDD_B.t90 272.504936387164
Riso3536 VDD_B.t128 VDD_B.t91 748.494579793109
Riso3537 VDD_B.t128 VDD_B.t92 1797.47505544569
Riso3538 VDD_B.t128 VDD_B.t94 697.033442689322
Riso3539 VDD_B.t128 VDD_B.t95 806.531778510729
Riso3540 VDD_B.t128 VDD_B.t96 555.700242704563
Riso3541 VDD_B.t128 VDD_B.t97 797.68712372435
Riso3542 VDD_B.t128 VDD_B.t99 697.033442689322
Riso3543 VDD_B.t129 VDD_B.t131 158.648
Riso3544 VDD_B.t13 VDD_B.t130 211.946732640235
Riso3545 VDD_B.t13 VDD_B.t132 211.946732640235
Riso3546 VDD_B.t13 VDD_B.t134 160.479361147038
Riso3547 VDD_B.t13 VDD_B.t135 2024.05714461873
Riso3548 VDD_B.t13 VDD_B.t136 296.775283646057
Riso3549 VDD_B.t13 VDD_B.t137 296.775283646057
Riso3550 VDD_B.t13 VDD_B.t139 47.3393741975516
Riso3551 VDD_B.t13 VDD_B.t140 6043.76438338417
Riso3552 VDD_B.t13 VDD_B.t141 5350.58822273581
Riso3553 VDD_B.t13 VDD_B.t143 428.851045801178
Riso3554 VDD_B.t13 VDD_B.t144 5532.3088306395
Riso3555 VDD_B.t13 VDD_B.t145 4585.56082020772
Riso3556 VDD_B.t13 VDD_B.t147 0.82408937054833
Riso3557 VDD_B.t13 VDD_B.t149 47.3393741975516
Riso3558 VDD_B.t13 VDD_B.t15 49.6856450324829
Riso3559 VDD_B.t13 VDD_B.t150 4933.0676265817
Riso3560 VDD_B.t13 VDD_B.t151 1840.74735829728
Riso3561 VDD_B.t13 VDD_B.t152 9052.00916087726
Riso3562 VDD_B.t13 VDD_B.t153 4238.97809765302
Riso3563 VDD_B.t13 VDD_B.t154 1669.25123760815
Riso3564 VDD_B.t13 VDD_B.t17 160.479361147038
Riso3565 VDD_B.t13 VDD_B.t18 1464.25829213844
Riso3566 VDD_B.t13 VDD_B.t2 593.269686855544
Riso3567 VDD_B.t13 VDD_B.t20 754.544668530589
Riso3568 VDD_B.t13 VDD_B.t22 131.334808869135
Riso3569 VDD_B.t13 VDD_B.t23 1669.25123760815
Riso3570 VDD_B.t13 VDD_B.t24 1748.15369683821
Riso3571 VDD_B.t13 VDD_B.t25 77.7815588989127
Riso3572 VDD_B.t13 VDD_B.t26 569.552176679536
Riso3573 VDD_B.t13 VDD_B.t27 5572.8805512446
Riso3574 VDD_B.t13 VDD_B.t28 5762.79630771898
Riso3575 VDD_B.t13 VDD_B.t3 3211.72845066038
Riso3576 VDD_B.t13 VDD_B.t30 754.544668530589
Riso3577 VDD_B.t13 VDD_B.t31 389.859861551068
Riso3578 VDD_B.t13 VDD_B.t32 5048.59191948817
Riso3579 VDD_B.t13 VDD_B.t33 504.0016272425
Riso3580 VDD_B.t13 VDD_B.t34 800.716692675816
Riso3581 VDD_B.t13 VDD_B.t35 8441.65157806015
Riso3582 VDD_B.t13 VDD_B.t36 8909.24751827649
Riso3583 VDD_B.t13 VDD_B.t37 3101.08277191578
Riso3584 VDD_B.t13 VDD_B.t38 5572.8805512446
Riso3585 VDD_B.t13 VDD_B.t39 6085.2204956611
Riso3586 VDD_B.t13 VDD_B.t4 77.7815588989127
Riso3587 VDD_B.t13 VDD_B.t41 844.908188301184
Riso3588 VDD_B.t13 VDD_B.t42 1509.61011424844
Riso3589 VDD_B.t13 VDD_B.t43 640.91542505597
Riso3590 VDD_B.t13 VDD_B.t44 11611.3772969532
Riso3591 VDD_B.t13 VDD_B.t45 34086.4843667409
Riso3592 VDD_B.t13 VDD_B.t46 4220.84287387213
Riso3593 VDD_B.t13 VDD_B.t47 5935.2894563017
Riso3594 VDD_B.t13 VDD_B.t48 2424.2794746882
Riso3595 VDD_B.t13 VDD_B.t49 3651.99504016286
Riso3596 VDD_B.t13 VDD_B.t50 5097.59981473216
Riso3597 VDD_B.t13 VDD_B.t51 389.859861551068
Riso3598 VDD_B.t13 VDD_B.t52 3651.99504016286
Riso3599 VDD_B.t13 VDD_B.t53 4534.13568063325
Riso3600 VDD_B.t13 VDD_B.t55 131.334808869135
Riso3601 VDD_B.t13 VDD_B.t56 2024.05714461873
Riso3602 VDD_B.t13 VDD_B.t57 2639.11109882649
Riso3603 VDD_B.t13 VDD_B.t58 85816.9576592992
Riso3604 VDD_B.t13 VDD_B.t59 484.458080000663
Riso3605 VDD_B.t13 VDD_B.t6 53.8266484552416
Riso3606 VDD_B.t13 VDD_B.t60 6043.76438338417
Riso3607 VDD_B.t13 VDD_B.t61 800.716692675816
Riso3608 VDD_B.t13 VDD_B.t62 444.167581614226
Riso3609 VDD_B.t13 VDD_B.t63 1509.61011424844
Riso3610 VDD_B.t13 VDD_B.t64 454.630895871234
Riso3611 VDD_B.t13 VDD_B.t66 120.164502368044
Riso3612 VDD_B.t13 VDD_B.t67 4585.56082020772
Riso3613 VDD_B.t13 VDD_B.t68 4933.0676265817
Riso3614 VDD_B.t13 VDD_B.t69 504.0016272425
Riso3615 VDD_B.t13 VDD_B.t70 1224.97997418717
Riso3616 VDD_B.t13 VDD_B.t71 4830.81999808578
Riso3617 VDD_B.t13 VDD_B.t73 844.908188301184
Riso3618 VDD_B.t13 VDD_B.t75 120.164502368044
Riso3619 VDD_B.t13 VDD_B.t76 5755.46032526998
Riso3620 VDD_B.t13 VDD_B.t77 4822.7332605663
Riso3621 VDD_B.t13 VDD_B.t78 5097.59981473216
Riso3622 VDD_B.t13 VDD_B.t79 6085.2204956611
Riso3623 VDD_B.t13 VDD_B.t8 593.269686855544
Riso3624 VDD_B.t13 VDD_B.t80 2424.2794746882
Riso3625 VDD_B.t13 VDD_B.t81 12288.7469269759
Riso3626 VDD_B.t13 VDD_B.t82 1893.28404887988
Riso3627 VDD_B.t13 VDD_B.t83 5762.79630771898
Riso3628 VDD_B.t13 VDD_B.t85 428.851045801178
Riso3629 VDD_B.t13 VDD_B.t86 5350.58822273581
Riso3630 VDD_B.t13 VDD_B.t87 340.8262414436
Riso3631 VDD_B.t13 VDD_B.t88 4822.7332605663
Riso3632 VDD_B.t13 VDD_B.t89 1840.74735829728
Riso3633 VDD_B.t13 VDD_B.t9 3943.30305273302
Riso3634 VDD_B.t13 VDD_B.t90 444.167581614226
Riso3635 VDD_B.t13 VDD_B.t91 1361.6360696866
Riso3636 VDD_B.t13 VDD_B.t92 4238.97809765302
Riso3637 VDD_B.t13 VDD_B.t94 296.414519786998
Riso3638 VDD_B.t13 VDD_B.t95 1723.9643017039
Riso3639 VDD_B.t13 VDD_B.t96 2541.17226762372
Riso3640 VDD_B.t13 VDD_B.t97 3647.7587038351
Riso3641 VDD_B.t13 VDD_B.t99 296.414519786998
Riso3642 VDD_B.t130 VDD_B.t132 0.819740602857732
Riso3643 VDD_B.t130 VDD_B.t134 44.8481049317075
Riso3644 VDD_B.t130 VDD_B.t135 1841.69613825229
Riso3645 VDD_B.t130 VDD_B.t136 323.165214369318
Riso3646 VDD_B.t130 VDD_B.t137 323.165214369318
Riso3647 VDD_B.t130 VDD_B.t139 314.259103045339
Riso3648 VDD_B.t130 VDD_B.t140 3232.51678964575
Riso3649 VDD_B.t130 VDD_B.t141 3791.00090053239
Riso3650 VDD_B.t130 VDD_B.t143 1451.71954379049
Riso3651 VDD_B.t130 VDD_B.t144 2646.46262217298
Riso3652 VDD_B.t130 VDD_B.t145 2011.04090130372
Riso3653 VDD_B.t130 VDD_B.t147 211.946732640235
Riso3654 VDD_B.t130 VDD_B.t149 314.259103045339
Riso3655 VDD_B.t130 VDD_B.t15 59.4658993699918
Riso3656 VDD_B.t130 VDD_B.t150 2219.98248494098
Riso3657 VDD_B.t130 VDD_B.t151 1689.04132743265
Riso3658 VDD_B.t130 VDD_B.t152 4544.95303580934
Riso3659 VDD_B.t130 VDD_B.t153 3386.24648551266
Riso3660 VDD_B.t130 VDD_B.t154 1544.06829415719
Riso3661 VDD_B.t130 VDD_B.t17 44.8481049317075
Riso3662 VDD_B.t130 VDD_B.t18 1278.64992679255
Riso3663 VDD_B.t130 VDD_B.t2 1640.36687767972
Riso3664 VDD_B.t130 VDD_B.t20 1577.7192762678
Riso3665 VDD_B.t130 VDD_B.t22 631.122332374415
Riso3666 VDD_B.t130 VDD_B.t23 1544.06829415719
Riso3667 VDD_B.t130 VDD_B.t24 10109.3675972651
Riso3668 VDD_B.t130 VDD_B.t25 457.484515407217
Riso3669 VDD_B.t130 VDD_B.t26 575.726322512865
Riso3670 VDD_B.t130 VDD_B.t27 3805.59054528616
Riso3671 VDD_B.t130 VDD_B.t28 2854.72363999242
Riso3672 VDD_B.t130 VDD_B.t3 18573.0485763606
Riso3673 VDD_B.t130 VDD_B.t30 1577.7192762678
Riso3674 VDD_B.t130 VDD_B.t31 410.822471970864
Riso3675 VDD_B.t130 VDD_B.t32 2534.86411284371
Riso3676 VDD_B.t130 VDD_B.t33 516.033515723598
Riso3677 VDD_B.t130 VDD_B.t34 783.976605776782
Riso3678 VDD_B.t130 VDD_B.t35 4238.49659065424
Riso3679 VDD_B.t130 VDD_B.t36 4473.2733733826
Riso3680 VDD_B.t130 VDD_B.t37 1799.57440361403
Riso3681 VDD_B.t130 VDD_B.t38 3805.59054528616
Riso3682 VDD_B.t130 VDD_B.t39 3389.34377407676
Riso3683 VDD_B.t130 VDD_B.t4 457.484515407217
Riso3684 VDD_B.t130 VDD_B.t41 1335.74235226808
Riso3685 VDD_B.t130 VDD_B.t42 1407.4609023256
Riso3686 VDD_B.t130 VDD_B.t43 640.304774619426
Riso3687 VDD_B.t130 VDD_B.t44 5829.9945965367
Riso3688 VDD_B.t130 VDD_B.t45 17114.5949865204
Riso3689 VDD_B.t130 VDD_B.t46 1809.68832052827
Riso3690 VDD_B.t130 VDD_B.t47 3052.17242337081
Riso3691 VDD_B.t130 VDD_B.t48 2165.09086523132
Riso3692 VDD_B.t130 VDD_B.t49 3044.39846268247
Riso3693 VDD_B.t130 VDD_B.t50 3737.94072999496
Riso3694 VDD_B.t130 VDD_B.t51 410.822471970864
Riso3695 VDD_B.t130 VDD_B.t52 3044.39846268247
Riso3696 VDD_B.t130 VDD_B.t53 3530.61252334092
Riso3697 VDD_B.t130 VDD_B.t55 631.122332374415
Riso3698 VDD_B.t130 VDD_B.t56 1841.69613825229
Riso3699 VDD_B.t130 VDD_B.t57 2331.96680828033
Riso3700 VDD_B.t130 VDD_B.t58 116570.455303614
Riso3701 VDD_B.t130 VDD_B.t59 665.451663789161
Riso3702 VDD_B.t130 VDD_B.t6 145.05037179205
Riso3703 VDD_B.t130 VDD_B.t60 3232.51678964575
Riso3704 VDD_B.t130 VDD_B.t61 783.976605776782
Riso3705 VDD_B.t130 VDD_B.t62 461.122905389625
Riso3706 VDD_B.t130 VDD_B.t63 1407.4609023256
Riso3707 VDD_B.t130 VDD_B.t64 441.413696989294
Riso3708 VDD_B.t130 VDD_B.t66 74.683638785546
Riso3709 VDD_B.t130 VDD_B.t67 2011.04090130372
Riso3710 VDD_B.t130 VDD_B.t68 2219.98248494098
Riso3711 VDD_B.t130 VDD_B.t69 516.033515723598
Riso3712 VDD_B.t130 VDD_B.t70 1160.46171401355
Riso3713 VDD_B.t130 VDD_B.t71 2425.52229295586
Riso3714 VDD_B.t130 VDD_B.t73 1335.74235226808
Riso3715 VDD_B.t130 VDD_B.t75 74.683638785546
Riso3716 VDD_B.t130 VDD_B.t76 3780.15627402821
Riso3717 VDD_B.t130 VDD_B.t77 3649.63497449538
Riso3718 VDD_B.t130 VDD_B.t78 3737.94072999496
Riso3719 VDD_B.t130 VDD_B.t79 3389.34377407676
Riso3720 VDD_B.t130 VDD_B.t8 1640.36687767972
Riso3721 VDD_B.t130 VDD_B.t80 2165.09086523132
Riso3722 VDD_B.t130 VDD_B.t81 6170.09734075867
Riso3723 VDD_B.t130 VDD_B.t82 950.605211801626
Riso3724 VDD_B.t130 VDD_B.t83 2854.72363999242
Riso3725 VDD_B.t130 VDD_B.t85 1451.71954379049
Riso3726 VDD_B.t130 VDD_B.t86 3791.00090053239
Riso3727 VDD_B.t130 VDD_B.t87 364.916771418873
Riso3728 VDD_B.t130 VDD_B.t88 3649.63497449538
Riso3729 VDD_B.t130 VDD_B.t89 1689.04132743265
Riso3730 VDD_B.t130 VDD_B.t9 3222.27938049246
Riso3731 VDD_B.t130 VDD_B.t90 461.122905389625
Riso3732 VDD_B.t130 VDD_B.t91 1279.56400774347
Riso3733 VDD_B.t130 VDD_B.t92 3386.24648551266
Riso3734 VDD_B.t130 VDD_B.t94 1130.04329556545
Riso3735 VDD_B.t130 VDD_B.t95 1462.49916960652
Riso3736 VDD_B.t130 VDD_B.t96 1275.9055373218
Riso3737 VDD_B.t130 VDD_B.t97 1831.51515870633
Riso3738 VDD_B.t130 VDD_B.t99 1130.04329556545
Riso3739 VDD_B.t131 VDD_B.t133 158.648
Riso3740 VDD_B.t132 VDD_B.t134 44.8481049317075
Riso3741 VDD_B.t132 VDD_B.t135 1841.69613825229
Riso3742 VDD_B.t132 VDD_B.t136 323.165214369318
Riso3743 VDD_B.t132 VDD_B.t137 323.165214369318
Riso3744 VDD_B.t132 VDD_B.t139 314.259103045339
Riso3745 VDD_B.t132 VDD_B.t140 3232.51678964575
Riso3746 VDD_B.t132 VDD_B.t141 3791.00090053239
Riso3747 VDD_B.t132 VDD_B.t143 1451.71954379049
Riso3748 VDD_B.t132 VDD_B.t144 2646.46262217298
Riso3749 VDD_B.t132 VDD_B.t145 2011.04090130372
Riso3750 VDD_B.t132 VDD_B.t147 211.946732640235
Riso3751 VDD_B.t132 VDD_B.t149 314.259103045339
Riso3752 VDD_B.t132 VDD_B.t15 59.4658993699918
Riso3753 VDD_B.t132 VDD_B.t150 2219.98248494098
Riso3754 VDD_B.t132 VDD_B.t151 1689.04132743265
Riso3755 VDD_B.t132 VDD_B.t152 4544.95303580934
Riso3756 VDD_B.t132 VDD_B.t153 3386.24648551266
Riso3757 VDD_B.t132 VDD_B.t154 1544.06829415719
Riso3758 VDD_B.t132 VDD_B.t17 44.8481049317075
Riso3759 VDD_B.t132 VDD_B.t18 1278.64992679255
Riso3760 VDD_B.t132 VDD_B.t2 1640.36687767972
Riso3761 VDD_B.t132 VDD_B.t20 1577.7192762678
Riso3762 VDD_B.t132 VDD_B.t22 631.122332374415
Riso3763 VDD_B.t132 VDD_B.t23 1544.06829415719
Riso3764 VDD_B.t132 VDD_B.t24 10109.3675972651
Riso3765 VDD_B.t132 VDD_B.t25 457.484515407217
Riso3766 VDD_B.t132 VDD_B.t26 575.726322512865
Riso3767 VDD_B.t132 VDD_B.t27 3805.59054528616
Riso3768 VDD_B.t132 VDD_B.t28 2854.72363999242
Riso3769 VDD_B.t132 VDD_B.t3 18573.0485763606
Riso3770 VDD_B.t132 VDD_B.t30 1577.7192762678
Riso3771 VDD_B.t132 VDD_B.t31 410.822471970864
Riso3772 VDD_B.t132 VDD_B.t32 2534.86411284371
Riso3773 VDD_B.t132 VDD_B.t33 516.033515723598
Riso3774 VDD_B.t132 VDD_B.t34 783.976605776782
Riso3775 VDD_B.t132 VDD_B.t35 4238.49659065424
Riso3776 VDD_B.t132 VDD_B.t36 4473.2733733826
Riso3777 VDD_B.t132 VDD_B.t37 1799.57440361403
Riso3778 VDD_B.t132 VDD_B.t38 3805.59054528616
Riso3779 VDD_B.t132 VDD_B.t39 3389.34377407676
Riso3780 VDD_B.t132 VDD_B.t4 457.484515407217
Riso3781 VDD_B.t132 VDD_B.t41 1335.74235226808
Riso3782 VDD_B.t132 VDD_B.t42 1407.4609023256
Riso3783 VDD_B.t132 VDD_B.t43 640.304774619426
Riso3784 VDD_B.t132 VDD_B.t44 5829.9945965367
Riso3785 VDD_B.t132 VDD_B.t45 17114.5949865204
Riso3786 VDD_B.t132 VDD_B.t46 1809.68832052827
Riso3787 VDD_B.t132 VDD_B.t47 3052.17242337081
Riso3788 VDD_B.t132 VDD_B.t48 2165.09086523132
Riso3789 VDD_B.t132 VDD_B.t49 3044.39846268247
Riso3790 VDD_B.t132 VDD_B.t50 3737.94072999496
Riso3791 VDD_B.t132 VDD_B.t51 410.822471970864
Riso3792 VDD_B.t132 VDD_B.t52 3044.39846268247
Riso3793 VDD_B.t132 VDD_B.t53 3530.61252334092
Riso3794 VDD_B.t132 VDD_B.t55 631.122332374415
Riso3795 VDD_B.t132 VDD_B.t56 1841.69613825229
Riso3796 VDD_B.t132 VDD_B.t57 2331.96680828033
Riso3797 VDD_B.t132 VDD_B.t58 116570.455303614
Riso3798 VDD_B.t132 VDD_B.t59 665.451663789161
Riso3799 VDD_B.t132 VDD_B.t6 145.05037179205
Riso3800 VDD_B.t132 VDD_B.t60 3232.51678964575
Riso3801 VDD_B.t132 VDD_B.t61 783.976605776782
Riso3802 VDD_B.t132 VDD_B.t62 461.122905389625
Riso3803 VDD_B.t132 VDD_B.t63 1407.4609023256
Riso3804 VDD_B.t132 VDD_B.t64 441.413696989294
Riso3805 VDD_B.t132 VDD_B.t66 74.683638785546
Riso3806 VDD_B.t132 VDD_B.t67 2011.04090130372
Riso3807 VDD_B.t132 VDD_B.t68 2219.98248494098
Riso3808 VDD_B.t132 VDD_B.t69 516.033515723598
Riso3809 VDD_B.t132 VDD_B.t70 1160.46171401355
Riso3810 VDD_B.t132 VDD_B.t71 2425.52229295586
Riso3811 VDD_B.t132 VDD_B.t73 1335.74235226808
Riso3812 VDD_B.t132 VDD_B.t75 74.683638785546
Riso3813 VDD_B.t132 VDD_B.t76 3780.15627402821
Riso3814 VDD_B.t132 VDD_B.t77 3649.63497449538
Riso3815 VDD_B.t132 VDD_B.t78 3737.94072999496
Riso3816 VDD_B.t132 VDD_B.t79 3389.34377407676
Riso3817 VDD_B.t132 VDD_B.t8 1640.36687767972
Riso3818 VDD_B.t132 VDD_B.t80 2165.09086523132
Riso3819 VDD_B.t132 VDD_B.t81 6170.09734075867
Riso3820 VDD_B.t132 VDD_B.t82 950.605211801626
Riso3821 VDD_B.t132 VDD_B.t83 2854.72363999242
Riso3822 VDD_B.t132 VDD_B.t85 1451.71954379049
Riso3823 VDD_B.t132 VDD_B.t86 3791.00090053239
Riso3824 VDD_B.t132 VDD_B.t87 364.916771418873
Riso3825 VDD_B.t132 VDD_B.t88 3649.63497449538
Riso3826 VDD_B.t132 VDD_B.t89 1689.04132743265
Riso3827 VDD_B.t132 VDD_B.t9 3222.27938049246
Riso3828 VDD_B.t132 VDD_B.t90 461.122905389625
Riso3829 VDD_B.t132 VDD_B.t91 1279.56400774347
Riso3830 VDD_B.t132 VDD_B.t92 3386.24648551266
Riso3831 VDD_B.t132 VDD_B.t94 1130.04329556545
Riso3832 VDD_B.t132 VDD_B.t95 1462.49916960652
Riso3833 VDD_B.t132 VDD_B.t96 1275.9055373218
Riso3834 VDD_B.t132 VDD_B.t97 1831.51515870633
Riso3835 VDD_B.t132 VDD_B.t99 1130.04329556545
Riso3836 VDD_B.t133 VDD_B.t16 158.648
Riso3837 VDD_B.t134 VDD_B.t135 1592.62101296725
Riso3838 VDD_B.t134 VDD_B.t136 274.080330183662
Riso3839 VDD_B.t134 VDD_B.t137 274.080330183662
Riso3840 VDD_B.t134 VDD_B.t139 239.987838373831
Riso3841 VDD_B.t134 VDD_B.t140 3685.9111664088
Riso3842 VDD_B.t134 VDD_B.t141 3766.33188703317
Riso3843 VDD_B.t134 VDD_B.t143 1195.94765248677
Riso3844 VDD_B.t134 VDD_B.t144 3165.01222825586
Riso3845 VDD_B.t134 VDD_B.t145 2488.68419519995
Riso3846 VDD_B.t134 VDD_B.t147 160.479361147038
Riso3847 VDD_B.t134 VDD_B.t149 239.987838373831
Riso3848 VDD_B.t134 VDD_B.t15 44.0786645118433
Riso3849 VDD_B.t134 VDD_B.t150 2720.28463465114
Riso3850 VDD_B.t134 VDD_B.t151 1455.50011097894
Riso3851 VDD_B.t134 VDD_B.t152 5316.83190892412
Riso3852 VDD_B.t134 VDD_B.t153 3148.00161807525
Riso3853 VDD_B.t134 VDD_B.t154 1326.65025395191
Riso3854 VDD_B.t134 VDD_B.t17 0.825300965877359
Riso3855 VDD_B.t134 VDD_B.t18 1129.48020855904
Riso3856 VDD_B.t134 VDD_B.t2 1372.077899053
Riso3857 VDD_B.t134 VDD_B.t20 1342.03947767937
Riso3858 VDD_B.t134 VDD_B.t22 502.981579847839
Riso3859 VDD_B.t134 VDD_B.t23 1326.65025395191
Riso3860 VDD_B.t134 VDD_B.t24 7893.90042869179
Riso3861 VDD_B.t134 VDD_B.t25 355.953305301629
Riso3862 VDD_B.t134 VDD_B.t26 488.667717381578
Riso3863 VDD_B.t134 VDD_B.t27 3855.23563176666
Riso3864 VDD_B.t134 VDD_B.t28 3365.01509849067
Riso3865 VDD_B.t134 VDD_B.t3 14502.7663410627
Riso3866 VDD_B.t134 VDD_B.t30 1342.03947767937
Riso3867 VDD_B.t134 VDD_B.t31 348.461605735593
Riso3868 VDD_B.t134 VDD_B.t32 2965.36538304496
Riso3869 VDD_B.t134 VDD_B.t33 437.865756841133
Riso3870 VDD_B.t134 VDD_B.t34 666.474082712226
Riso3871 VDD_B.t134 VDD_B.t35 4958.3293251882
Riso3872 VDD_B.t134 VDD_B.t36 5232.97873961551
Riso3873 VDD_B.t134 VDD_B.t37 1976.57362157508
Riso3874 VDD_B.t134 VDD_B.t38 3855.23563176666
Riso3875 VDD_B.t134 VDD_B.t39 3794.51793308369
Riso3876 VDD_B.t134 VDD_B.t4 355.953305301629
Riso3877 VDD_B.t134 VDD_B.t41 1150.96801054134
Riso3878 VDD_B.t134 VDD_B.t42 1206.29017895344
Riso3879 VDD_B.t134 VDD_B.t43 543.702279632381
Riso3880 VDD_B.t134 VDD_B.t44 6820.11476367253
Riso3881 VDD_B.t134 VDD_B.t45 20021.202422929
Riso3882 VDD_B.t134 VDD_B.t46 2258.4914694006
Riso3883 VDD_B.t134 VDD_B.t47 3540.85171126568
Riso3884 VDD_B.t134 VDD_B.t48 1889.21934783568
Riso3885 VDD_B.t134 VDD_B.t49 2761.73892111172
Riso3886 VDD_B.t134 VDD_B.t50 3645.34442459616
Riso3887 VDD_B.t134 VDD_B.t51 348.461605735593
Riso3888 VDD_B.t134 VDD_B.t52 2761.73892111172
Riso3889 VDD_B.t134 VDD_B.t53 3330.19064141061
Riso3890 VDD_B.t134 VDD_B.t55 502.981579847839
Riso3891 VDD_B.t134 VDD_B.t56 1592.62101296725
Riso3892 VDD_B.t134 VDD_B.t57 2046.41748180214
Riso3893 VDD_B.t134 VDD_B.t58 101021.306902081
Riso3894 VDD_B.t134 VDD_B.t59 576.443631011893
Riso3895 VDD_B.t134 VDD_B.t6 109.15919207108
Riso3896 VDD_B.t134 VDD_B.t60 3685.9111664088
Riso3897 VDD_B.t134 VDD_B.t61 666.474082712226
Riso3898 VDD_B.t134 VDD_B.t62 391.185142509131
Riso3899 VDD_B.t134 VDD_B.t63 1206.29017895344
Riso3900 VDD_B.t134 VDD_B.t64 375.55120446492
Riso3901 VDD_B.t134 VDD_B.t66 54.4157818506901
Riso3902 VDD_B.t134 VDD_B.t67 2488.68419519995
Riso3903 VDD_B.t134 VDD_B.t68 2720.28463465114
Riso3904 VDD_B.t134 VDD_B.t69 437.865756841133
Riso3905 VDD_B.t134 VDD_B.t70 990.843506472818
Riso3906 VDD_B.t134 VDD_B.t71 2837.45381335895
Riso3907 VDD_B.t134 VDD_B.t73 1150.96801054134
Riso3908 VDD_B.t134 VDD_B.t75 54.4157818506901
Riso3909 VDD_B.t134 VDD_B.t76 3907.2330377826
Riso3910 VDD_B.t134 VDD_B.t77 3497.95287941774
Riso3911 VDD_B.t134 VDD_B.t78 3645.34442459616
Riso3912 VDD_B.t134 VDD_B.t79 3794.51793308369
Riso3913 VDD_B.t134 VDD_B.t8 1372.077899053
Riso3914 VDD_B.t134 VDD_B.t80 1889.21934783568
Riso3915 VDD_B.t134 VDD_B.t81 7217.9778677673
Riso3916 VDD_B.t134 VDD_B.t82 1112.04848170591
Riso3917 VDD_B.t134 VDD_B.t83 3365.01509849067
Riso3918 VDD_B.t134 VDD_B.t85 1195.94765248677
Riso3919 VDD_B.t134 VDD_B.t86 3766.33188703317
Riso3920 VDD_B.t134 VDD_B.t87 309.498270512202
Riso3921 VDD_B.t134 VDD_B.t88 3497.95287941774
Riso3922 VDD_B.t134 VDD_B.t89 1455.50011097894
Riso3923 VDD_B.t134 VDD_B.t9 2956.89875634346
Riso3924 VDD_B.t134 VDD_B.t90 391.185142509131
Riso3925 VDD_B.t134 VDD_B.t91 1094.41224043306
Riso3926 VDD_B.t134 VDD_B.t92 3148.00161807525
Riso3927 VDD_B.t134 VDD_B.t94 921.361100771113
Riso3928 VDD_B.t134 VDD_B.t95 1313.43170862043
Riso3929 VDD_B.t134 VDD_B.t96 1492.5952413934
Riso3930 VDD_B.t134 VDD_B.t97 2142.56520601296
Riso3931 VDD_B.t134 VDD_B.t99 921.361100771113
Riso3932 VDD_B.t135 VDD_B.t136 322.935027672475
Riso3933 VDD_B.t135 VDD_B.t137 322.935027672475
Riso3934 VDD_B.t135 VDD_B.t139 2340.76753595392
Riso3935 VDD_B.t135 VDD_B.t140 471.074235523445
Riso3936 VDD_B.t135 VDD_B.t141 239.017022991723
Riso3937 VDD_B.t135 VDD_B.t143 2502.83042855636
Riso3938 VDD_B.t135 VDD_B.t144 567.460246932697
Riso3939 VDD_B.t135 VDD_B.t145 612.060808773836
Riso3940 VDD_B.t135 VDD_B.t147 2024.05714461873
Riso3941 VDD_B.t135 VDD_B.t149 2340.76753595392
Riso3942 VDD_B.t135 VDD_B.t15 849.225783399225
Riso3943 VDD_B.t135 VDD_B.t150 605.26808998638
Riso3944 VDD_B.t135 VDD_B.t151 41.5860517205105
Riso3945 VDD_B.t135 VDD_B.t152 38561.6986071689
Riso3946 VDD_B.t135 VDD_B.t153 141.561062639702
Riso3947 VDD_B.t135 VDD_B.t154 49.3293239317583
Riso3948 VDD_B.t135 VDD_B.t17 1592.62101296725
Riso3949 VDD_B.t135 VDD_B.t18 34.0220583179906
Riso3950 VDD_B.t135 VDD_B.t2 2132.85209255722
Riso3951 VDD_B.t135 VDD_B.t20 1618.88865514528
Riso3952 VDD_B.t135 VDD_B.t22 2132.07741398524
Riso3953 VDD_B.t135 VDD_B.t23 49.3293239317583
Riso3954 VDD_B.t135 VDD_B.t24 49409.435405431
Riso3955 VDD_B.t135 VDD_B.t25 2310.31263419276
Riso3956 VDD_B.t135 VDD_B.t26 205.913139082023
Riso3957 VDD_B.t135 VDD_B.t27 267.881957822298
Riso3958 VDD_B.t135 VDD_B.t28 539.13577302137
Riso3959 VDD_B.t135 VDD_B.t3 90775.5935360272
Riso3960 VDD_B.t135 VDD_B.t30 1618.88865514528
Riso3961 VDD_B.t135 VDD_B.t31 280.27215774529
Riso3962 VDD_B.t135 VDD_B.t32 21507.0794262237
Riso3963 VDD_B.t135 VDD_B.t33 230.629949709841
Riso3964 VDD_B.t135 VDD_B.t34 139.454109786367
Riso3965 VDD_B.t135 VDD_B.t35 35961.5658926641
Riso3966 VDD_B.t135 VDD_B.t36 37953.5318083074
Riso3967 VDD_B.t135 VDD_B.t37 202.962813717142
Riso3968 VDD_B.t135 VDD_B.t38 267.881957822298
Riso3969 VDD_B.t135 VDD_B.t39 434.071186710436
Riso3970 VDD_B.t135 VDD_B.t4 2310.31263419276
Riso3971 VDD_B.t135 VDD_B.t41 1182.00625743825
Riso3972 VDD_B.t135 VDD_B.t42 58.1688930301409
Riso3973 VDD_B.t135 VDD_B.t43 182.216445000381
Riso3974 VDD_B.t135 VDD_B.t44 49464.6463322668
Riso3975 VDD_B.t135 VDD_B.t45 145208.949015342
Riso3976 VDD_B.t135 VDD_B.t46 609.521114357658
Riso3977 VDD_B.t135 VDD_B.t47 506.526271819467
Riso3978 VDD_B.t135 VDD_B.t48 48.9282161536782
Riso3979 VDD_B.t135 VDD_B.t49 105.196956340579
Riso3980 VDD_B.t135 VDD_B.t50 211.71789279396
Riso3981 VDD_B.t135 VDD_B.t51 280.27215774529
Riso3982 VDD_B.t135 VDD_B.t52 105.196956340579
Riso3983 VDD_B.t135 VDD_B.t53 162.868371593627
Riso3984 VDD_B.t135 VDD_B.t55 2132.07741398524
Riso3985 VDD_B.t135 VDD_B.t56 0.0669663740302972
Riso3986 VDD_B.t135 VDD_B.t57 57.3081010506099
Riso3987 VDD_B.t135 VDD_B.t58 97027.5695097284
Riso3988 VDD_B.t135 VDD_B.t59 557.623336739093
Riso3989 VDD_B.t135 VDD_B.t6 1623.08256251083
Riso3990 VDD_B.t135 VDD_B.t60 471.074235523445
Riso3991 VDD_B.t135 VDD_B.t61 139.454109786367
Riso3992 VDD_B.t135 VDD_B.t62 255.716093645484
Riso3993 VDD_B.t135 VDD_B.t63 58.1688930301409
Riso3994 VDD_B.t135 VDD_B.t64 61.8084507520292
Riso3995 VDD_B.t135 VDD_B.t66 1490.31456468833
Riso3996 VDD_B.t135 VDD_B.t67 612.060808773836
Riso3997 VDD_B.t135 VDD_B.t68 605.26808998638
Riso3998 VDD_B.t135 VDD_B.t69 230.629949709841
Riso3999 VDD_B.t135 VDD_B.t70 79.1267619347386
Riso4000 VDD_B.t135 VDD_B.t71 20579.36768301
Riso4001 VDD_B.t135 VDD_B.t73 1182.00625743825
Riso4002 VDD_B.t135 VDD_B.t75 1490.31456468833
Riso4003 VDD_B.t135 VDD_B.t76 297.865452168809
Riso4004 VDD_B.t135 VDD_B.t77 186.278348880019
Riso4005 VDD_B.t135 VDD_B.t78 211.71789279396
Riso4006 VDD_B.t135 VDD_B.t79 434.071186710436
Riso4007 VDD_B.t135 VDD_B.t8 2132.85209255722
Riso4008 VDD_B.t135 VDD_B.t80 48.9282161536782
Riso4009 VDD_B.t135 VDD_B.t81 52350.2514011921
Riso4010 VDD_B.t135 VDD_B.t82 8065.41924263702
Riso4011 VDD_B.t135 VDD_B.t83 539.13577302137
Riso4012 VDD_B.t135 VDD_B.t85 2502.83042855636
Riso4013 VDD_B.t135 VDD_B.t86 239.017022991723
Riso4014 VDD_B.t135 VDD_B.t87 303.13959386059
Riso4015 VDD_B.t135 VDD_B.t88 186.278348880019
Riso4016 VDD_B.t135 VDD_B.t89 41.5860517205105
Riso4017 VDD_B.t135 VDD_B.t9 122.355721588228
Riso4018 VDD_B.t135 VDD_B.t90 255.716093645484
Riso4019 VDD_B.t135 VDD_B.t91 68.1202504788932
Riso4020 VDD_B.t135 VDD_B.t92 141.561062639702
Riso4021 VDD_B.t135 VDD_B.t94 2512.40588943168
Riso4022 VDD_B.t135 VDD_B.t95 46.05144591768
Riso4023 VDD_B.t135 VDD_B.t96 10825.4330449114
Riso4024 VDD_B.t135 VDD_B.t97 15539.5083267165
Riso4025 VDD_B.t135 VDD_B.t99 2512.40588943168
Riso4026 VDD_B.t136 VDD_B.t137 0.0669387527654945
Riso4027 VDD_B.t136 VDD_B.t139 299.56932525541
Riso4028 VDD_B.t136 VDD_B.t140 1363.05798079882
Riso4029 VDD_B.t136 VDD_B.t141 1018.52680770132
Riso4030 VDD_B.t136 VDD_B.t143 379.665959301577
Riso4031 VDD_B.t136 VDD_B.t144 1370.97437010682
Riso4032 VDD_B.t136 VDD_B.t145 1244.48490527927
Riso4033 VDD_B.t136 VDD_B.t147 296.775283646057
Riso4034 VDD_B.t136 VDD_B.t149 299.56932525541
Riso4035 VDD_B.t136 VDD_B.t15 141.955564439607
Riso4036 VDD_B.t136 VDD_B.t150 1300.59224722079
Riso4037 VDD_B.t136 VDD_B.t151 288.530354817962
Riso4038 VDD_B.t136 VDD_B.t152 6931.06046858313
Riso4039 VDD_B.t136 VDD_B.t153 759.713806929138
Riso4040 VDD_B.t136 VDD_B.t154 256.613394582299
Riso4041 VDD_B.t136 VDD_B.t17 274.080330183662
Riso4042 VDD_B.t136 VDD_B.t18 246.965604473429
Riso4043 VDD_B.t136 VDD_B.t2 404.083350078719
Riso4044 VDD_B.t136 VDD_B.t20 365.573018804122
Riso4045 VDD_B.t136 VDD_B.t22 221.598497458588
Riso4046 VDD_B.t136 VDD_B.t23 256.613394582299
Riso4047 VDD_B.t136 VDD_B.t24 5474.33504755195
Riso4048 VDD_B.t136 VDD_B.t25 258.195879729535
Riso4049 VDD_B.t136 VDD_B.t26 66.6723941743448
Riso4050 VDD_B.t136 VDD_B.t27 1080.89135283627
Riso4051 VDD_B.t136 VDD_B.t28 1383.33826642487
Riso4052 VDD_B.t136 VDD_B.t3 10057.5124787194
Riso4053 VDD_B.t136 VDD_B.t30 365.573018804122
Riso4054 VDD_B.t136 VDD_B.t31 40.7720577097919
Riso4055 VDD_B.t136 VDD_B.t32 3865.67172583169
Riso4056 VDD_B.t136 VDD_B.t33 56.8835958644504
Riso4057 VDD_B.t136 VDD_B.t34 103.349758445391
Riso4058 VDD_B.t136 VDD_B.t35 6463.71391172728
Riso4059 VDD_B.t136 VDD_B.t36 6821.74887158026
Riso4060 VDD_B.t136 VDD_B.t37 660.571308155872
Riso4061 VDD_B.t136 VDD_B.t38 1080.89135283627
Riso4062 VDD_B.t136 VDD_B.t39 1332.6056463672
Riso4063 VDD_B.t136 VDD_B.t4 258.195879729535
Riso4064 VDD_B.t136 VDD_B.t41 296.197827508474
Riso4065 VDD_B.t136 VDD_B.t42 227.198075269953
Riso4066 VDD_B.t136 VDD_B.t43 77.689180928591
Riso4067 VDD_B.t136 VDD_B.t44 8890.75085303122
Riso4068 VDD_B.t136 VDD_B.t45 26099.7840488706
Riso4069 VDD_B.t136 VDD_B.t46 1176.80809071514
Riso4070 VDD_B.t136 VDD_B.t47 1380.42663350841
Riso4071 VDD_B.t136 VDD_B.t48 398.831736777073
Riso4072 VDD_B.t136 VDD_B.t49 638.305136246555
Riso4073 VDD_B.t136 VDD_B.t50 953.977765859464
Riso4074 VDD_B.t136 VDD_B.t51 40.7720577097919
Riso4075 VDD_B.t136 VDD_B.t52 638.305136246555
Riso4076 VDD_B.t136 VDD_B.t53 823.55295231481
Riso4077 VDD_B.t136 VDD_B.t55 221.598497458588
Riso4078 VDD_B.t136 VDD_B.t56 322.935027672475
Riso4079 VDD_B.t136 VDD_B.t57 439.911808410001
Riso4080 VDD_B.t136 VDD_B.t58 25431.1564845735
Riso4081 VDD_B.t136 VDD_B.t59 145.036837416564
Riso4082 VDD_B.t136 VDD_B.t6 261.480064779972
Riso4083 VDD_B.t136 VDD_B.t60 1363.05798079882
Riso4084 VDD_B.t136 VDD_B.t61 103.349758445391
Riso4085 VDD_B.t136 VDD_B.t62 48.2753019014988
Riso4086 VDD_B.t136 VDD_B.t63 227.198075269953
Riso4087 VDD_B.t136 VDD_B.t64 60.2661702033418
Riso4088 VDD_B.t136 VDD_B.t66 253.010459707871
Riso4089 VDD_B.t136 VDD_B.t67 1244.48490527927
Riso4090 VDD_B.t136 VDD_B.t68 1300.59224722079
Riso4091 VDD_B.t136 VDD_B.t69 56.8835958644504
Riso4092 VDD_B.t136 VDD_B.t70 175.715520955557
Riso4093 VDD_B.t136 VDD_B.t71 3698.92527995721
Riso4094 VDD_B.t136 VDD_B.t73 296.197827508474
Riso4095 VDD_B.t136 VDD_B.t75 253.010459707871
Riso4096 VDD_B.t136 VDD_B.t76 1139.48192105903
Riso4097 VDD_B.t136 VDD_B.t77 888.609419510985
Riso4098 VDD_B.t136 VDD_B.t78 953.977765859464
Riso4099 VDD_B.t136 VDD_B.t79 1332.6056463672
Riso4100 VDD_B.t136 VDD_B.t8 404.083350078719
Riso4101 VDD_B.t136 VDD_B.t80 398.831736777073
Riso4102 VDD_B.t136 VDD_B.t81 9409.40806844375
Riso4103 VDD_B.t136 VDD_B.t82 1449.67443070048
Riso4104 VDD_B.t136 VDD_B.t83 1383.33826642487
Riso4105 VDD_B.t136 VDD_B.t85 379.665959301577
Riso4106 VDD_B.t136 VDD_B.t86 1018.52680770132
Riso4107 VDD_B.t136 VDD_B.t87 34.2826582350228
Riso4108 VDD_B.t136 VDD_B.t88 888.609419510985
Riso4109 VDD_B.t136 VDD_B.t89 288.530354817962
Riso4110 VDD_B.t136 VDD_B.t9 697.791433129478
Riso4111 VDD_B.t136 VDD_B.t90 48.2753019014988
Riso4112 VDD_B.t136 VDD_B.t91 200.253499562139
Riso4113 VDD_B.t136 VDD_B.t92 759.713806929138
Riso4114 VDD_B.t136 VDD_B.t94 308.650979129625
Riso4115 VDD_B.t136 VDD_B.t95 297.638378716009
Riso4116 VDD_B.t136 VDD_B.t96 1945.75793450474
Riso4117 VDD_B.t136 VDD_B.t97 2793.06347372623
Riso4118 VDD_B.t136 VDD_B.t99 308.650979129625
Riso4119 VDD_B.t137 VDD_B.t139 299.56932525541
Riso4120 VDD_B.t137 VDD_B.t140 1363.05798079882
Riso4121 VDD_B.t137 VDD_B.t141 1018.52680770132
Riso4122 VDD_B.t137 VDD_B.t143 379.665959301577
Riso4123 VDD_B.t137 VDD_B.t144 1370.97437010682
Riso4124 VDD_B.t137 VDD_B.t145 1244.48490527927
Riso4125 VDD_B.t137 VDD_B.t147 296.775283646057
Riso4126 VDD_B.t137 VDD_B.t149 299.56932525541
Riso4127 VDD_B.t137 VDD_B.t15 141.955564439607
Riso4128 VDD_B.t137 VDD_B.t150 1300.59224722079
Riso4129 VDD_B.t137 VDD_B.t151 288.530354817962
Riso4130 VDD_B.t137 VDD_B.t152 6931.06046858313
Riso4131 VDD_B.t137 VDD_B.t153 759.713806929138
Riso4132 VDD_B.t137 VDD_B.t154 256.613394582299
Riso4133 VDD_B.t137 VDD_B.t17 274.080330183662
Riso4134 VDD_B.t137 VDD_B.t18 246.965604473429
Riso4135 VDD_B.t137 VDD_B.t2 404.083350078719
Riso4136 VDD_B.t137 VDD_B.t20 365.573018804122
Riso4137 VDD_B.t137 VDD_B.t22 221.598497458588
Riso4138 VDD_B.t137 VDD_B.t23 256.613394582299
Riso4139 VDD_B.t137 VDD_B.t24 5474.33504755195
Riso4140 VDD_B.t137 VDD_B.t25 258.195879729535
Riso4141 VDD_B.t137 VDD_B.t26 66.6723941743448
Riso4142 VDD_B.t137 VDD_B.t27 1080.89135283627
Riso4143 VDD_B.t137 VDD_B.t28 1383.33826642487
Riso4144 VDD_B.t137 VDD_B.t3 10057.5124787194
Riso4145 VDD_B.t137 VDD_B.t30 365.573018804122
Riso4146 VDD_B.t137 VDD_B.t31 40.7720577097919
Riso4147 VDD_B.t137 VDD_B.t32 3865.67172583169
Riso4148 VDD_B.t137 VDD_B.t33 56.8835958644504
Riso4149 VDD_B.t137 VDD_B.t34 103.349758445391
Riso4150 VDD_B.t137 VDD_B.t35 6463.71391172728
Riso4151 VDD_B.t137 VDD_B.t36 6821.74887158026
Riso4152 VDD_B.t137 VDD_B.t37 660.571308155872
Riso4153 VDD_B.t137 VDD_B.t38 1080.89135283627
Riso4154 VDD_B.t137 VDD_B.t39 1332.6056463672
Riso4155 VDD_B.t137 VDD_B.t4 258.195879729535
Riso4156 VDD_B.t137 VDD_B.t41 296.197827508474
Riso4157 VDD_B.t137 VDD_B.t42 227.198075269953
Riso4158 VDD_B.t137 VDD_B.t43 77.689180928591
Riso4159 VDD_B.t137 VDD_B.t44 8890.75085303122
Riso4160 VDD_B.t137 VDD_B.t45 26099.7840488706
Riso4161 VDD_B.t137 VDD_B.t46 1176.80809071514
Riso4162 VDD_B.t137 VDD_B.t47 1380.42663350841
Riso4163 VDD_B.t137 VDD_B.t48 398.831736777073
Riso4164 VDD_B.t137 VDD_B.t49 638.305136246555
Riso4165 VDD_B.t137 VDD_B.t50 953.977765859464
Riso4166 VDD_B.t137 VDD_B.t51 40.7720577097919
Riso4167 VDD_B.t137 VDD_B.t52 638.305136246555
Riso4168 VDD_B.t137 VDD_B.t53 823.55295231481
Riso4169 VDD_B.t137 VDD_B.t55 221.598497458588
Riso4170 VDD_B.t137 VDD_B.t56 322.935027672475
Riso4171 VDD_B.t137 VDD_B.t57 439.911808410001
Riso4172 VDD_B.t137 VDD_B.t58 25431.1564845735
Riso4173 VDD_B.t137 VDD_B.t59 145.036837416564
Riso4174 VDD_B.t137 VDD_B.t6 261.480064779972
Riso4175 VDD_B.t137 VDD_B.t60 1363.05798079882
Riso4176 VDD_B.t137 VDD_B.t61 103.349758445391
Riso4177 VDD_B.t137 VDD_B.t62 48.2753019014988
Riso4178 VDD_B.t137 VDD_B.t63 227.198075269953
Riso4179 VDD_B.t137 VDD_B.t64 60.2661702033418
Riso4180 VDD_B.t137 VDD_B.t66 253.010459707871
Riso4181 VDD_B.t137 VDD_B.t67 1244.48490527927
Riso4182 VDD_B.t137 VDD_B.t68 1300.59224722079
Riso4183 VDD_B.t137 VDD_B.t69 56.8835958644504
Riso4184 VDD_B.t137 VDD_B.t70 175.715520955557
Riso4185 VDD_B.t137 VDD_B.t71 3698.92527995721
Riso4186 VDD_B.t137 VDD_B.t73 296.197827508474
Riso4187 VDD_B.t137 VDD_B.t75 253.010459707871
Riso4188 VDD_B.t137 VDD_B.t76 1139.48192105903
Riso4189 VDD_B.t137 VDD_B.t77 888.609419510985
Riso4190 VDD_B.t137 VDD_B.t78 953.977765859464
Riso4191 VDD_B.t137 VDD_B.t79 1332.6056463672
Riso4192 VDD_B.t137 VDD_B.t8 404.083350078719
Riso4193 VDD_B.t137 VDD_B.t80 398.831736777073
Riso4194 VDD_B.t137 VDD_B.t81 9409.40806844375
Riso4195 VDD_B.t137 VDD_B.t82 1449.67443070048
Riso4196 VDD_B.t137 VDD_B.t83 1383.33826642487
Riso4197 VDD_B.t137 VDD_B.t85 379.665959301577
Riso4198 VDD_B.t137 VDD_B.t86 1018.52680770132
Riso4199 VDD_B.t137 VDD_B.t87 34.2826582350228
Riso4200 VDD_B.t137 VDD_B.t88 888.609419510985
Riso4201 VDD_B.t137 VDD_B.t89 288.530354817962
Riso4202 VDD_B.t137 VDD_B.t9 697.791433129478
Riso4203 VDD_B.t137 VDD_B.t90 48.2753019014988
Riso4204 VDD_B.t137 VDD_B.t91 200.253499562139
Riso4205 VDD_B.t137 VDD_B.t92 759.713806929138
Riso4206 VDD_B.t137 VDD_B.t94 308.650979129625
Riso4207 VDD_B.t137 VDD_B.t95 297.638378716009
Riso4208 VDD_B.t137 VDD_B.t96 1945.75793450474
Riso4209 VDD_B.t137 VDD_B.t97 2793.06347372623
Riso4210 VDD_B.t137 VDD_B.t99 308.650979129625
Riso4211 VDD_B.t138 VDD_B.t146 158.648
Riso4212 VDD_B.t138 VDD_B.t148 158.648
Riso4213 VDD_B.t139 VDD_B.t140 7174.53320779826
Riso4214 VDD_B.t139 VDD_B.t141 6255.40340737655
Riso4215 VDD_B.t139 VDD_B.t143 283.075866127584
Riso4216 VDD_B.t139 VDD_B.t144 6642.25134133414
Riso4217 VDD_B.t139 VDD_B.t145 5572.56876550086
Riso4218 VDD_B.t139 VDD_B.t147 47.3393741975516
Riso4219 VDD_B.t139 VDD_B.t149 0.823122351730223
Riso4220 VDD_B.t139 VDD_B.t15 75.9028473568585
Riso4221 VDD_B.t139 VDD_B.t150 5971.15959056529
Riso4222 VDD_B.t139 VDD_B.t151 2122.84022537632
Riso4223 VDD_B.t139 VDD_B.t152 10859.2944563643
Riso4224 VDD_B.t139 VDD_B.t153 4944.81919693163
Riso4225 VDD_B.t139 VDD_B.t154 1918.57714475214
Riso4226 VDD_B.t139 VDD_B.t17 239.987838373831
Riso4227 VDD_B.t139 VDD_B.t18 1704.01981202344
Riso4228 VDD_B.t139 VDD_B.t2 405.504496386277
Riso4229 VDD_B.t139 VDD_B.t20 550.089351230794
Riso4230 VDD_B.t139 VDD_B.t22 82.9310655206161
Riso4231 VDD_B.t139 VDD_B.t23 1918.57714475214
Riso4232 VDD_B.t139 VDD_B.t24 1084.59859792661
Riso4233 VDD_B.t139 VDD_B.t25 48.2000421244593
Riso4234 VDD_B.t139 VDD_B.t26 611.976281875173
Riso4235 VDD_B.t139 VDD_B.t27 6522.77917677634
Riso4236 VDD_B.t139 VDD_B.t28 6891.4438253714
Riso4237 VDD_B.t139 VDD_B.t3 1992.63724969237
Riso4238 VDD_B.t139 VDD_B.t30 550.089351230794
Riso4239 VDD_B.t139 VDD_B.t31 404.236912299043
Riso4240 VDD_B.t139 VDD_B.t32 6056.5721122658
Riso4241 VDD_B.t139 VDD_B.t33 535.554131046092
Riso4242 VDD_B.t139 VDD_B.t34 884.445933195249
Riso4243 VDD_B.t139 VDD_B.t35 10127.0754983752
Riso4244 VDD_B.t139 VDD_B.t36 10688.029636972
Riso4245 VDD_B.t139 VDD_B.t37 3659.29229486114
Riso4246 VDD_B.t139 VDD_B.t38 6522.77917677634
Riso4247 VDD_B.t139 VDD_B.t39 7200.69844498169
Riso4248 VDD_B.t139 VDD_B.t4 48.2000421244593
Riso4249 VDD_B.t139 VDD_B.t41 675.514928047826
Riso4250 VDD_B.t139 VDD_B.t42 1728.15899619561
Riso4251 VDD_B.t139 VDD_B.t43 695.73764952199
Riso4252 VDD_B.t139 VDD_B.t44 13929.6550490166
Riso4253 VDD_B.t139 VDD_B.t45 40892.0455273629
Riso4254 VDD_B.t139 VDD_B.t46 5148.82191408844
Riso4255 VDD_B.t139 VDD_B.t47 7070.74357837353
Riso4256 VDD_B.t139 VDD_B.t48 2814.91327279724
Riso4257 VDD_B.t139 VDD_B.t49 4257.26450661224
Riso4258 VDD_B.t139 VDD_B.t50 5954.58943021421
Riso4259 VDD_B.t139 VDD_B.t51 404.236912299043
Riso4260 VDD_B.t139 VDD_B.t52 4257.26450661224
Riso4261 VDD_B.t139 VDD_B.t53 5290.89416272296
Riso4262 VDD_B.t139 VDD_B.t55 82.9310655206161
Riso4263 VDD_B.t139 VDD_B.t56 2340.76753595392
Riso4264 VDD_B.t139 VDD_B.t57 3068.41753282792
Riso4265 VDD_B.t139 VDD_B.t58 73374.6435496473
Riso4266 VDD_B.t139 VDD_B.t59 411.975592277762
Riso4267 VDD_B.t139 VDD_B.t6 83.2674374601055
Riso4268 VDD_B.t139 VDD_B.t60 7174.53320779826
Riso4269 VDD_B.t139 VDD_B.t61 884.445933195249
Riso4270 VDD_B.t139 VDD_B.t62 466.386404266989
Riso4271 VDD_B.t139 VDD_B.t63 1728.15899619561
Riso4272 VDD_B.t139 VDD_B.t64 505.651879381999
Riso4273 VDD_B.t139 VDD_B.t66 181.568470409613
Riso4274 VDD_B.t139 VDD_B.t67 5572.56876550086
Riso4275 VDD_B.t139 VDD_B.t68 5971.15959056529
Riso4276 VDD_B.t139 VDD_B.t69 535.554131046092
Riso4277 VDD_B.t139 VDD_B.t70 1388.28105909338
Riso4278 VDD_B.t139 VDD_B.t71 5795.32078376983
Riso4279 VDD_B.t139 VDD_B.t73 675.514928047826
Riso4280 VDD_B.t139 VDD_B.t75 181.568470409613
Riso4281 VDD_B.t139 VDD_B.t76 6746.60798991481
Riso4282 VDD_B.t139 VDD_B.t77 5630.10162337956
Riso4283 VDD_B.t139 VDD_B.t78 5954.58943021421
Riso4284 VDD_B.t139 VDD_B.t79 7200.69844498169
Riso4285 VDD_B.t139 VDD_B.t8 405.504496386277
Riso4286 VDD_B.t139 VDD_B.t80 2814.91327279724
Riso4287 VDD_B.t139 VDD_B.t81 14742.2653919233
Riso4288 VDD_B.t139 VDD_B.t82 2271.2890156125
Riso4289 VDD_B.t139 VDD_B.t83 6891.4438253714
Riso4290 VDD_B.t139 VDD_B.t85 283.075866127584
Riso4291 VDD_B.t139 VDD_B.t86 6255.40340737655
Riso4292 VDD_B.t139 VDD_B.t87 348.766613154774
Riso4293 VDD_B.t139 VDD_B.t88 5630.10162337956
Riso4294 VDD_B.t139 VDD_B.t89 2122.84022537632
Riso4295 VDD_B.t139 VDD_B.t9 4598.48973541717
Riso4296 VDD_B.t139 VDD_B.t90 466.386404266989
Riso4297 VDD_B.t139 VDD_B.t91 1551.49116574055
Riso4298 VDD_B.t139 VDD_B.t92 4944.81919693163
Riso4299 VDD_B.t139 VDD_B.t94 192.362901976319
Riso4300 VDD_B.t139 VDD_B.t95 2008.73661269836
Riso4301 VDD_B.t139 VDD_B.t96 3048.53181520629
Riso4302 VDD_B.t139 VDD_B.t97 4376.05454951531
Riso4303 VDD_B.t139 VDD_B.t99 192.362901976319
Riso4304 VDD_B.t14 VDD_B.t5 158.648
Riso4305 VDD_B.t14 VDD_B.t74 270.481
Riso4306 VDD_B.t140 VDD_B.t141 96.8344202230685
Riso4307 VDD_B.t140 VDD_B.t143 7119.45673052605
Riso4308 VDD_B.t140 VDD_B.t144 49.960748640953
Riso4309 VDD_B.t140 VDD_B.t145 66.8999607684956
Riso4310 VDD_B.t140 VDD_B.t147 6043.76438338417
Riso4311 VDD_B.t140 VDD_B.t149 7174.53320779826
Riso4312 VDD_B.t140 VDD_B.t15 2404.61685024673
Riso4313 VDD_B.t140 VDD_B.t150 61.9506250589044
Riso4314 VDD_B.t140 VDD_B.t151 520.453534288652
Riso4315 VDD_B.t140 VDD_B.t152 54672.7624045671
Riso4316 VDD_B.t140 VDD_B.t153 169.366146229877
Riso4317 VDD_B.t140 VDD_B.t154 572.699152676491
Riso4318 VDD_B.t140 VDD_B.t17 3685.9111664088
Riso4319 VDD_B.t140 VDD_B.t18 155.636439938139
Riso4320 VDD_B.t140 VDD_B.t2 5783.40209967898
Riso4321 VDD_B.t140 VDD_B.t20 4260.90541004726
Riso4322 VDD_B.t140 VDD_B.t22 6862.33970362313
Riso4323 VDD_B.t140 VDD_B.t23 572.699152676491
Riso4324 VDD_B.t140 VDD_B.t24 156421.979778187
Riso4325 VDD_B.t140 VDD_B.t25 7301.88963074068
Riso4326 VDD_B.t140 VDD_B.t26 1206.13781541047
Riso4327 VDD_B.t140 VDD_B.t27 83.1384224731862
Riso4328 VDD_B.t140 VDD_B.t28 43.7541385327606
Riso4329 VDD_B.t140 VDD_B.t3 287380.293661171
Riso4330 VDD_B.t140 VDD_B.t30 4260.90541004726
Riso4331 VDD_B.t140 VDD_B.t31 1342.62467603233
Riso4332 VDD_B.t140 VDD_B.t32 30492.7294688072
Riso4333 VDD_B.t140 VDD_B.t33 1262.23032054234
Riso4334 VDD_B.t140 VDD_B.t34 1005.29345326171
Riso4335 VDD_B.t140 VDD_B.t35 50986.2951778864
Riso4336 VDD_B.t140 VDD_B.t36 53810.5037360571
Riso4337 VDD_B.t140 VDD_B.t37 22.6455881365276
Riso4338 VDD_B.t140 VDD_B.t38 83.1384224731862
Riso4339 VDD_B.t140 VDD_B.t39 38.000455444543
Riso4340 VDD_B.t140 VDD_B.t4 7301.88963074068
Riso4341 VDD_B.t140 VDD_B.t41 3064.70123292227
Riso4342 VDD_B.t140 VDD_B.t42 627.547473797455
Riso4343 VDD_B.t140 VDD_B.t43 1143.05845264111
Riso4344 VDD_B.t140 VDD_B.t44 70130.9577645834
Riso4345 VDD_B.t140 VDD_B.t45 205877.195644509
Riso4346 VDD_B.t140 VDD_B.t46 70.5330285157058
Riso4347 VDD_B.t140 VDD_B.t47 37.8140902361695
Riso4348 VDD_B.t140 VDD_B.t48 381.440886084003
Riso4349 VDD_B.t140 VDD_B.t49 216.417010761325
Riso4350 VDD_B.t140 VDD_B.t50 112.237981803285
Riso4351 VDD_B.t140 VDD_B.t51 1342.62467603233
Riso4352 VDD_B.t140 VDD_B.t52 216.417010761325
Riso4353 VDD_B.t140 VDD_B.t53 148.47272685887
Riso4354 VDD_B.t140 VDD_B.t55 6862.33970362313
Riso4355 VDD_B.t140 VDD_B.t56 471.074235523445
Riso4356 VDD_B.t140 VDD_B.t57 341.260689685434
Riso4357 VDD_B.t140 VDD_B.t58 250085.361290453
Riso4358 VDD_B.t140 VDD_B.t59 1438.66353309968
Riso4359 VDD_B.t140 VDD_B.t6 4752.73779026102
Riso4360 VDD_B.t140 VDD_B.t60 0.0669562074605699
Riso4361 VDD_B.t140 VDD_B.t61 1005.29345326171
Riso4362 VDD_B.t140 VDD_B.t62 1308.65358916245
Riso4363 VDD_B.t140 VDD_B.t63 627.547473797455
Riso4364 VDD_B.t140 VDD_B.t64 478.169142887386
Riso4365 VDD_B.t140 VDD_B.t66 3981.64794142567
Riso4366 VDD_B.t140 VDD_B.t67 66.8999607684956
Riso4367 VDD_B.t140 VDD_B.t68 61.9506250589044
Riso4368 VDD_B.t140 VDD_B.t69 1262.23032054234
Riso4369 VDD_B.t140 VDD_B.t70 743.245942885437
Riso4370 VDD_B.t140 VDD_B.t71 29177.4200932182
Riso4371 VDD_B.t140 VDD_B.t73 3064.70123292227
Riso4372 VDD_B.t140 VDD_B.t75 3981.64794142567
Riso4373 VDD_B.t140 VDD_B.t76 71.0455665511807
Riso4374 VDD_B.t140 VDD_B.t77 129.433013647641
Riso4375 VDD_B.t140 VDD_B.t78 112.237981803285
Riso4376 VDD_B.t140 VDD_B.t79 38.000455444543
Riso4377 VDD_B.t140 VDD_B.t8 5783.40209967898
Riso4378 VDD_B.t140 VDD_B.t80 381.440886084003
Riso4379 VDD_B.t140 VDD_B.t81 74222.1675926029
Riso4380 VDD_B.t140 VDD_B.t82 11435.1484989808
Riso4381 VDD_B.t140 VDD_B.t83 43.7541385327606
Riso4382 VDD_B.t140 VDD_B.t85 7119.45673052605
Riso4383 VDD_B.t140 VDD_B.t86 96.8344202230685
Riso4384 VDD_B.t140 VDD_B.t87 1361.49624109379
Riso4385 VDD_B.t140 VDD_B.t88 129.433013647641
Riso4386 VDD_B.t140 VDD_B.t89 520.453534288652
Riso4387 VDD_B.t140 VDD_B.t9 192.060293434033
Riso4388 VDD_B.t140 VDD_B.t90 1308.65358916245
Riso4389 VDD_B.t140 VDD_B.t91 684.591880602263
Riso4390 VDD_B.t140 VDD_B.t92 169.366146229877
Riso4391 VDD_B.t140 VDD_B.t94 7584.86512023775
Riso4392 VDD_B.t140 VDD_B.t95 123.934730405559
Riso4393 VDD_B.t140 VDD_B.t96 15348.2950743504
Riso4394 VDD_B.t140 VDD_B.t97 22031.909312014
Riso4395 VDD_B.t140 VDD_B.t99 7584.86512023775
Riso4396 VDD_B.t141 VDD_B.t143 5978.44134154747
Riso4397 VDD_B.t141 VDD_B.t144 136.036824941516
Riso4398 VDD_B.t141 VDD_B.t145 166.182218609996
Riso4399 VDD_B.t141 VDD_B.t147 5350.58822273581
Riso4400 VDD_B.t141 VDD_B.t149 6255.40340737655
Riso4401 VDD_B.t141 VDD_B.t15 2195.78183444079
Riso4402 VDD_B.t141 VDD_B.t150 158.362052168784
Riso4403 VDD_B.t141 VDD_B.t151 270.670294333646
Riso4404 VDD_B.t141 VDD_B.t152 68700.2576807626
Riso4405 VDD_B.t141 VDD_B.t153 67.4329164386075
Riso4406 VDD_B.t141 VDD_B.t154 304.958900946666
Riso4407 VDD_B.t141 VDD_B.t17 3766.33188703317
Riso4408 VDD_B.t141 VDD_B.t18 70.8502140406715
Riso4409 VDD_B.t141 VDD_B.t2 4854.46693007678
Riso4410 VDD_B.t141 VDD_B.t20 3575.61367820774
Riso4411 VDD_B.t141 VDD_B.t22 5797.90152692882
Riso4412 VDD_B.t141 VDD_B.t23 304.958900946666
Riso4413 VDD_B.t141 VDD_B.t24 133787.161514991
Riso4414 VDD_B.t141 VDD_B.t25 6251.96817798526
Riso4415 VDD_B.t141 VDD_B.t26 794.085530059845
Riso4416 VDD_B.t141 VDD_B.t27 40.4503822249444
Riso4417 VDD_B.t141 VDD_B.t28 123.071224444703
Riso4418 VDD_B.t141 VDD_B.t3 245795.340391378
Riso4419 VDD_B.t141 VDD_B.t30 3575.61367820774
Riso4420 VDD_B.t141 VDD_B.t31 951.985589242418
Riso4421 VDD_B.t141 VDD_B.t32 38316.3074218807
Riso4422 VDD_B.t141 VDD_B.t33 851.103574195367
Riso4423 VDD_B.t141 VDD_B.t34 618.79687499204
Riso4424 VDD_B.t141 VDD_B.t35 64067.9465030219
Riso4425 VDD_B.t141 VDD_B.t36 67616.7676555877
Riso4426 VDD_B.t141 VDD_B.t37 37.3775601693822
Riso4427 VDD_B.t141 VDD_B.t38 40.4503822249444
Riso4428 VDD_B.t141 VDD_B.t39 84.4870650437975
Riso4429 VDD_B.t141 VDD_B.t4 6251.96817798526
Riso4430 VDD_B.t141 VDD_B.t41 2571.47894241195
Riso4431 VDD_B.t141 VDD_B.t42 341.78018350013
Riso4432 VDD_B.t141 VDD_B.t43 735.394482847858
Riso4433 VDD_B.t141 VDD_B.t44 88124.5918063048
Riso4434 VDD_B.t141 VDD_B.t45 258699.501713654
Riso4435 VDD_B.t141 VDD_B.t46 170.830208185722
Riso4436 VDD_B.t141 VDD_B.t47 109.825767153291
Riso4437 VDD_B.t141 VDD_B.t48 183.653937923129
Riso4438 VDD_B.t141 VDD_B.t49 91.1373571735049
Riso4439 VDD_B.t141 VDD_B.t50 40.910588145584
Riso4440 VDD_B.t141 VDD_B.t51 951.985589242418
Riso4441 VDD_B.t141 VDD_B.t52 91.1373571735049
Riso4442 VDD_B.t141 VDD_B.t53 57.4034092010417
Riso4443 VDD_B.t141 VDD_B.t55 5797.90152692882
Riso4444 VDD_B.t141 VDD_B.t56 239.017022991723
Riso4445 VDD_B.t141 VDD_B.t57 159.832418010433
Riso4446 VDD_B.t141 VDD_B.t58 209832.230160195
Riso4447 VDD_B.t141 VDD_B.t59 1207.08194325826
Riso4448 VDD_B.t141 VDD_B.t6 4255.68791110627
Riso4449 VDD_B.t141 VDD_B.t60 96.8344202230685
Riso4450 VDD_B.t141 VDD_B.t61 618.79687499204
Riso4451 VDD_B.t141 VDD_B.t62 904.51052747062
Riso4452 VDD_B.t141 VDD_B.t63 341.78018350013
Riso4453 VDD_B.t141 VDD_B.t64 288.07150969814
Riso4454 VDD_B.t141 VDD_B.t66 3759.36841339703
Riso4455 VDD_B.t141 VDD_B.t67 166.182218609996
Riso4456 VDD_B.t141 VDD_B.t68 158.362052168784
Riso4457 VDD_B.t141 VDD_B.t69 851.103574195367
Riso4458 VDD_B.t141 VDD_B.t70 422.05261915235
Riso4459 VDD_B.t141 VDD_B.t71 36663.5266027184
Riso4460 VDD_B.t141 VDD_B.t73 2571.47894241195
Riso4461 VDD_B.t141 VDD_B.t75 3759.36841339703
Riso4462 VDD_B.t141 VDD_B.t76 47.2842410931188
Riso4463 VDD_B.t141 VDD_B.t77 48.5842721859194
Riso4464 VDD_B.t141 VDD_B.t78 40.910588145584
Riso4465 VDD_B.t141 VDD_B.t79 84.4870650437975
Riso4466 VDD_B.t141 VDD_B.t8 4854.46693007678
Riso4467 VDD_B.t141 VDD_B.t80 183.653937923129
Riso4468 VDD_B.t141 VDD_B.t81 93265.4911691567
Riso4469 VDD_B.t141 VDD_B.t82 14369.086432555
Riso4470 VDD_B.t141 VDD_B.t83 123.071224444703
Riso4471 VDD_B.t141 VDD_B.t85 5978.44134154747
Riso4472 VDD_B.t141 VDD_B.t86 0.0669641750938175
Riso4473 VDD_B.t141 VDD_B.t87 990.906930081042
Riso4474 VDD_B.t141 VDD_B.t88 48.5842721859194
Riso4475 VDD_B.t141 VDD_B.t89 270.670294333646
Riso4476 VDD_B.t141 VDD_B.t9 78.6938083719541
Riso4477 VDD_B.t141 VDD_B.t90 904.51052747062
Riso4478 VDD_B.t141 VDD_B.t91 380.926546696641
Riso4479 VDD_B.t141 VDD_B.t92 67.4329164386075
Riso4480 VDD_B.t141 VDD_B.t94 6372.78174917673
Riso4481 VDD_B.t141 VDD_B.t95 53.5336797721083
Riso4482 VDD_B.t141 VDD_B.t96 19286.2365132691
Riso4483 VDD_B.t141 VDD_B.t97 27684.6784461748
Riso4484 VDD_B.t141 VDD_B.t99 6372.78174917673
Riso4485 VDD_B.t142 VDD_B.t7 158.648
Riso4486 VDD_B.t142 VDD_B.t84 158.648
Riso4487 VDD_B.t143 VDD_B.t144 6889.25640347949
Riso4488 VDD_B.t143 VDD_B.t145 6097.94683489035
Riso4489 VDD_B.t143 VDD_B.t147 428.851045801178
Riso4490 VDD_B.t143 VDD_B.t149 283.075866127584
Riso4491 VDD_B.t143 VDD_B.t15 484.197816889226
Riso4492 VDD_B.t143 VDD_B.t150 6416.2309050866
Riso4493 VDD_B.t143 VDD_B.t151 2297.84404394583
Riso4494 VDD_B.t143 VDD_B.t152 16377.7233749231
Riso4495 VDD_B.t143 VDD_B.t153 4818.80367108231
Riso4496 VDD_B.t143 VDD_B.t154 2102.77921412977
Riso4497 VDD_B.t143 VDD_B.t17 1195.94765248677
Riso4498 VDD_B.t143 VDD_B.t18 1742.48062340923
Riso4499 VDD_B.t143 VDD_B.t2 41.7621862458547
Riso4500 VDD_B.t143 VDD_B.t20 65.3997532377392
Riso4501 VDD_B.t143 VDD_B.t22 123.280317449893
Riso4502 VDD_B.t143 VDD_B.t23 2102.77921412977
Riso4503 VDD_B.t143 VDD_B.t24 3919.97974276232
Riso4504 VDD_B.t143 VDD_B.t25 187.520176210158
Riso4505 VDD_B.t143 VDD_B.t26 748.307968882745
Riso4506 VDD_B.t143 VDD_B.t27 6231.05176025534
Riso4507 VDD_B.t143 VDD_B.t28 7032.07743695652
Riso4508 VDD_B.t143 VDD_B.t3 7201.83270419116
Riso4509 VDD_B.t143 VDD_B.t30 65.3997532377392
Riso4510 VDD_B.t143 VDD_B.t31 506.151998271241
Riso4511 VDD_B.t143 VDD_B.t32 9134.37452622244
Riso4512 VDD_B.t143 VDD_B.t33 660.493614333177
Riso4513 VDD_B.t143 VDD_B.t34 1051.29795958366
Riso4514 VDD_B.t143 VDD_B.t35 15273.4085787815
Riso4515 VDD_B.t143 VDD_B.t36 16119.4259461964
Riso4516 VDD_B.t143 VDD_B.t37 3560.22147592733
Riso4517 VDD_B.t143 VDD_B.t38 6231.05176025534
Riso4518 VDD_B.t143 VDD_B.t39 7067.31247307198
Riso4519 VDD_B.t143 VDD_B.t4 187.520176210158
Riso4520 VDD_B.t143 VDD_B.t41 105.563039339753
Riso4521 VDD_B.t143 VDD_B.t42 1917.9739088099
Riso4522 VDD_B.t143 VDD_B.t43 843.028368179205
Riso4523 VDD_B.t143 VDD_B.t44 21008.3664291091
Riso4524 VDD_B.t143 VDD_B.t45 61672.3869651962
Riso4525 VDD_B.t143 VDD_B.t46 5736.55402399576
Riso4526 VDD_B.t143 VDD_B.t47 7108.66349745628
Riso4527 VDD_B.t143 VDD_B.t48 2939.9141081304
Riso4528 VDD_B.t143 VDD_B.t49 4222.40273335279
Riso4529 VDD_B.t143 VDD_B.t50 5704.73119290188
Riso4530 VDD_B.t143 VDD_B.t51 506.151998271241
Riso4531 VDD_B.t143 VDD_B.t52 4222.40273335279
Riso4532 VDD_B.t143 VDD_B.t53 5119.4859963894
Riso4533 VDD_B.t143 VDD_B.t55 123.280317449893
Riso4534 VDD_B.t143 VDD_B.t56 2502.83042855636
Riso4535 VDD_B.t143 VDD_B.t57 3169.80427257127
Riso4536 VDD_B.t143 VDD_B.t58 17609.3689352921
Riso4537 VDD_B.t143 VDD_B.t59 83.5785513738191
Riso4538 VDD_B.t143 VDD_B.t6 640.631791416729
Riso4539 VDD_B.t143 VDD_B.t60 7119.45673052605
Riso4540 VDD_B.t143 VDD_B.t61 1051.29795958366
Riso4541 VDD_B.t143 VDD_B.t62 579.769743714541
Riso4542 VDD_B.t143 VDD_B.t63 1917.9739088099
Riso4543 VDD_B.t143 VDD_B.t64 595.211341186378
Riso4544 VDD_B.t143 VDD_B.t66 1010.19807980837
Riso4545 VDD_B.t143 VDD_B.t67 6097.94683489035
Riso4546 VDD_B.t143 VDD_B.t68 6416.2309050866
Riso4547 VDD_B.t143 VDD_B.t69 660.493614333177
Riso4548 VDD_B.t143 VDD_B.t70 1579.61353774627
Riso4549 VDD_B.t143 VDD_B.t71 8740.36163646877
Riso4550 VDD_B.t143 VDD_B.t73 105.563039339753
Riso4551 VDD_B.t143 VDD_B.t75 1010.19807980837
Riso4552 VDD_B.t143 VDD_B.t76 6455.4526314342
Riso4553 VDD_B.t143 VDD_B.t77 5416.47039084265
Riso4554 VDD_B.t143 VDD_B.t78 5704.73119290188
Riso4555 VDD_B.t143 VDD_B.t79 7067.31247307198
Riso4556 VDD_B.t143 VDD_B.t8 41.7621862458547
Riso4557 VDD_B.t143 VDD_B.t80 2939.9141081304
Riso4558 VDD_B.t143 VDD_B.t81 22233.9255537103
Riso4559 VDD_B.t143 VDD_B.t82 3425.50276647134
Riso4560 VDD_B.t143 VDD_B.t83 7032.07743695652
Riso4561 VDD_B.t143 VDD_B.t85 0.821593278612879
Riso4562 VDD_B.t143 VDD_B.t86 5978.44134154747
Riso4563 VDD_B.t143 VDD_B.t87 439.524059504274
Riso4564 VDD_B.t143 VDD_B.t88 5416.47039084265
Riso4565 VDD_B.t143 VDD_B.t89 2297.84404394583
Riso4566 VDD_B.t143 VDD_B.t9 4518.63342067666
Riso4567 VDD_B.t143 VDD_B.t90 579.769743714541
Riso4568 VDD_B.t143 VDD_B.t91 1743.58032704201
Riso4569 VDD_B.t143 VDD_B.t92 4818.80367108231
Riso4570 VDD_B.t143 VDD_B.t94 43.7991547841106
Riso4571 VDD_B.t143 VDD_B.t95 2012.57586756294
Riso4572 VDD_B.t143 VDD_B.t96 4597.72142377439
Riso4573 VDD_B.t143 VDD_B.t97 6599.85887421368
Riso4574 VDD_B.t143 VDD_B.t99 43.7991547841106
Riso4575 VDD_B.t144 VDD_B.t145 42.6761666684912
Riso4576 VDD_B.t144 VDD_B.t147 5532.3088306395
Riso4577 VDD_B.t144 VDD_B.t149 6642.25134133414
Riso4578 VDD_B.t144 VDD_B.t15 2163.27031547968
Riso4579 VDD_B.t144 VDD_B.t150 39.0055126396012
Riso4580 VDD_B.t144 VDD_B.t151 621.210601389331
Riso4581 VDD_B.t144 VDD_B.t152 44072.994884472
Riso4582 VDD_B.t144 VDD_B.t153 224.814592119193
Riso4583 VDD_B.t144 VDD_B.t154 677.533321394235
Riso4584 VDD_B.t144 VDD_B.t17 3165.01222825586
Riso4585 VDD_B.t144 VDD_B.t18 195.326476316437
Riso4586 VDD_B.t144 VDD_B.t2 5626.05363244093
Riso4587 VDD_B.t144 VDD_B.t20 4158.16498173092
Riso4588 VDD_B.t144 VDD_B.t22 6511.85578382443
Riso4589 VDD_B.t144 VDD_B.t23 677.533321394235
Riso4590 VDD_B.t144 VDD_B.t24 146973.913439072
Riso4591 VDD_B.t144 VDD_B.t25 6854.56435960973
Riso4592 VDD_B.t144 VDD_B.t26 1297.45238728643
Riso4593 VDD_B.t144 VDD_B.t27 118.55870519227
Riso4594 VDD_B.t144 VDD_B.t28 36.260685039471
Riso4595 VDD_B.t144 VDD_B.t3 270022.195503128
Riso4596 VDD_B.t144 VDD_B.t30 4158.16498173092
Riso4597 VDD_B.t144 VDD_B.t31 1388.61938368473
Riso4598 VDD_B.t144 VDD_B.t32 24580.9037404714
Riso4599 VDD_B.t144 VDD_B.t33 1340.8969491925
Riso4600 VDD_B.t144 VDD_B.t34 1118.27618282549
Riso4601 VDD_B.t144 VDD_B.t35 41101.2472705322
Riso4602 VDD_B.t144 VDD_B.t36 43377.9079670573
Riso4603 VDD_B.t144 VDD_B.t37 34.1562211470159
Riso4604 VDD_B.t144 VDD_B.t38 118.55870519227
Riso4605 VDD_B.t144 VDD_B.t39 58.0069699992082
Riso4606 VDD_B.t144 VDD_B.t4 6854.56435960973
Riso4607 VDD_B.t144 VDD_B.t41 2995.49703704677
Riso4608 VDD_B.t144 VDD_B.t42 736.048289965197
Riso4609 VDD_B.t144 VDD_B.t43 1244.2452380906
Riso4610 VDD_B.t144 VDD_B.t44 56534.208385699
Riso4611 VDD_B.t144 VDD_B.t45 165962.4315912
Riso4612 VDD_B.t144 VDD_B.t46 45.5351783824288
Riso4613 VDD_B.t144 VDD_B.t47 42.7029555210061
Riso4614 VDD_B.t144 VDD_B.t48 468.55892326043
Riso4615 VDD_B.t144 VDD_B.t49 280.350239421082
Riso4616 VDD_B.t144 VDD_B.t50 155.360684812773
Riso4617 VDD_B.t144 VDD_B.t51 1388.61938368473
Riso4618 VDD_B.t144 VDD_B.t52 280.350239421082
Riso4619 VDD_B.t144 VDD_B.t53 199.742992982124
Riso4620 VDD_B.t144 VDD_B.t55 6511.85578382443
Riso4621 VDD_B.t144 VDD_B.t56 567.460246932697
Riso4622 VDD_B.t144 VDD_B.t57 423.612411146204
Riso4623 VDD_B.t144 VDD_B.t58 244582.482644134
Riso4624 VDD_B.t144 VDD_B.t59 1406.89719934063
Riso4625 VDD_B.t144 VDD_B.t6 4317.33758027708
Riso4626 VDD_B.t144 VDD_B.t60 49.960748640953
Riso4627 VDD_B.t144 VDD_B.t61 1118.27618282549
Riso4628 VDD_B.t144 VDD_B.t62 1372.06487253261
Riso4629 VDD_B.t144 VDD_B.t63 736.048289965197
Riso4630 VDD_B.t144 VDD_B.t64 537.235448745065
Riso4631 VDD_B.t144 VDD_B.t66 3529.44751802331
Riso4632 VDD_B.t144 VDD_B.t67 42.6761666684912
Riso4633 VDD_B.t144 VDD_B.t68 39.0055126396012
Riso4634 VDD_B.t144 VDD_B.t69 1340.8969491925
Riso4635 VDD_B.t144 VDD_B.t70 857.269704197132
Riso4636 VDD_B.t144 VDD_B.t71 23520.6020320472
Riso4637 VDD_B.t144 VDD_B.t73 2995.49703704677
Riso4638 VDD_B.t144 VDD_B.t75 3529.44751802331
Riso4639 VDD_B.t144 VDD_B.t76 102.848120146156
Riso4640 VDD_B.t144 VDD_B.t77 176.587061369681
Riso4641 VDD_B.t144 VDD_B.t78 155.360684812773
Riso4642 VDD_B.t144 VDD_B.t79 58.0069699992082
Riso4643 VDD_B.t144 VDD_B.t8 5626.05363244093
Riso4644 VDD_B.t144 VDD_B.t80 468.55892326043
Riso4645 VDD_B.t144 VDD_B.t81 59832.2284946398
Riso4646 VDD_B.t144 VDD_B.t82 9218.14115718904
Riso4647 VDD_B.t144 VDD_B.t83 36.260685039471
Riso4648 VDD_B.t144 VDD_B.t85 6889.25640347949
Riso4649 VDD_B.t144 VDD_B.t86 136.036824941516
Riso4650 VDD_B.t144 VDD_B.t87 1388.65703710239
Riso4651 VDD_B.t144 VDD_B.t88 176.587061369681
Riso4652 VDD_B.t144 VDD_B.t89 621.210601389331
Riso4653 VDD_B.t144 VDD_B.t9 251.732093268587
Riso4654 VDD_B.t144 VDD_B.t90 1372.06487253261
Riso4655 VDD_B.t144 VDD_B.t91 796.20936395615
Riso4656 VDD_B.t144 VDD_B.t92 224.814592119193
Riso4657 VDD_B.t144 VDD_B.t94 7289.2320203509
Riso4658 VDD_B.t144 VDD_B.t95 158.855566002941
Riso4659 VDD_B.t144 VDD_B.t96 12372.620305732
Riso4660 VDD_B.t144 VDD_B.t97 17760.4383553598
Riso4661 VDD_B.t144 VDD_B.t99 7289.2320203509
Riso4662 VDD_B.t145 VDD_B.t147 4585.56082020772
Riso4663 VDD_B.t145 VDD_B.t149 5572.56876550086
Riso4664 VDD_B.t145 VDD_B.t15 1764.21151740049
Riso4665 VDD_B.t145 VDD_B.t150 30.7617494333052
Riso4666 VDD_B.t145 VDD_B.t151 665.060543059074
Riso4667 VDD_B.t145 VDD_B.t152 33223.2834244355
Riso4668 VDD_B.t145 VDD_B.t153 261.788045661227
Riso4669 VDD_B.t145 VDD_B.t154 720.031644267619
Riso4670 VDD_B.t145 VDD_B.t17 2488.68419519995
Riso4671 VDD_B.t145 VDD_B.t18 217.559484039093
Riso4672 VDD_B.t145 VDD_B.t2 5017.45990908873
Riso4673 VDD_B.t145 VDD_B.t20 3725.34642245692
Riso4674 VDD_B.t145 VDD_B.t22 5614.86453860527
Riso4675 VDD_B.t145 VDD_B.t23 720.031644267619
Riso4676 VDD_B.t145 VDD_B.t24 125324.34588921
Riso4677 VDD_B.t145 VDD_B.t25 5838.74168020263
Riso4678 VDD_B.t145 VDD_B.t26 1258.62195038939
Riso4679 VDD_B.t145 VDD_B.t27 146.78149483051
Riso4680 VDD_B.t145 VDD_B.t28 49.876053475966
Riso4681 VDD_B.t145 VDD_B.t3 230247.356385638
Riso4682 VDD_B.t145 VDD_B.t30 3725.34642245692
Riso4683 VDD_B.t145 VDD_B.t31 1295.11954997426
Riso4684 VDD_B.t145 VDD_B.t32 18529.6763684688
Riso4685 VDD_B.t145 VDD_B.t33 1284.44218100213
Riso4686 VDD_B.t145 VDD_B.t34 1122.00063371797
Riso4687 VDD_B.t145 VDD_B.t35 30983.1086075751
Riso4688 VDD_B.t145 VDD_B.t36 32699.3101904309
Riso4689 VDD_B.t145 VDD_B.t37 44.6038753514892
Riso4690 VDD_B.t145 VDD_B.t38 146.78149483051
Riso4691 VDD_B.t145 VDD_B.t39 76.6746762189946
Riso4692 VDD_B.t145 VDD_B.t4 5838.74168020263
Riso4693 VDD_B.t145 VDD_B.t41 2689.79641015534
Riso4694 VDD_B.t145 VDD_B.t42 776.473830232273
Riso4695 VDD_B.t145 VDD_B.t43 1221.53730480182
Riso4696 VDD_B.t145 VDD_B.t44 42616.8458326378
Riso4697 VDD_B.t145 VDD_B.t45 125106.47204748
Riso4698 VDD_B.t145 VDD_B.t46 27.9996315515264
Riso4699 VDD_B.t145 VDD_B.t47 57.9511109446611
Riso4700 VDD_B.t145 VDD_B.t48 513.260655270333
Riso4701 VDD_B.t145 VDD_B.t49 320.141519509919
Riso4702 VDD_B.t145 VDD_B.t50 187.356634410366
Riso4703 VDD_B.t145 VDD_B.t51 1295.11954997426
Riso4704 VDD_B.t145 VDD_B.t52 320.141519509919
Riso4705 VDD_B.t145 VDD_B.t53 235.161528588896
Riso4706 VDD_B.t145 VDD_B.t55 5614.86453860527
Riso4707 VDD_B.t145 VDD_B.t56 612.060808773836
Riso4708 VDD_B.t145 VDD_B.t57 467.825231444376
Riso4709 VDD_B.t145 VDD_B.t58 219811.155451191
Riso4710 VDD_B.t145 VDD_B.t59 1264.25774154746
Riso4711 VDD_B.t145 VDD_B.t6 3550.69587617647
Riso4712 VDD_B.t145 VDD_B.t60 66.8999607684956
Riso4713 VDD_B.t145 VDD_B.t61 1122.00063371797
Riso4714 VDD_B.t145 VDD_B.t62 1297.10331324526
Riso4715 VDD_B.t145 VDD_B.t63 776.473830232273
Riso4716 VDD_B.t145 VDD_B.t64 544.331831628513
Riso4717 VDD_B.t145 VDD_B.t66 2844.04103398603
Riso4718 VDD_B.t145 VDD_B.t67 0.0669220665700172
Riso4719 VDD_B.t145 VDD_B.t68 30.7617494333052
Riso4720 VDD_B.t145 VDD_B.t69 1284.44218100213
Riso4721 VDD_B.t145 VDD_B.t70 890.856638297177
Riso4722 VDD_B.t145 VDD_B.t71 17730.3954422071
Riso4723 VDD_B.t145 VDD_B.t73 2689.79641015534
Riso4724 VDD_B.t145 VDD_B.t75 2844.04103398603
Riso4725 VDD_B.t145 VDD_B.t76 129.096756728179
Riso4726 VDD_B.t145 VDD_B.t77 210.344679350232
Riso4727 VDD_B.t145 VDD_B.t78 187.356634410366
Riso4728 VDD_B.t145 VDD_B.t79 76.6746762189946
Riso4729 VDD_B.t145 VDD_B.t8 5017.45990908873
Riso4730 VDD_B.t145 VDD_B.t80 513.260655270333
Riso4731 VDD_B.t145 VDD_B.t81 45102.9727025281
Riso4732 VDD_B.t145 VDD_B.t82 6948.85648489586
Riso4733 VDD_B.t145 VDD_B.t83 49.876053475966
Riso4734 VDD_B.t145 VDD_B.t85 6097.94683489035
Riso4735 VDD_B.t145 VDD_B.t86 166.182218609996
Riso4736 VDD_B.t145 VDD_B.t87 1277.61498351961
Riso4737 VDD_B.t145 VDD_B.t88 210.344679350232
Riso4738 VDD_B.t145 VDD_B.t89 665.060543059074
Riso4739 VDD_B.t145 VDD_B.t9 290.158016329461
Riso4740 VDD_B.t145 VDD_B.t90 1297.10331324526
Riso4741 VDD_B.t145 VDD_B.t91 833.709464325643
Riso4742 VDD_B.t145 VDD_B.t92 261.788045661227
Riso4743 VDD_B.t145 VDD_B.t94 6389.90276072235
Riso4744 VDD_B.t145 VDD_B.t95 179.888338143804
Riso4745 VDD_B.t145 VDD_B.t96 9326.77872692258
Riso4746 VDD_B.t145 VDD_B.t97 13388.2455405867
Riso4747 VDD_B.t145 VDD_B.t99 6389.90276072235
Riso4748 VDD_B.t147 VDD_B.t149 47.3393741975516
Riso4749 VDD_B.t147 VDD_B.t15 49.6856450324829
Riso4750 VDD_B.t147 VDD_B.t150 4933.0676265817
Riso4751 VDD_B.t147 VDD_B.t151 1840.74735829728
Riso4752 VDD_B.t147 VDD_B.t152 9052.00916087726
Riso4753 VDD_B.t147 VDD_B.t153 4238.97809765302
Riso4754 VDD_B.t147 VDD_B.t154 1669.25123760815
Riso4755 VDD_B.t147 VDD_B.t17 160.479361147038
Riso4756 VDD_B.t147 VDD_B.t18 1464.25829213844
Riso4757 VDD_B.t147 VDD_B.t2 593.269686855544
Riso4758 VDD_B.t147 VDD_B.t20 754.544668530589
Riso4759 VDD_B.t147 VDD_B.t22 131.334808869135
Riso4760 VDD_B.t147 VDD_B.t23 1669.25123760815
Riso4761 VDD_B.t147 VDD_B.t24 1748.15369683821
Riso4762 VDD_B.t147 VDD_B.t25 77.7815588989127
Riso4763 VDD_B.t147 VDD_B.t26 569.552176679536
Riso4764 VDD_B.t147 VDD_B.t27 5572.8805512446
Riso4765 VDD_B.t147 VDD_B.t28 5762.79630771898
Riso4766 VDD_B.t147 VDD_B.t3 3211.72845066038
Riso4767 VDD_B.t147 VDD_B.t30 754.544668530589
Riso4768 VDD_B.t147 VDD_B.t31 389.859861551068
Riso4769 VDD_B.t147 VDD_B.t32 5048.59191948817
Riso4770 VDD_B.t147 VDD_B.t33 504.0016272425
Riso4771 VDD_B.t147 VDD_B.t34 800.716692675816
Riso4772 VDD_B.t147 VDD_B.t35 8441.65157806015
Riso4773 VDD_B.t147 VDD_B.t36 8909.24751827649
Riso4774 VDD_B.t147 VDD_B.t37 3101.08277191578
Riso4775 VDD_B.t147 VDD_B.t38 5572.8805512446
Riso4776 VDD_B.t147 VDD_B.t39 6085.2204956611
Riso4777 VDD_B.t147 VDD_B.t4 77.7815588989127
Riso4778 VDD_B.t147 VDD_B.t41 844.908188301184
Riso4779 VDD_B.t147 VDD_B.t42 1509.61011424844
Riso4780 VDD_B.t147 VDD_B.t43 640.91542505597
Riso4781 VDD_B.t147 VDD_B.t44 11611.3772969532
Riso4782 VDD_B.t147 VDD_B.t45 34086.4843667409
Riso4783 VDD_B.t147 VDD_B.t46 4220.84287387213
Riso4784 VDD_B.t147 VDD_B.t47 5935.2894563017
Riso4785 VDD_B.t147 VDD_B.t48 2424.2794746882
Riso4786 VDD_B.t147 VDD_B.t49 3651.99504016286
Riso4787 VDD_B.t147 VDD_B.t50 5097.59981473216
Riso4788 VDD_B.t147 VDD_B.t51 389.859861551068
Riso4789 VDD_B.t147 VDD_B.t52 3651.99504016286
Riso4790 VDD_B.t147 VDD_B.t53 4534.13568063325
Riso4791 VDD_B.t147 VDD_B.t55 131.334808869135
Riso4792 VDD_B.t147 VDD_B.t56 2024.05714461873
Riso4793 VDD_B.t147 VDD_B.t57 2639.11109882649
Riso4794 VDD_B.t147 VDD_B.t58 85816.9576592992
Riso4795 VDD_B.t147 VDD_B.t59 484.458080000663
Riso4796 VDD_B.t147 VDD_B.t6 53.8266484552416
Riso4797 VDD_B.t147 VDD_B.t60 6043.76438338417
Riso4798 VDD_B.t147 VDD_B.t61 800.716692675816
Riso4799 VDD_B.t147 VDD_B.t62 444.167581614226
Riso4800 VDD_B.t147 VDD_B.t63 1509.61011424844
Riso4801 VDD_B.t147 VDD_B.t64 454.630895871234
Riso4802 VDD_B.t147 VDD_B.t66 120.164502368044
Riso4803 VDD_B.t147 VDD_B.t67 4585.56082020772
Riso4804 VDD_B.t147 VDD_B.t68 4933.0676265817
Riso4805 VDD_B.t147 VDD_B.t69 504.0016272425
Riso4806 VDD_B.t147 VDD_B.t70 1224.97997418717
Riso4807 VDD_B.t147 VDD_B.t71 4830.81999808578
Riso4808 VDD_B.t147 VDD_B.t73 844.908188301184
Riso4809 VDD_B.t147 VDD_B.t75 120.164502368044
Riso4810 VDD_B.t147 VDD_B.t76 5755.46032526998
Riso4811 VDD_B.t147 VDD_B.t77 4822.7332605663
Riso4812 VDD_B.t147 VDD_B.t78 5097.59981473216
Riso4813 VDD_B.t147 VDD_B.t79 6085.2204956611
Riso4814 VDD_B.t147 VDD_B.t8 593.269686855544
Riso4815 VDD_B.t147 VDD_B.t80 2424.2794746882
Riso4816 VDD_B.t147 VDD_B.t81 12288.7469269759
Riso4817 VDD_B.t147 VDD_B.t82 1893.28404887988
Riso4818 VDD_B.t147 VDD_B.t83 5762.79630771898
Riso4819 VDD_B.t147 VDD_B.t85 428.851045801178
Riso4820 VDD_B.t147 VDD_B.t86 5350.58822273581
Riso4821 VDD_B.t147 VDD_B.t87 340.8262414436
Riso4822 VDD_B.t147 VDD_B.t88 4822.7332605663
Riso4823 VDD_B.t147 VDD_B.t89 1840.74735829728
Riso4824 VDD_B.t147 VDD_B.t9 3943.30305273302
Riso4825 VDD_B.t147 VDD_B.t90 444.167581614226
Riso4826 VDD_B.t147 VDD_B.t91 1361.6360696866
Riso4827 VDD_B.t147 VDD_B.t92 4238.97809765302
Riso4828 VDD_B.t147 VDD_B.t94 296.414519786998
Riso4829 VDD_B.t147 VDD_B.t95 1723.9643017039
Riso4830 VDD_B.t147 VDD_B.t96 2541.17226762372
Riso4831 VDD_B.t147 VDD_B.t97 3647.7587038351
Riso4832 VDD_B.t147 VDD_B.t99 296.414519786998
Riso4833 VDD_B.t148 VDD_B.t3 158.648
Riso4834 VDD_B.t149 VDD_B.t15 75.9028473568585
Riso4835 VDD_B.t149 VDD_B.t150 5971.15959056529
Riso4836 VDD_B.t149 VDD_B.t151 2122.84022537632
Riso4837 VDD_B.t149 VDD_B.t152 10859.2944563643
Riso4838 VDD_B.t149 VDD_B.t153 4944.81919693163
Riso4839 VDD_B.t149 VDD_B.t154 1918.57714475214
Riso4840 VDD_B.t149 VDD_B.t17 239.987838373831
Riso4841 VDD_B.t149 VDD_B.t18 1704.01981202344
Riso4842 VDD_B.t149 VDD_B.t2 405.504496386277
Riso4843 VDD_B.t149 VDD_B.t20 550.089351230794
Riso4844 VDD_B.t149 VDD_B.t22 82.9310655206161
Riso4845 VDD_B.t149 VDD_B.t23 1918.57714475214
Riso4846 VDD_B.t149 VDD_B.t24 1084.59859792661
Riso4847 VDD_B.t149 VDD_B.t25 48.2000421244593
Riso4848 VDD_B.t149 VDD_B.t26 611.976281875173
Riso4849 VDD_B.t149 VDD_B.t27 6522.77917677634
Riso4850 VDD_B.t149 VDD_B.t28 6891.4438253714
Riso4851 VDD_B.t149 VDD_B.t3 1992.63724969237
Riso4852 VDD_B.t149 VDD_B.t30 550.089351230794
Riso4853 VDD_B.t149 VDD_B.t31 404.236912299043
Riso4854 VDD_B.t149 VDD_B.t32 6056.5721122658
Riso4855 VDD_B.t149 VDD_B.t33 535.554131046092
Riso4856 VDD_B.t149 VDD_B.t34 884.445933195249
Riso4857 VDD_B.t149 VDD_B.t35 10127.0754983752
Riso4858 VDD_B.t149 VDD_B.t36 10688.029636972
Riso4859 VDD_B.t149 VDD_B.t37 3659.29229486114
Riso4860 VDD_B.t149 VDD_B.t38 6522.77917677634
Riso4861 VDD_B.t149 VDD_B.t39 7200.69844498169
Riso4862 VDD_B.t149 VDD_B.t4 48.2000421244593
Riso4863 VDD_B.t149 VDD_B.t41 675.514928047826
Riso4864 VDD_B.t149 VDD_B.t42 1728.15899619561
Riso4865 VDD_B.t149 VDD_B.t43 695.73764952199
Riso4866 VDD_B.t149 VDD_B.t44 13929.6550490166
Riso4867 VDD_B.t149 VDD_B.t45 40892.0455273629
Riso4868 VDD_B.t149 VDD_B.t46 5148.82191408844
Riso4869 VDD_B.t149 VDD_B.t47 7070.74357837353
Riso4870 VDD_B.t149 VDD_B.t48 2814.91327279724
Riso4871 VDD_B.t149 VDD_B.t49 4257.26450661224
Riso4872 VDD_B.t149 VDD_B.t50 5954.58943021421
Riso4873 VDD_B.t149 VDD_B.t51 404.236912299043
Riso4874 VDD_B.t149 VDD_B.t52 4257.26450661224
Riso4875 VDD_B.t149 VDD_B.t53 5290.89416272296
Riso4876 VDD_B.t149 VDD_B.t55 82.9310655206161
Riso4877 VDD_B.t149 VDD_B.t56 2340.76753595392
Riso4878 VDD_B.t149 VDD_B.t57 3068.41753282792
Riso4879 VDD_B.t149 VDD_B.t58 73374.6435496473
Riso4880 VDD_B.t149 VDD_B.t59 411.975592277762
Riso4881 VDD_B.t149 VDD_B.t6 83.2674374601055
Riso4882 VDD_B.t149 VDD_B.t60 7174.53320779826
Riso4883 VDD_B.t149 VDD_B.t61 884.445933195249
Riso4884 VDD_B.t149 VDD_B.t62 466.386404266989
Riso4885 VDD_B.t149 VDD_B.t63 1728.15899619561
Riso4886 VDD_B.t149 VDD_B.t64 505.651879381999
Riso4887 VDD_B.t149 VDD_B.t66 181.568470409613
Riso4888 VDD_B.t149 VDD_B.t67 5572.56876550086
Riso4889 VDD_B.t149 VDD_B.t68 5971.15959056529
Riso4890 VDD_B.t149 VDD_B.t69 535.554131046092
Riso4891 VDD_B.t149 VDD_B.t70 1388.28105909338
Riso4892 VDD_B.t149 VDD_B.t71 5795.32078376983
Riso4893 VDD_B.t149 VDD_B.t73 675.514928047826
Riso4894 VDD_B.t149 VDD_B.t75 181.568470409613
Riso4895 VDD_B.t149 VDD_B.t76 6746.60798991481
Riso4896 VDD_B.t149 VDD_B.t77 5630.10162337956
Riso4897 VDD_B.t149 VDD_B.t78 5954.58943021421
Riso4898 VDD_B.t149 VDD_B.t79 7200.69844498169
Riso4899 VDD_B.t149 VDD_B.t8 405.504496386277
Riso4900 VDD_B.t149 VDD_B.t80 2814.91327279724
Riso4901 VDD_B.t149 VDD_B.t81 14742.2653919233
Riso4902 VDD_B.t149 VDD_B.t82 2271.2890156125
Riso4903 VDD_B.t149 VDD_B.t83 6891.4438253714
Riso4904 VDD_B.t149 VDD_B.t85 283.075866127584
Riso4905 VDD_B.t149 VDD_B.t86 6255.40340737655
Riso4906 VDD_B.t149 VDD_B.t87 348.766613154774
Riso4907 VDD_B.t149 VDD_B.t88 5630.10162337956
Riso4908 VDD_B.t149 VDD_B.t89 2122.84022537632
Riso4909 VDD_B.t149 VDD_B.t9 4598.48973541717
Riso4910 VDD_B.t149 VDD_B.t90 466.386404266989
Riso4911 VDD_B.t149 VDD_B.t91 1551.49116574055
Riso4912 VDD_B.t149 VDD_B.t92 4944.81919693163
Riso4913 VDD_B.t149 VDD_B.t94 192.362901976319
Riso4914 VDD_B.t149 VDD_B.t95 2008.73661269836
Riso4915 VDD_B.t149 VDD_B.t96 3048.53181520629
Riso4916 VDD_B.t149 VDD_B.t97 4376.05454951531
Riso4917 VDD_B.t149 VDD_B.t99 192.362901976319
Riso4918 VDD_B.t15 VDD_B.t150 1907.62786059844
Riso4919 VDD_B.t15 VDD_B.t151 774.337560981642
Riso4920 VDD_B.t15 VDD_B.t152 3556.13451925556
Riso4921 VDD_B.t15 VDD_B.t153 1754.72847554805
Riso4922 VDD_B.t15 VDD_B.t154 704.356031862243
Riso4923 VDD_B.t15 VDD_B.t17 44.0786645118433
Riso4924 VDD_B.t15 VDD_B.t18 610.09985766964
Riso4925 VDD_B.t15 VDD_B.t2 590.015264807348
Riso4926 VDD_B.t15 VDD_B.t20 620.341636927386
Riso4927 VDD_B.t15 VDD_B.t22 180.598324193088
Riso4928 VDD_B.t15 VDD_B.t23 704.356031862243
Riso4929 VDD_B.t15 VDD_B.t24 2639.21852879188
Riso4930 VDD_B.t15 VDD_B.t25 118.229894846677
Riso4931 VDD_B.t15 VDD_B.t26 255.58028994634
Riso4932 VDD_B.t15 VDD_B.t27 2279.76396971632
Riso4933 VDD_B.t15 VDD_B.t28 2266.53315218177
Riso4934 VDD_B.t15 VDD_B.t3 4848.80319834681
Riso4935 VDD_B.t15 VDD_B.t30 620.341636927386
Riso4936 VDD_B.t15 VDD_B.t31 181.257163692823
Riso4937 VDD_B.t15 VDD_B.t32 1983.36873940886
Riso4938 VDD_B.t15 VDD_B.t33 228.621474666538
Riso4939 VDD_B.t15 VDD_B.t34 350.12840984792
Riso4940 VDD_B.t15 VDD_B.t35 3316.35198802191
Riso4941 VDD_B.t15 VDD_B.t36 3500.04977649233
Riso4942 VDD_B.t15 VDD_B.t37 1246.96264383721
Riso4943 VDD_B.t15 VDD_B.t38 2279.76396971632
Riso4944 VDD_B.t15 VDD_B.t39 2434.39500504813
Riso4945 VDD_B.t15 VDD_B.t4 118.229894846677
Riso4946 VDD_B.t15 VDD_B.t41 565.025250772616
Riso4947 VDD_B.t15 VDD_B.t42 639.281768305707
Riso4948 VDD_B.t15 VDD_B.t43 284.815269631352
Riso4949 VDD_B.t15 VDD_B.t44 4561.59719769813
Riso4950 VDD_B.t15 VDD_B.t45 13391.073908821
Riso4951 VDD_B.t15 VDD_B.t46 1616.25693908539
Riso4952 VDD_B.t15 VDD_B.t47 2348.01277116462
Riso4953 VDD_B.t15 VDD_B.t48 1013.01005364239
Riso4954 VDD_B.t15 VDD_B.t49 1515.99196009487
Riso4955 VDD_B.t15 VDD_B.t50 2097.65393865257
Riso4956 VDD_B.t15 VDD_B.t51 181.257163692823
Riso4957 VDD_B.t15 VDD_B.t52 1515.99196009487
Riso4958 VDD_B.t15 VDD_B.t53 1873.7663950723
Riso4959 VDD_B.t15 VDD_B.t55 180.598324193088
Riso4960 VDD_B.t15 VDD_B.t56 849.225783399225
Riso4961 VDD_B.t15 VDD_B.t57 1101.05783034811
Riso4962 VDD_B.t15 VDD_B.t58 50999.7635644648
Riso4963 VDD_B.t15 VDD_B.t59 290.442787898881
Riso4964 VDD_B.t15 VDD_B.t6 32.4875624666552
Riso4965 VDD_B.t15 VDD_B.t60 2404.61685024673
Riso4966 VDD_B.t15 VDD_B.t61 350.12840984792
Riso4967 VDD_B.t15 VDD_B.t62 203.876983904682
Riso4968 VDD_B.t15 VDD_B.t63 639.281768305707
Riso4969 VDD_B.t15 VDD_B.t64 197.54772822938
Riso4970 VDD_B.t15 VDD_B.t66 30.1258503300881
Riso4971 VDD_B.t15 VDD_B.t67 1764.21151740049
Riso4972 VDD_B.t15 VDD_B.t68 1907.62786059844
Riso4973 VDD_B.t15 VDD_B.t69 228.621474666538
Riso4974 VDD_B.t15 VDD_B.t70 523.400583536488
Riso4975 VDD_B.t15 VDD_B.t71 1897.81577174608
Riso4976 VDD_B.t15 VDD_B.t73 565.025250772616
Riso4977 VDD_B.t15 VDD_B.t75 30.1258503300881
Riso4978 VDD_B.t15 VDD_B.t76 2345.87649508736
Riso4979 VDD_B.t15 VDD_B.t77 1989.13338089602
Riso4980 VDD_B.t15 VDD_B.t78 2097.65393865257
Riso4981 VDD_B.t15 VDD_B.t79 2434.39500504813
Riso4982 VDD_B.t15 VDD_B.t8 590.015264807348
Riso4983 VDD_B.t15 VDD_B.t80 1013.01005364239
Riso4984 VDD_B.t15 VDD_B.t81 4827.7058019658
Riso4985 VDD_B.t15 VDD_B.t82 743.787665403241
Riso4986 VDD_B.t15 VDD_B.t83 2266.53315218177
Riso4987 VDD_B.t15 VDD_B.t85 484.197816889226
Riso4988 VDD_B.t15 VDD_B.t86 2195.78183444079
Riso4989 VDD_B.t15 VDD_B.t87 160.655348078034
Riso4990 VDD_B.t15 VDD_B.t88 1989.13338089602
Riso4991 VDD_B.t15 VDD_B.t89 774.337560981642
Riso4992 VDD_B.t15 VDD_B.t9 1634.73164243162
Riso4993 VDD_B.t15 VDD_B.t90 203.876983904682
Riso4994 VDD_B.t15 VDD_B.t91 579.018163686968
Riso4995 VDD_B.t15 VDD_B.t92 1754.72847554805
Riso4996 VDD_B.t15 VDD_B.t94 358.930346702876
Riso4997 VDD_B.t15 VDD_B.t95 716.557741167694
Riso4998 VDD_B.t15 VDD_B.t96 998.314325545359
Riso4999 VDD_B.t15 VDD_B.t97 1433.04325195421
Riso5000 VDD_B.t15 VDD_B.t99 358.930346702876
Riso5001 VDD_B.t150 VDD_B.t151 659.167993352583
Riso5002 VDD_B.t150 VDD_B.t152 36748.622231722
Riso5003 VDD_B.t150 VDD_B.t153 253.075018707156
Riso5004 VDD_B.t150 VDD_B.t154 715.266641029297
Riso5005 VDD_B.t150 VDD_B.t17 2720.28463465114
Riso5006 VDD_B.t150 VDD_B.t18 213.098304206195
Riso5007 VDD_B.t150 VDD_B.t2 5265.31361470027
Riso5008 VDD_B.t150 VDD_B.t20 3903.03347230681
Riso5009 VDD_B.t150 VDD_B.t22 5962.0042154897
Riso5010 VDD_B.t150 VDD_B.t23 715.266641029297
Riso5011 VDD_B.t150 VDD_B.t24 133568.507162561
Riso5012 VDD_B.t150 VDD_B.t25 6225.01687632006
Riso5013 VDD_B.t150 VDD_B.t26 1287.54249265844
Riso5014 VDD_B.t150 VDD_B.t27 139.305376531126
Riso5015 VDD_B.t150 VDD_B.t28 45.7861323906484
Riso5016 VDD_B.t150 VDD_B.t3 245393.626053656
Riso5017 VDD_B.t150 VDD_B.t30 3903.03347230681
Riso5018 VDD_B.t150 VDD_B.t31 1341.84217438033
Riso5019 VDD_B.t150 VDD_B.t32 20495.8693649195
Riso5020 VDD_B.t150 VDD_B.t33 1319.35740874291
Riso5021 VDD_B.t150 VDD_B.t34 1135.25452657619
Riso5022 VDD_B.t150 VDD_B.t35 34270.7413725029
Riso5023 VDD_B.t150 VDD_B.t36 36169.0499423134
Riso5024 VDD_B.t150 VDD_B.t37 41.6356178966998
Riso5025 VDD_B.t150 VDD_B.t38 139.305376531126
Riso5026 VDD_B.t150 VDD_B.t39 71.2970558025263
Riso5027 VDD_B.t150 VDD_B.t4 6225.01687632006
Riso5028 VDD_B.t150 VDD_B.t41 2815.8163882465
Riso5029 VDD_B.t150 VDD_B.t42 773.100248946967
Riso5030 VDD_B.t150 VDD_B.t43 1244.74727447657
Riso5031 VDD_B.t150 VDD_B.t44 47138.9401283342
Riso5032 VDD_B.t150 VDD_B.t45 138381.580811333
Riso5033 VDD_B.t150 VDD_B.t46 33.08388586534
Riso5034 VDD_B.t150 VDD_B.t47 53.4328166500979
Riso5035 VDD_B.t150 VDD_B.t48 505.221388468467
Riso5036 VDD_B.t150 VDD_B.t49 311.27816115513
Riso5037 VDD_B.t150 VDD_B.t50 179.237488911634
Riso5038 VDD_B.t150 VDD_B.t51 1341.84217438033
Riso5039 VDD_B.t150 VDD_B.t52 311.27816115513
Riso5040 VDD_B.t150 VDD_B.t53 226.594590021552
Riso5041 VDD_B.t150 VDD_B.t55 5962.0042154897
Riso5042 VDD_B.t150 VDD_B.t56 605.26808998638
Riso5043 VDD_B.t150 VDD_B.t57 459.386310049506
Riso5044 VDD_B.t150 VDD_B.t58 230038.946592346
Riso5045 VDD_B.t150 VDD_B.t59 1323.13936480607
Riso5046 VDD_B.t150 VDD_B.t6 3829.41585898366
Riso5047 VDD_B.t150 VDD_B.t60 61.9506250589044
Riso5048 VDD_B.t150 VDD_B.t61 1135.25452657619
Riso5049 VDD_B.t150 VDD_B.t62 1338.05430346699
Riso5050 VDD_B.t150 VDD_B.t63 773.100248946967
Riso5051 VDD_B.t150 VDD_B.t64 549.0144279268
Riso5052 VDD_B.t150 VDD_B.t66 3086.33192714286
Riso5053 VDD_B.t150 VDD_B.t67 30.7617494333052
Riso5054 VDD_B.t150 VDD_B.t68 0.0669341012565195
Riso5055 VDD_B.t150 VDD_B.t69 1319.35740874291
Riso5056 VDD_B.t150 VDD_B.t70 891.207645899146
Riso5057 VDD_B.t150 VDD_B.t71 19611.7763497599
Riso5058 VDD_B.t150 VDD_B.t73 2815.8163882465
Riso5059 VDD_B.t150 VDD_B.t75 3086.33192714286
Riso5060 VDD_B.t150 VDD_B.t76 122.004214673235
Riso5061 VDD_B.t150 VDD_B.t77 201.975792436794
Riso5062 VDD_B.t150 VDD_B.t78 179.237488911634
Riso5063 VDD_B.t150 VDD_B.t79 71.2970558025263
Riso5064 VDD_B.t150 VDD_B.t8 5265.31361470027
Riso5065 VDD_B.t150 VDD_B.t80 505.221388468467
Riso5066 VDD_B.t150 VDD_B.t81 49888.871132882
Riso5067 VDD_B.t150 VDD_B.t82 7686.20303549148
Riso5068 VDD_B.t150 VDD_B.t83 45.7861323906484
Riso5069 VDD_B.t150 VDD_B.t85 6416.2309050866
Riso5070 VDD_B.t150 VDD_B.t86 158.362052168784
Riso5071 VDD_B.t150 VDD_B.t87 1329.5030221273
Riso5072 VDD_B.t150 VDD_B.t88 201.975792436794
Riso5073 VDD_B.t150 VDD_B.t89 659.167993352583
Riso5074 VDD_B.t150 VDD_B.t9 281.348299017911
Riso5075 VDD_B.t150 VDD_B.t90 1338.05430346699
Riso5076 VDD_B.t150 VDD_B.t91 832.029142007966
Riso5077 VDD_B.t150 VDD_B.t92 253.075018707156
Riso5078 VDD_B.t150 VDD_B.t94 6746.32558952612
Riso5079 VDD_B.t150 VDD_B.t95 175.341344923328
Riso5080 VDD_B.t150 VDD_B.t96 10316.4477663412
Riso5081 VDD_B.t150 VDD_B.t97 14808.8788043958
Riso5082 VDD_B.t150 VDD_B.t99 6746.32558952612
Riso5083 VDD_B.t151 VDD_B.t152 35616.2055307152
Riso5084 VDD_B.t151 VDD_B.t153 163.056464873166
Riso5085 VDD_B.t151 VDD_B.t154 41.5684881807917
Riso5086 VDD_B.t151 VDD_B.t17 1455.50011097894
Riso5087 VDD_B.t151 VDD_B.t18 40.0023380695389
Riso5088 VDD_B.t151 VDD_B.t2 1972.30772813199
Riso5089 VDD_B.t151 VDD_B.t20 1504.05653041452
Riso5090 VDD_B.t151 VDD_B.t22 1924.27406503396
Riso5091 VDD_B.t151 VDD_B.t23 41.5684881807917
Riso5092 VDD_B.t151 VDD_B.t24 44658.0524198948
Riso5093 VDD_B.t151 VDD_B.t25 2088.57483846032
Riso5094 VDD_B.t151 VDD_B.t26 180.520421687464
Riso5095 VDD_B.t151 VDD_B.t27 302.175878670212
Riso5096 VDD_B.t151 VDD_B.t28 591.912234192009
Riso5097 VDD_B.t151 VDD_B.t3 82046.2970546993
Riso5098 VDD_B.t151 VDD_B.t30 1504.05653041452
Riso5099 VDD_B.t151 VDD_B.t31 248.714445032871
Riso5100 VDD_B.t151 VDD_B.t32 19864.284740491
Riso5101 VDD_B.t151 VDD_B.t33 203.045249718331
Riso5102 VDD_B.t151 VDD_B.t34 120.666385408099
Riso5103 VDD_B.t151 VDD_B.t35 33214.6811033208
Riso5104 VDD_B.t151 VDD_B.t36 35054.4928861073
Riso5105 VDD_B.t151 VDD_B.t37 225.792145981379
Riso5106 VDD_B.t151 VDD_B.t38 302.175878670212
Riso5107 VDD_B.t151 VDD_B.t39 481.195821401675
Riso5108 VDD_B.t151 VDD_B.t4 2088.57483846032
Riso5109 VDD_B.t151 VDD_B.t41 1100.82418265034
Riso5110 VDD_B.t151 VDD_B.t42 49.1949353744108
Riso5111 VDD_B.t151 VDD_B.t43 159.056474678991
Riso5112 VDD_B.t151 VDD_B.t44 45686.3435457335
Riso5113 VDD_B.t151 VDD_B.t45 134117.322624064
Riso5114 VDD_B.t151 VDD_B.t46 660.97206460934
Riso5115 VDD_B.t151 VDD_B.t47 557.818178857911
Riso5116 VDD_B.t151 VDD_B.t48 57.9296081415201
Riso5117 VDD_B.t151 VDD_B.t49 122.236935638833
Riso5118 VDD_B.t151 VDD_B.t50 240.737547150155
Riso5119 VDD_B.t151 VDD_B.t51 248.714445032871
Riso5120 VDD_B.t151 VDD_B.t52 122.236935638833
Riso5121 VDD_B.t151 VDD_B.t53 186.780690835071
Riso5122 VDD_B.t151 VDD_B.t55 1924.27406503396
Riso5123 VDD_B.t151 VDD_B.t56 41.5860517205105
Riso5124 VDD_B.t151 VDD_B.t57 67.6116675155874
Riso5125 VDD_B.t151 VDD_B.t58 90450.9355962875
Riso5126 VDD_B.t151 VDD_B.t59 519.744517430427
Riso5127 VDD_B.t151 VDD_B.t6 1478.68071966304
Riso5128 VDD_B.t151 VDD_B.t60 520.453534288652
Riso5129 VDD_B.t151 VDD_B.t61 120.666385408099
Riso5130 VDD_B.t151 VDD_B.t62 226.049442604235
Riso5131 VDD_B.t151 VDD_B.t63 49.1949353744108
Riso5132 VDD_B.t151 VDD_B.t64 53.2484682365991
Riso5133 VDD_B.t151 VDD_B.t66 1359.88788403463
Riso5134 VDD_B.t151 VDD_B.t67 665.060543059074
Riso5135 VDD_B.t151 VDD_B.t68 659.167993352583
Riso5136 VDD_B.t151 VDD_B.t69 203.045249718331
Riso5137 VDD_B.t151 VDD_B.t70 67.4118804049838
Riso5138 VDD_B.t151 VDD_B.t71 19007.4352418174
Riso5139 VDD_B.t151 VDD_B.t73 1100.82418265034
Riso5140 VDD_B.t151 VDD_B.t75 1359.88788403463
Riso5141 VDD_B.t151 VDD_B.t76 334.766279402891
Riso5142 VDD_B.t151 VDD_B.t77 212.707377609448
Riso5143 VDD_B.t151 VDD_B.t78 240.737547150155
Riso5144 VDD_B.t151 VDD_B.t79 481.195821401675
Riso5145 VDD_B.t151 VDD_B.t8 1972.30772813199
Riso5146 VDD_B.t151 VDD_B.t80 57.9296081415201
Riso5147 VDD_B.t151 VDD_B.t81 48351.5348346933
Riso5148 VDD_B.t151 VDD_B.t82 7449.35103516789
Riso5149 VDD_B.t151 VDD_B.t83 591.912234192009
Riso5150 VDD_B.t151 VDD_B.t85 2297.84404394583
Riso5151 VDD_B.t151 VDD_B.t86 270.670294333646
Riso5152 VDD_B.t151 VDD_B.t87 269.971423339958
Riso5153 VDD_B.t151 VDD_B.t88 212.707377609448
Riso5154 VDD_B.t151 VDD_B.t89 0.0669665300352238
Riso5155 VDD_B.t151 VDD_B.t9 141.554943063187
Riso5156 VDD_B.t151 VDD_B.t90 226.049442604235
Riso5157 VDD_B.t151 VDD_B.t91 57.8232925129455
Riso5158 VDD_B.t151 VDD_B.t92 163.056464873166
Riso5159 VDD_B.t151 VDD_B.t94 2287.31850610897
Riso5160 VDD_B.t151 VDD_B.t95 53.7425555821795
Riso5161 VDD_B.t151 VDD_B.t96 9998.54420870565
Riso5162 VDD_B.t151 VDD_B.t97 14352.5400177186
Riso5163 VDD_B.t151 VDD_B.t99 2287.31850610897
Riso5164 VDD_B.t152 VDD_B.t153 64642.0937813956
Riso5165 VDD_B.t152 VDD_B.t154 32768.8248977583
Riso5166 VDD_B.t152 VDD_B.t17 5316.83190892412
Riso5167 VDD_B.t152 VDD_B.t18 25871.0387410101
Riso5168 VDD_B.t152 VDD_B.t2 15742.5675674159
Riso5169 VDD_B.t152 VDD_B.t20 13027.2152624097
Riso5170 VDD_B.t152 VDD_B.t22 10729.3200325194
Riso5171 VDD_B.t152 VDD_B.t23 32768.8248977583
Riso5172 VDD_B.t152 VDD_B.t24 240118.604731931
Riso5173 VDD_B.t152 VDD_B.t25 11195.1547335454
Riso5174 VDD_B.t152 VDD_B.t26 12546.4322145158
Riso5175 VDD_B.t152 VDD_B.t27 68123.427738146
Riso5176 VDD_B.t152 VDD_B.t28 47742.2108029834
Riso5177 VDD_B.t152 VDD_B.t3 441148.713494264
Riso5178 VDD_B.t152 VDD_B.t30 13027.2152624097
Riso5179 VDD_B.t152 VDD_B.t31 8890.5969200344
Riso5180 VDD_B.t152 VDD_B.t32 55.8740057963428
Riso5181 VDD_B.t152 VDD_B.t33 11229.0695890973
Riso5182 VDD_B.t152 VDD_B.t34 17076.8108236485
Riso5183 VDD_B.t152 VDD_B.t35 22.7266584716211
Riso5184 VDD_B.t152 VDD_B.t36 17.6387645370045
Riso5185 VDD_B.t152 VDD_B.t37 30905.9795105654
Riso5186 VDD_B.t152 VDD_B.t38 68123.427738146
Riso5187 VDD_B.t152 VDD_B.t39 57736.132102256
Riso5188 VDD_B.t152 VDD_B.t4 11195.1547335454
Riso5189 VDD_B.t152 VDD_B.t41 9975.23685739766
Riso5190 VDD_B.t152 VDD_B.t42 30042.0039678296
Riso5191 VDD_B.t152 VDD_B.t43 13962.7053441234
Riso5192 VDD_B.t152 VDD_B.t44 41.0267453399892
Riso5193 VDD_B.t152 VDD_B.t45 129.993918427904
Riso5194 VDD_B.t152 VDD_B.t46 29853.0991835583
Riso5195 VDD_B.t152 VDD_B.t47 51307.3355059756
Riso5196 VDD_B.t152 VDD_B.t48 44613.4498650435
Riso5197 VDD_B.t152 VDD_B.t49 59591.5721374388
Riso5198 VDD_B.t152 VDD_B.t50 68609.5043794157
Riso5199 VDD_B.t152 VDD_B.t51 8890.5969200344
Riso5200 VDD_B.t152 VDD_B.t52 59591.5721374388
Riso5201 VDD_B.t152 VDD_B.t53 66525.1660386221
Riso5202 VDD_B.t152 VDD_B.t55 10729.3200325194
Riso5203 VDD_B.t152 VDD_B.t56 38561.6986071689
Riso5204 VDD_B.t152 VDD_B.t57 47627.7718553489
Riso5205 VDD_B.t152 VDD_B.t58 834888.673072596
Riso5206 VDD_B.t152 VDD_B.t59 4783.58696714569
Riso5207 VDD_B.t152 VDD_B.t6 7070.85193795241
Riso5208 VDD_B.t152 VDD_B.t60 54672.7624045671
Riso5209 VDD_B.t152 VDD_B.t61 17076.8108236485
Riso5210 VDD_B.t152 VDD_B.t62 10010.9586274615
Riso5211 VDD_B.t152 VDD_B.t63 30042.0039678296
Riso5212 VDD_B.t152 VDD_B.t64 9598.73094343039
Riso5213 VDD_B.t152 VDD_B.t66 5841.27805498667
Riso5214 VDD_B.t152 VDD_B.t67 33223.2834244355
Riso5215 VDD_B.t152 VDD_B.t68 36748.622231722
Riso5216 VDD_B.t152 VDD_B.t69 11229.0695890973
Riso5217 VDD_B.t152 VDD_B.t70 25005.1729960022
Riso5218 VDD_B.t152 VDD_B.t71 79.4376573695116
Riso5219 VDD_B.t152 VDD_B.t73 9975.23685739766
Riso5220 VDD_B.t152 VDD_B.t75 5841.27805498667
Riso5221 VDD_B.t152 VDD_B.t76 66889.2032337124
Riso5222 VDD_B.t152 VDD_B.t77 67869.6067636978
Riso5223 VDD_B.t152 VDD_B.t78 68609.5043794157
Riso5224 VDD_B.t152 VDD_B.t79 57736.132102256
Riso5225 VDD_B.t152 VDD_B.t8 15742.5675674159
Riso5226 VDD_B.t152 VDD_B.t80 44613.4498650435
Riso5227 VDD_B.t152 VDD_B.t81 42.4996973298547
Riso5228 VDD_B.t152 VDD_B.t82 140.560684996625
Riso5229 VDD_B.t152 VDD_B.t83 47742.2108029834
Riso5230 VDD_B.t152 VDD_B.t85 16377.7233749231
Riso5231 VDD_B.t152 VDD_B.t86 68700.2576807626
Riso5232 VDD_B.t152 VDD_B.t87 7865.1903033469
Riso5233 VDD_B.t152 VDD_B.t88 67869.6067636978
Riso5234 VDD_B.t152 VDD_B.t89 35616.2055307152
Riso5235 VDD_B.t152 VDD_B.t9 62301.2478769614
Riso5236 VDD_B.t152 VDD_B.t90 10010.9586274615
Riso5237 VDD_B.t152 VDD_B.t91 27450.9962684167
Riso5238 VDD_B.t152 VDD_B.t92 64642.0937813956
Riso5239 VDD_B.t152 VDD_B.t94 14502.4312218933
Riso5240 VDD_B.t152 VDD_B.t95 28966.2730737994
Riso5241 VDD_B.t152 VDD_B.t96 92.1706986842272
Riso5242 VDD_B.t152 VDD_B.t97 88.526807371465
Riso5243 VDD_B.t152 VDD_B.t99 14502.4312218933
Riso5244 VDD_B.t153 VDD_B.t154 186.771253923217
Riso5245 VDD_B.t153 VDD_B.t17 3148.00161807525
Riso5246 VDD_B.t153 VDD_B.t18 39.1255153715147
Riso5247 VDD_B.t153 VDD_B.t2 3944.59383237589
Riso5248 VDD_B.t153 VDD_B.t20 2919.60390994763
Riso5249 VDD_B.t153 VDD_B.t22 4565.86054433696
Riso5250 VDD_B.t153 VDD_B.t23 186.771253923217
Riso5251 VDD_B.t153 VDD_B.t24 105475.991206477
Riso5252 VDD_B.t153 VDD_B.t25 4929.32575849544
Riso5253 VDD_B.t153 VDD_B.t26 557.758256205885
Riso5254 VDD_B.t153 VDD_B.t27 78.3364549445744
Riso5255 VDD_B.t153 VDD_B.t28 207.168470363816
Riso5256 VDD_B.t153 VDD_B.t3 193781.726648029
Riso5257 VDD_B.t153 VDD_B.t30 2919.60390994763
Riso5258 VDD_B.t153 VDD_B.t31 693.757510749727
Riso5259 VDD_B.t153 VDD_B.t32 36052.9410127026
Riso5260 VDD_B.t153 VDD_B.t33 605.32356241931
Riso5261 VDD_B.t153 VDD_B.t34 417.95833367095
Riso5262 VDD_B.t153 VDD_B.t35 60283.4159003376
Riso5263 VDD_B.t153 VDD_B.t36 63622.6061377827
Riso5264 VDD_B.t153 VDD_B.t37 67.9250920188268
Riso5265 VDD_B.t153 VDD_B.t38 78.3364549445744
Riso5266 VDD_B.t153 VDD_B.t39 150.644179089864
Riso5267 VDD_B.t153 VDD_B.t4 4929.32575849544
Riso5268 VDD_B.t153 VDD_B.t41 2104.7484590425
Riso5269 VDD_B.t153 VDD_B.t42 212.671981891566
Riso5270 VDD_B.t153 VDD_B.t43 509.996514282912
Riso5271 VDD_B.t153 VDD_B.t44 82919.0212715245
Riso5272 VDD_B.t153 VDD_B.t45 243417.972734288
Riso5273 VDD_B.t153 VDD_B.t46 265.826951320732
Riso5274 VDD_B.t153 VDD_B.t47 188.420748276079
Riso5275 VDD_B.t153 VDD_B.t48 105.04328197021
Riso5276 VDD_B.t153 VDD_B.t49 48.1278836535006
Riso5277 VDD_B.t153 VDD_B.t50 57.5935900397299
Riso5278 VDD_B.t153 VDD_B.t51 693.757510749727
Riso5279 VDD_B.t153 VDD_B.t52 48.1278836535006
Riso5280 VDD_B.t153 VDD_B.t53 41.2053257384006
Riso5281 VDD_B.t153 VDD_B.t55 4565.86054433696
Riso5282 VDD_B.t153 VDD_B.t56 141.561062639702
Riso5283 VDD_B.t153 VDD_B.t57 89.8237517697841
Riso5284 VDD_B.t153 VDD_B.t58 171908.328659705
Riso5285 VDD_B.t153 VDD_B.t59 988.770335029649
Riso5286 VDD_B.t153 VDD_B.t6 3378.80555528526
Riso5287 VDD_B.t153 VDD_B.t60 169.366146229877
Riso5288 VDD_B.t153 VDD_B.t61 417.95833367095
Riso5289 VDD_B.t153 VDD_B.t62 651.256195069261
Riso5290 VDD_B.t153 VDD_B.t63 212.671981891566
Riso5291 VDD_B.t153 VDD_B.t64 191.915525696733
Riso5292 VDD_B.t153 VDD_B.t66 3041.94027309122
Riso5293 VDD_B.t153 VDD_B.t67 261.788045661227
Riso5294 VDD_B.t153 VDD_B.t68 253.075018707156
Riso5295 VDD_B.t153 VDD_B.t69 605.32356241931
Riso5296 VDD_B.t153 VDD_B.t70 270.398290654681
Riso5297 VDD_B.t153 VDD_B.t71 34497.7909110997
Riso5298 VDD_B.t153 VDD_B.t73 2104.7484590425
Riso5299 VDD_B.t153 VDD_B.t75 3041.94027309122
Riso5300 VDD_B.t153 VDD_B.t76 90.1733346564786
Riso5301 VDD_B.t153 VDD_B.t77 48.8584510272282
Riso5302 VDD_B.t153 VDD_B.t78 57.5935900397299
Riso5303 VDD_B.t153 VDD_B.t79 150.644179089864
Riso5304 VDD_B.t153 VDD_B.t8 3944.59383237589
Riso5305 VDD_B.t153 VDD_B.t80 105.04328197021
Riso5306 VDD_B.t153 VDD_B.t81 87756.2447398619
Riso5307 VDD_B.t153 VDD_B.t82 13520.2961980489
Riso5308 VDD_B.t153 VDD_B.t83 207.168470363816
Riso5309 VDD_B.t153 VDD_B.t85 4818.80367108231
Riso5310 VDD_B.t153 VDD_B.t86 67.4329164386075
Riso5311 VDD_B.t153 VDD_B.t87 730.696095122855
Riso5312 VDD_B.t153 VDD_B.t88 48.8584510272282
Riso5313 VDD_B.t153 VDD_B.t89 163.056464873166
Riso5314 VDD_B.t153 VDD_B.t9 40.9496334545207
Riso5315 VDD_B.t153 VDD_B.t90 651.256195069261
Riso5316 VDD_B.t153 VDD_B.t91 240.631817454669
Riso5317 VDD_B.t153 VDD_B.t92 0.0669652355119561
Riso5318 VDD_B.t153 VDD_B.t94 5082.94964813912
Riso5319 VDD_B.t153 VDD_B.t95 28.6712636600458
Riso5320 VDD_B.t153 VDD_B.t96 18146.9873835716
Riso5321 VDD_B.t153 VDD_B.t97 26049.3285009401
Riso5322 VDD_B.t153 VDD_B.t99 5082.94964813912
Riso5323 VDD_B.t154 VDD_B.t17 1326.65025395191
Riso5324 VDD_B.t154 VDD_B.t18 46.7725056184506
Riso5325 VDD_B.t154 VDD_B.t2 1819.27678539836
Riso5326 VDD_B.t154 VDD_B.t20 1394.63975671712
Riso5327 VDD_B.t154 VDD_B.t22 1728.97741390606
Riso5328 VDD_B.t154 VDD_B.t23 0.0669662820208451
Riso5329 VDD_B.t154 VDD_B.t24 40197.243530436
Riso5330 VDD_B.t154 VDD_B.t25 1880.42098644039
Riso5331 VDD_B.t154 VDD_B.t26 157.42144870003
Riso5332 VDD_B.t154 VDD_B.t27 339.182369243641
Riso5333 VDD_B.t154 VDD_B.t28 647.395784527673
Riso5334 VDD_B.t154 VDD_B.t3 73850.8467066288
Riso5335 VDD_B.t154 VDD_B.t30 1394.63975671712
Riso5336 VDD_B.t154 VDD_B.t31 219.634108086993
Riso5337 VDD_B.t154 VDD_B.t32 18276.2104688273
Riso5338 VDD_B.t154 VDD_B.t33 177.835502831731
Riso5339 VDD_B.t154 VDD_B.t34 103.836600495235
Riso5340 VDD_B.t154 VDD_B.t35 30559.2932456256
Riso5341 VDD_B.t154 VDD_B.t36 32252.0190499781
Riso5342 VDD_B.t154 VDD_B.t37 250.103104855494
Riso5343 VDD_B.t154 VDD_B.t38 339.182369243641
Riso5344 VDD_B.t154 VDD_B.t39 531.215697597027
Riso5345 VDD_B.t154 VDD_B.t4 1880.42098644039
Riso5346 VDD_B.t154 VDD_B.t41 1023.52881272152
Riso5347 VDD_B.t154 VDD_B.t42 41.3920115011287
Riso5348 VDD_B.t154 VDD_B.t43 138.091970591533
Riso5349 VDD_B.t154 VDD_B.t44 42033.893548202
Riso5350 VDD_B.t154 VDD_B.t45 123395.151036906
Riso5351 VDD_B.t154 VDD_B.t46 714.152537789558
Riso5352 VDD_B.t154 VDD_B.t47 611.914701113251
Riso5353 VDD_B.t154 VDD_B.t48 68.2177320466314
Riso5354 VDD_B.t154 VDD_B.t49 141.234860679856
Riso5355 VDD_B.t154 VDD_B.t50 272.304049543724
Riso5356 VDD_B.t154 VDD_B.t51 219.634108086993
Riso5357 VDD_B.t154 VDD_B.t52 141.234860679856
Riso5358 VDD_B.t154 VDD_B.t53 213.031225003816
Riso5359 VDD_B.t154 VDD_B.t55 1728.97741390606
Riso5360 VDD_B.t154 VDD_B.t56 49.3293239317583
Riso5361 VDD_B.t154 VDD_B.t57 79.3304376476345
Riso5362 VDD_B.t154 VDD_B.t58 84191.8568258212
Riso5363 VDD_B.t154 VDD_B.t59 483.691717930196
Riso5364 VDD_B.t154 VDD_B.t6 1343.76317638053
Riso5365 VDD_B.t154 VDD_B.t60 572.699152676491
Riso5366 VDD_B.t154 VDD_B.t61 103.836600495235
Riso5367 VDD_B.t154 VDD_B.t62 198.819623872392
Riso5368 VDD_B.t154 VDD_B.t63 41.3920115011287
Riso5369 VDD_B.t154 VDD_B.t64 45.6220470774454
Riso5370 VDD_B.t154 VDD_B.t66 1237.84539302469
Riso5371 VDD_B.t154 VDD_B.t67 720.031644267619
Riso5372 VDD_B.t154 VDD_B.t68 715.266641029297
Riso5373 VDD_B.t154 VDD_B.t69 177.835502831731
Riso5374 VDD_B.t154 VDD_B.t70 57.1245731791539
Riso5375 VDD_B.t154 VDD_B.t71 17487.8628397809
Riso5376 VDD_B.t154 VDD_B.t73 1023.52881272152
Riso5377 VDD_B.t154 VDD_B.t75 1237.84539302469
Riso5378 VDD_B.t154 VDD_B.t76 374.445047604797
Riso5379 VDD_B.t154 VDD_B.t77 241.584026004858
Riso5380 VDD_B.t154 VDD_B.t78 272.304049543724
Riso5381 VDD_B.t154 VDD_B.t79 531.215697597027
Riso5382 VDD_B.t154 VDD_B.t8 1819.27678539836
Riso5383 VDD_B.t154 VDD_B.t80 68.2177320466314
Riso5384 VDD_B.t154 VDD_B.t81 44486.0128957175
Riso5385 VDD_B.t154 VDD_B.t82 6853.80365583398
Riso5386 VDD_B.t154 VDD_B.t83 647.395784527673
Riso5387 VDD_B.t154 VDD_B.t85 2102.77921412977
Riso5388 VDD_B.t154 VDD_B.t86 304.958900946666
Riso5389 VDD_B.t154 VDD_B.t87 239.298082847339
Riso5390 VDD_B.t154 VDD_B.t88 241.584026004858
Riso5391 VDD_B.t154 VDD_B.t89 41.5684881807917
Riso5392 VDD_B.t154 VDD_B.t9 162.846338096345
Riso5393 VDD_B.t154 VDD_B.t90 198.819623872392
Riso5394 VDD_B.t154 VDD_B.t91 48.8252232543145
Riso5395 VDD_B.t154 VDD_B.t92 186.771253923217
Riso5396 VDD_B.t154 VDD_B.t94 2074.10938932445
Riso5397 VDD_B.t154 VDD_B.t95 62.3642106207389
Riso5398 VDD_B.t154 VDD_B.t96 9199.19849757761
Riso5399 VDD_B.t154 VDD_B.t97 13205.1088449917
Riso5400 VDD_B.t154 VDD_B.t99 2074.10938932445
Riso5401 VDD_B.t16 VDD_B.t65 158.648
Riso5402 VDD_B.t17 VDD_B.t18 1129.48020855904
Riso5403 VDD_B.t17 VDD_B.t2 1372.077899053
Riso5404 VDD_B.t17 VDD_B.t20 1342.03947767937
Riso5405 VDD_B.t17 VDD_B.t22 502.981579847839
Riso5406 VDD_B.t17 VDD_B.t23 1326.65025395191
Riso5407 VDD_B.t17 VDD_B.t24 7893.90042869179
Riso5408 VDD_B.t17 VDD_B.t25 355.953305301629
Riso5409 VDD_B.t17 VDD_B.t26 488.667717381578
Riso5410 VDD_B.t17 VDD_B.t27 3855.23563176666
Riso5411 VDD_B.t17 VDD_B.t28 3365.01509849067
Riso5412 VDD_B.t17 VDD_B.t3 14502.7663410627
Riso5413 VDD_B.t17 VDD_B.t30 1342.03947767937
Riso5414 VDD_B.t17 VDD_B.t31 348.461605735593
Riso5415 VDD_B.t17 VDD_B.t32 2965.36538304496
Riso5416 VDD_B.t17 VDD_B.t33 437.865756841133
Riso5417 VDD_B.t17 VDD_B.t34 666.474082712226
Riso5418 VDD_B.t17 VDD_B.t35 4958.3293251882
Riso5419 VDD_B.t17 VDD_B.t36 5232.97873961551
Riso5420 VDD_B.t17 VDD_B.t37 1976.57362157508
Riso5421 VDD_B.t17 VDD_B.t38 3855.23563176666
Riso5422 VDD_B.t17 VDD_B.t39 3794.51793308369
Riso5423 VDD_B.t17 VDD_B.t4 355.953305301629
Riso5424 VDD_B.t17 VDD_B.t41 1150.96801054134
Riso5425 VDD_B.t17 VDD_B.t42 1206.29017895344
Riso5426 VDD_B.t17 VDD_B.t43 543.702279632381
Riso5427 VDD_B.t17 VDD_B.t44 6820.11476367253
Riso5428 VDD_B.t17 VDD_B.t45 20021.202422929
Riso5429 VDD_B.t17 VDD_B.t46 2258.4914694006
Riso5430 VDD_B.t17 VDD_B.t47 3540.85171126568
Riso5431 VDD_B.t17 VDD_B.t48 1889.21934783568
Riso5432 VDD_B.t17 VDD_B.t49 2761.73892111172
Riso5433 VDD_B.t17 VDD_B.t50 3645.34442459616
Riso5434 VDD_B.t17 VDD_B.t51 348.461605735593
Riso5435 VDD_B.t17 VDD_B.t52 2761.73892111172
Riso5436 VDD_B.t17 VDD_B.t53 3330.19064141061
Riso5437 VDD_B.t17 VDD_B.t55 502.981579847839
Riso5438 VDD_B.t17 VDD_B.t56 1592.62101296725
Riso5439 VDD_B.t17 VDD_B.t57 2046.41748180214
Riso5440 VDD_B.t17 VDD_B.t58 101021.306902081
Riso5441 VDD_B.t17 VDD_B.t59 576.443631011893
Riso5442 VDD_B.t17 VDD_B.t6 109.15919207108
Riso5443 VDD_B.t17 VDD_B.t60 3685.9111664088
Riso5444 VDD_B.t17 VDD_B.t61 666.474082712226
Riso5445 VDD_B.t17 VDD_B.t62 391.185142509131
Riso5446 VDD_B.t17 VDD_B.t63 1206.29017895344
Riso5447 VDD_B.t17 VDD_B.t64 375.55120446492
Riso5448 VDD_B.t17 VDD_B.t66 54.4157818506901
Riso5449 VDD_B.t17 VDD_B.t67 2488.68419519995
Riso5450 VDD_B.t17 VDD_B.t68 2720.28463465114
Riso5451 VDD_B.t17 VDD_B.t69 437.865756841133
Riso5452 VDD_B.t17 VDD_B.t70 990.843506472818
Riso5453 VDD_B.t17 VDD_B.t71 2837.45381335895
Riso5454 VDD_B.t17 VDD_B.t73 1150.96801054134
Riso5455 VDD_B.t17 VDD_B.t75 54.4157818506901
Riso5456 VDD_B.t17 VDD_B.t76 3907.2330377826
Riso5457 VDD_B.t17 VDD_B.t77 3497.95287941774
Riso5458 VDD_B.t17 VDD_B.t78 3645.34442459616
Riso5459 VDD_B.t17 VDD_B.t79 3794.51793308369
Riso5460 VDD_B.t17 VDD_B.t8 1372.077899053
Riso5461 VDD_B.t17 VDD_B.t80 1889.21934783568
Riso5462 VDD_B.t17 VDD_B.t81 7217.9778677673
Riso5463 VDD_B.t17 VDD_B.t82 1112.04848170591
Riso5464 VDD_B.t17 VDD_B.t83 3365.01509849067
Riso5465 VDD_B.t17 VDD_B.t85 1195.94765248677
Riso5466 VDD_B.t17 VDD_B.t86 3766.33188703317
Riso5467 VDD_B.t17 VDD_B.t87 309.498270512202
Riso5468 VDD_B.t17 VDD_B.t88 3497.95287941774
Riso5469 VDD_B.t17 VDD_B.t89 1455.50011097894
Riso5470 VDD_B.t17 VDD_B.t9 2956.89875634346
Riso5471 VDD_B.t17 VDD_B.t90 391.185142509131
Riso5472 VDD_B.t17 VDD_B.t91 1094.41224043306
Riso5473 VDD_B.t17 VDD_B.t92 3148.00161807525
Riso5474 VDD_B.t17 VDD_B.t94 921.361100771113
Riso5475 VDD_B.t17 VDD_B.t95 1313.43170862043
Riso5476 VDD_B.t17 VDD_B.t96 1492.5952413934
Riso5477 VDD_B.t17 VDD_B.t97 2142.56520601296
Riso5478 VDD_B.t17 VDD_B.t99 921.361100771113
Riso5479 VDD_B.t18 VDD_B.t2 1452.94748937496
Riso5480 VDD_B.t18 VDD_B.t20 1087.68480144535
Riso5481 VDD_B.t18 VDD_B.t22 1568.45919075308
Riso5482 VDD_B.t18 VDD_B.t23 46.7725056184506
Riso5483 VDD_B.t18 VDD_B.t24 36244.6142928535
Riso5484 VDD_B.t18 VDD_B.t25 1694.0039065843
Riso5485 VDD_B.t18 VDD_B.t26 168.166411893166
Riso5486 VDD_B.t18 VDD_B.t27 80.7451130723437
Riso5487 VDD_B.t18 VDD_B.t28 183.213705238521
Riso5488 VDD_B.t18 VDD_B.t3 66589.0299680799
Riso5489 VDD_B.t18 VDD_B.t30 1087.68480144535
Riso5490 VDD_B.t18 VDD_B.t31 219.427995950552
Riso5491 VDD_B.t18 VDD_B.t32 14429.0968795232
Riso5492 VDD_B.t18 VDD_B.t33 185.587092176331
Riso5493 VDD_B.t18 VDD_B.t34 119.367961451577
Riso5494 VDD_B.t18 VDD_B.t35 24126.6100301801
Riso5495 VDD_B.t18 VDD_B.t36 25463.0197122162
Riso5496 VDD_B.t18 VDD_B.t37 65.0107436655294
Riso5497 VDD_B.t18 VDD_B.t38 80.7451130723437
Riso5498 VDD_B.t18 VDD_B.t39 141.250494962329
Riso5499 VDD_B.t18 VDD_B.t4 1694.0039065843
Riso5500 VDD_B.t18 VDD_B.t41 788.580207213344
Riso5501 VDD_B.t18 VDD_B.t42 54.3516819546011
Riso5502 VDD_B.t18 VDD_B.t43 151.109260521731
Riso5503 VDD_B.t18 VDD_B.t44 33185.8249972042
Riso5504 VDD_B.t18 VDD_B.t45 97420.6656140116
Riso5505 VDD_B.t18 VDD_B.t46 218.459182879369
Riso5506 VDD_B.t18 VDD_B.t47 169.790548148494
Riso5507 VDD_B.t18 VDD_B.t48 24.2494765318815
Riso5508 VDD_B.t18 VDD_B.t49 28.0976937733944
Riso5509 VDD_B.t18 VDD_B.t50 61.6845442472127
Riso5510 VDD_B.t18 VDD_B.t51 219.427995950552
Riso5511 VDD_B.t18 VDD_B.t52 28.0976937733944
Riso5512 VDD_B.t18 VDD_B.t53 45.8112990021311
Riso5513 VDD_B.t18 VDD_B.t55 1568.45919075308
Riso5514 VDD_B.t18 VDD_B.t56 34.0220583179906
Riso5515 VDD_B.t18 VDD_B.t57 20.3386927694067
Riso5516 VDD_B.t18 VDD_B.t58 64551.9002393557
Riso5517 VDD_B.t18 VDD_B.t59 371.152324772098
Riso5518 VDD_B.t18 VDD_B.t6 1169.44477020178
Riso5519 VDD_B.t18 VDD_B.t60 155.636439938139
Riso5520 VDD_B.t18 VDD_B.t61 119.367961451577
Riso5521 VDD_B.t18 VDD_B.t62 202.886453959448
Riso5522 VDD_B.t18 VDD_B.t63 54.3516819546011
Riso5523 VDD_B.t18 VDD_B.t64 53.7657945650124
Riso5524 VDD_B.t18 VDD_B.t66 1066.71467290132
Riso5525 VDD_B.t18 VDD_B.t67 217.559484039093
Riso5526 VDD_B.t18 VDD_B.t68 213.098304206195
Riso5527 VDD_B.t18 VDD_B.t69 185.587092176331
Riso5528 VDD_B.t18 VDD_B.t70 71.8210889210246
Riso5529 VDD_B.t18 VDD_B.t71 13806.695187791
Riso5530 VDD_B.t18 VDD_B.t73 788.580207213344
Riso5531 VDD_B.t18 VDD_B.t75 1066.71467290132
Riso5532 VDD_B.t18 VDD_B.t76 91.2220807453754
Riso5533 VDD_B.t18 VDD_B.t77 53.3284298152796
Riso5534 VDD_B.t18 VDD_B.t78 61.6845442472127
Riso5535 VDD_B.t18 VDD_B.t79 141.250494962329
Riso5536 VDD_B.t18 VDD_B.t8 1452.94748937496
Riso5537 VDD_B.t18 VDD_B.t80 24.2494765318815
Riso5538 VDD_B.t18 VDD_B.t81 35121.7770746768
Riso5539 VDD_B.t18 VDD_B.t82 5411.08875452804
Riso5540 VDD_B.t18 VDD_B.t83 183.213705238521
Riso5541 VDD_B.t18 VDD_B.t85 1742.48062340923
Riso5542 VDD_B.t18 VDD_B.t86 70.8502140406715
Riso5543 VDD_B.t18 VDD_B.t87 234.42415177402
Riso5544 VDD_B.t18 VDD_B.t88 53.3284298152796
Riso5545 VDD_B.t18 VDD_B.t89 40.0023380695389
Riso5546 VDD_B.t18 VDD_B.t9 33.2377072878846
Riso5547 VDD_B.t18 VDD_B.t90 202.886453959448
Riso5548 VDD_B.t18 VDD_B.t91 62.7237200674222
Riso5549 VDD_B.t18 VDD_B.t92 39.1255153715147
Riso5550 VDD_B.t18 VDD_B.t94 1795.66414941832
Riso5551 VDD_B.t18 VDD_B.t95 12.1002202334218
Riso5552 VDD_B.t18 VDD_B.t96 7262.7816670153
Riso5553 VDD_B.t18 VDD_B.t97 10425.4541801225
Riso5554 VDD_B.t18 VDD_B.t99 1795.66414941832
Riso5555 VDD_B.t19 VDD_B.t29 158.648
Riso5556 VDD_B.t2 VDD_B.t20 42.6023736089367
Riso5557 VDD_B.t2 VDD_B.t22 181.745860055113
Riso5558 VDD_B.t2 VDD_B.t23 1819.27678539836
Riso5559 VDD_B.t2 VDD_B.t24 5706.53904333327
Riso5560 VDD_B.t2 VDD_B.t25 272.856186828685
Riso5561 VDD_B.t2 VDD_B.t26 728.12867679719
Riso5562 VDD_B.t2 VDD_B.t27 5054.45481435704
Riso5563 VDD_B.t2 VDD_B.t28 5730.75439997179
Riso5564 VDD_B.t2 VDD_B.t3 10484.1203799336
Riso5565 VDD_B.t2 VDD_B.t30 42.6023736089367
Riso5566 VDD_B.t2 VDD_B.t31 518.872992482942
Riso5567 VDD_B.t2 VDD_B.t32 8780.12803570229
Riso5568 VDD_B.t2 VDD_B.t33 653.449270643896
Riso5569 VDD_B.t2 VDD_B.t34 979.610675941647
Riso5570 VDD_B.t2 VDD_B.t35 14681.0799664851
Riso5571 VDD_B.t2 VDD_B.t36 15494.2873497609
Riso5572 VDD_B.t2 VDD_B.t37 2887.15346504163
Riso5573 VDD_B.t2 VDD_B.t38 5054.45481435704
Riso5574 VDD_B.t2 VDD_B.t39 5734.99739178471
Riso5575 VDD_B.t2 VDD_B.t4 272.856186828685
Riso5576 VDD_B.t2 VDD_B.t41 69.6517274744538
Riso5577 VDD_B.t2 VDD_B.t42 1673.9372431538
Riso5578 VDD_B.t2 VDD_B.t43 807.574592495743
Riso5579 VDD_B.t2 VDD_B.t44 20193.626453459
Riso5580 VDD_B.t2 VDD_B.t45 59280.6275095592
Riso5581 VDD_B.t2 VDD_B.t46 4732.99175164582
Riso5582 VDD_B.t2 VDD_B.t47 5782.89391805527
Riso5583 VDD_B.t2 VDD_B.t48 2474.82559674226
Riso5584 VDD_B.t2 VDD_B.t49 3478.74662995015
Riso5585 VDD_B.t2 VDD_B.t50 4638.80519249675
Riso5586 VDD_B.t2 VDD_B.t51 518.872992482942
Riso5587 VDD_B.t2 VDD_B.t52 3478.74662995015
Riso5588 VDD_B.t2 VDD_B.t53 4179.77469338731
Riso5589 VDD_B.t2 VDD_B.t55 181.745860055113
Riso5590 VDD_B.t2 VDD_B.t56 2132.85209255722
Riso5591 VDD_B.t2 VDD_B.t57 2654.79584131428
Riso5592 VDD_B.t2 VDD_B.t58 11933.8904869867
Riso5593 VDD_B.t2 VDD_B.t59 56.0435161016815
Riso5594 VDD_B.t2 VDD_B.t6 829.099684498729
Riso5595 VDD_B.t2 VDD_B.t60 5783.40209967898
Riso5596 VDD_B.t2 VDD_B.t61 979.610675941647
Riso5597 VDD_B.t2 VDD_B.t62 583.678004662029
Riso5598 VDD_B.t2 VDD_B.t63 1673.9372431538
Riso5599 VDD_B.t2 VDD_B.t64 548.177502812587
Riso5600 VDD_B.t2 VDD_B.t66 1187.88141428875
Riso5601 VDD_B.t2 VDD_B.t67 5017.45990908873
Riso5602 VDD_B.t2 VDD_B.t68 5265.31361470027
Riso5603 VDD_B.t2 VDD_B.t69 653.449270643896
Riso5604 VDD_B.t2 VDD_B.t70 1406.40127914736
Riso5605 VDD_B.t2 VDD_B.t71 8401.39563209622
Riso5606 VDD_B.t2 VDD_B.t73 69.6517274744538
Riso5607 VDD_B.t2 VDD_B.t75 1187.88141428875
Riso5608 VDD_B.t2 VDD_B.t76 5233.33835052928
Riso5609 VDD_B.t2 VDD_B.t77 4412.44019655296
Riso5610 VDD_B.t2 VDD_B.t78 4638.80519249675
Riso5611 VDD_B.t2 VDD_B.t79 5734.99739178471
Riso5612 VDD_B.t2 VDD_B.t8 0.821393783257179
Riso5613 VDD_B.t2 VDD_B.t80 2474.82559674226
Riso5614 VDD_B.t2 VDD_B.t81 21371.6563227654
Riso5615 VDD_B.t2 VDD_B.t82 3292.65597660018
Riso5616 VDD_B.t2 VDD_B.t83 5730.75439997179
Riso5617 VDD_B.t2 VDD_B.t85 41.7621862458547
Riso5618 VDD_B.t2 VDD_B.t86 4854.46693007678
Riso5619 VDD_B.t2 VDD_B.t87 459.0276408007
Riso5620 VDD_B.t2 VDD_B.t88 4412.44019655296
Riso5621 VDD_B.t2 VDD_B.t89 1972.30772813199
Riso5622 VDD_B.t2 VDD_B.t9 3710.06102689503
Riso5623 VDD_B.t2 VDD_B.t90 583.678004662029
Riso5624 VDD_B.t2 VDD_B.t91 1536.33134575777
Riso5625 VDD_B.t2 VDD_B.t92 3944.59383237589
Riso5626 VDD_B.t2 VDD_B.t94 66.6890568079654
Riso5627 VDD_B.t2 VDD_B.t95 1664.52053066
Riso5628 VDD_B.t2 VDD_B.t96 4419.41401212997
Riso5629 VDD_B.t2 VDD_B.t97 6343.90518659042
Riso5630 VDD_B.t2 VDD_B.t99 66.6890568079654
Riso5631 VDD_B.t20 VDD_B.t22 261.35200781984
Riso5632 VDD_B.t20 VDD_B.t23 1394.63975671712
Riso5633 VDD_B.t20 VDD_B.t24 7993.49436237739
Riso5634 VDD_B.t20 VDD_B.t25 381.841992933257
Riso5635 VDD_B.t20 VDD_B.t26 608.486907216966
Riso5636 VDD_B.t20 VDD_B.t27 3720.66055385074
Riso5637 VDD_B.t20 VDD_B.t28 4230.2429038013
Riso5638 VDD_B.t20 VDD_B.t3 14685.7414827277
Riso5639 VDD_B.t20 VDD_B.t30 0.822285475021503
Riso5640 VDD_B.t20 VDD_B.t31 453.353267823336
Riso5641 VDD_B.t20 VDD_B.t32 7265.69013998444
Riso5642 VDD_B.t20 VDD_B.t33 553.620210800882
Riso5643 VDD_B.t20 VDD_B.t34 791.384268118106
Riso5644 VDD_B.t20 VDD_B.t35 12148.8180494718
Riso5645 VDD_B.t20 VDD_B.t36 12821.7595877277
Riso5646 VDD_B.t20 VDD_B.t37 2124.9264349898
Riso5647 VDD_B.t20 VDD_B.t38 3720.66055385074
Riso5648 VDD_B.t20 VDD_B.t39 4222.58198795935
Riso5649 VDD_B.t20 VDD_B.t4 381.841992933257
Riso5650 VDD_B.t20 VDD_B.t41 46.1317526277642
Riso5651 VDD_B.t20 VDD_B.t42 1290.72996831
Riso5652 VDD_B.t20 VDD_B.t43 666.474886073863
Riso5653 VDD_B.t20 VDD_B.t44 16710.5345180414
Riso5654 VDD_B.t20 VDD_B.t45 49055.625275269
Riso5655 VDD_B.t20 VDD_B.t46 3520.00802913324
Riso5656 VDD_B.t20 VDD_B.t47 4264.18126601093
Riso5657 VDD_B.t20 VDD_B.t48 1863.77952148
Riso5658 VDD_B.t20 VDD_B.t49 2584.93589310823
Riso5659 VDD_B.t20 VDD_B.t50 3419.67505146938
Riso5660 VDD_B.t20 VDD_B.t51 453.353267823336
Riso5661 VDD_B.t20 VDD_B.t52 2584.93589310823
Riso5662 VDD_B.t20 VDD_B.t53 3088.78268562239
Riso5663 VDD_B.t20 VDD_B.t55 261.35200781984
Riso5664 VDD_B.t20 VDD_B.t56 1618.88865514528
Riso5665 VDD_B.t20 VDD_B.t57 1992.89776763278
Riso5666 VDD_B.t20 VDD_B.t58 7998.83271521049
Riso5667 VDD_B.t20 VDD_B.t59 37.3846208212211
Riso5668 VDD_B.t20 VDD_B.t6 947.039711732903
Riso5669 VDD_B.t20 VDD_B.t60 4260.90541004726
Riso5670 VDD_B.t20 VDD_B.t61 791.384268118106
Riso5671 VDD_B.t20 VDD_B.t62 501.909797921408
Riso5672 VDD_B.t20 VDD_B.t63 1290.72996831
Riso5673 VDD_B.t20 VDD_B.t64 439.007137489261
Riso5674 VDD_B.t20 VDD_B.t66 1195.33359480524
Riso5675 VDD_B.t20 VDD_B.t67 3725.34642245692
Riso5676 VDD_B.t20 VDD_B.t68 3903.03347230681
Riso5677 VDD_B.t20 VDD_B.t69 553.620210800882
Riso5678 VDD_B.t20 VDD_B.t70 1099.34358217509
Riso5679 VDD_B.t20 VDD_B.t71 6952.28328767159
Riso5680 VDD_B.t20 VDD_B.t73 46.1317526277642
Riso5681 VDD_B.t20 VDD_B.t75 1195.33359480524
Riso5682 VDD_B.t20 VDD_B.t76 3850.95874433657
Riso5683 VDD_B.t20 VDD_B.t77 3256.36214038667
Riso5684 VDD_B.t20 VDD_B.t78 3419.67505146938
Riso5685 VDD_B.t20 VDD_B.t79 4222.58198795935
Riso5686 VDD_B.t20 VDD_B.t8 42.6023736089367
Riso5687 VDD_B.t20 VDD_B.t80 1863.77952148
Riso5688 VDD_B.t20 VDD_B.t81 17685.3722392252
Riso5689 VDD_B.t20 VDD_B.t82 2724.72314370199
Riso5690 VDD_B.t20 VDD_B.t83 4230.2429038013
Riso5691 VDD_B.t20 VDD_B.t85 65.3997532377392
Riso5692 VDD_B.t20 VDD_B.t86 3575.61367820774
Riso5693 VDD_B.t20 VDD_B.t87 407.922721519227
Riso5694 VDD_B.t20 VDD_B.t88 3256.36214038667
Riso5695 VDD_B.t20 VDD_B.t89 1504.05653041452
Riso5696 VDD_B.t20 VDD_B.t9 2751.05240283671
Riso5697 VDD_B.t20 VDD_B.t90 501.909797921408
Riso5698 VDD_B.t20 VDD_B.t91 1192.32317750969
Riso5699 VDD_B.t20 VDD_B.t92 2919.60390994763
Riso5700 VDD_B.t20 VDD_B.t94 103.067168927486
Riso5701 VDD_B.t20 VDD_B.t95 1239.77818328129
Riso5702 VDD_B.t20 VDD_B.t96 3657.13263882643
Riso5703 VDD_B.t20 VDD_B.t97 5249.67849851171
Riso5704 VDD_B.t20 VDD_B.t99 103.067168927486
Riso5705 VDD_B.t21 VDD_B.t54 158.648
Riso5706 VDD_B.t22 VDD_B.t23 1728.97741390606
Riso5707 VDD_B.t22 VDD_B.t24 1126.29194237708
Riso5708 VDD_B.t22 VDD_B.t25 53.9140956750371
Riso5709 VDD_B.t22 VDD_B.t26 494.195418979469
Riso5710 VDD_B.t22 VDD_B.t27 6059.25034014014
Riso5711 VDD_B.t22 VDD_B.t28 6697.05282592639
Riso5712 VDD_B.t22 VDD_B.t3 2069.23675053544
Riso5713 VDD_B.t22 VDD_B.t30 261.35200781984
Riso5714 VDD_B.t22 VDD_B.t31 310.030467080106
Riso5715 VDD_B.t22 VDD_B.t32 5984.08126362644
Riso5716 VDD_B.t22 VDD_B.t33 425.379040728978
Riso5717 VDD_B.t22 VDD_B.t34 745.628923911632
Riso5718 VDD_B.t22 VDD_B.t35 10005.8649714461
Riso5719 VDD_B.t22 VDD_B.t36 10560.1050743142
Riso5720 VDD_B.t22 VDD_B.t37 3456.12113736201
Riso5721 VDD_B.t22 VDD_B.t38 6059.25034014014
Riso5722 VDD_B.t22 VDD_B.t39 6840.86153357507
Riso5723 VDD_B.t22 VDD_B.t4 53.9140956750371
Riso5724 VDD_B.t22 VDD_B.t41 353.870298318363
Riso5725 VDD_B.t22 VDD_B.t42 1546.62429810543
Riso5726 VDD_B.t22 VDD_B.t43 570.68270695557
Riso5727 VDD_B.t22 VDD_B.t44 13762.9316125513
Riso5728 VDD_B.t22 VDD_B.t45 40402.6104099514
Riso5729 VDD_B.t22 VDD_B.t46 5233.8111804537
Riso5730 VDD_B.t22 VDD_B.t47 6814.64027993373
Riso5731 VDD_B.t22 VDD_B.t48 2581.58241131643
Riso5732 VDD_B.t22 VDD_B.t49 3927.93661949008
Riso5733 VDD_B.t22 VDD_B.t50 5510.34212473785
Riso5734 VDD_B.t22 VDD_B.t51 310.030467080106
Riso5735 VDD_B.t22 VDD_B.t52 3927.93661949008
Riso5736 VDD_B.t22 VDD_B.t53 4887.60783314019
Riso5737 VDD_B.t22 VDD_B.t55 0.826338745669087
Riso5738 VDD_B.t22 VDD_B.t56 2132.07741398524
Riso5739 VDD_B.t22 VDD_B.t57 2820.21569597943
Riso5740 VDD_B.t22 VDD_B.t58 43898.7437538545
Riso5741 VDD_B.t22 VDD_B.t59 233.374529747708
Riso5742 VDD_B.t22 VDD_B.t6 215.874985774212
Riso5743 VDD_B.t22 VDD_B.t60 6862.33970362313
Riso5744 VDD_B.t22 VDD_B.t61 745.628923911632
Riso5745 VDD_B.t22 VDD_B.t62 364.101012482955
Riso5746 VDD_B.t22 VDD_B.t63 1546.62429810543
Riso5747 VDD_B.t22 VDD_B.t64 431.086409225212
Riso5748 VDD_B.t22 VDD_B.t66 403.511860550076
Riso5749 VDD_B.t22 VDD_B.t67 5614.86453860527
Riso5750 VDD_B.t22 VDD_B.t68 5962.0042154897
Riso5751 VDD_B.t22 VDD_B.t69 425.379040728978
Riso5752 VDD_B.t22 VDD_B.t70 1221.18880426444
Riso5753 VDD_B.t22 VDD_B.t71 5725.95684093787
Riso5754 VDD_B.t22 VDD_B.t73 353.870298318363
Riso5755 VDD_B.t22 VDD_B.t75 403.511860550076
Riso5756 VDD_B.t22 VDD_B.t76 6285.95539472171
Riso5757 VDD_B.t22 VDD_B.t77 5204.51825645559
Riso5758 VDD_B.t22 VDD_B.t78 5510.34212473785
Riso5759 VDD_B.t22 VDD_B.t79 6840.86153357507
Riso5760 VDD_B.t22 VDD_B.t8 181.745860055113
Riso5761 VDD_B.t22 VDD_B.t80 2581.58241131643
Riso5762 VDD_B.t22 VDD_B.t81 14565.8158575468
Riso5763 VDD_B.t22 VDD_B.t82 2244.10405600249
Riso5764 VDD_B.t22 VDD_B.t83 6697.05282592639
Riso5765 VDD_B.t22 VDD_B.t85 123.280317449893
Riso5766 VDD_B.t22 VDD_B.t86 5797.90152692882
Riso5767 VDD_B.t22 VDD_B.t87 262.708103286429
Riso5768 VDD_B.t22 VDD_B.t88 5204.51825645559
Riso5769 VDD_B.t22 VDD_B.t89 1924.27406503396
Riso5770 VDD_B.t22 VDD_B.t9 4244.53906980745
Riso5771 VDD_B.t22 VDD_B.t90 364.101012482955
Riso5772 VDD_B.t22 VDD_B.t91 1377.37747272439
Riso5773 VDD_B.t22 VDD_B.t92 4565.86054433696
Riso5774 VDD_B.t22 VDD_B.t94 82.663923723346
Riso5775 VDD_B.t22 VDD_B.t95 1852.20993968716
Riso5776 VDD_B.t22 VDD_B.t96 3012.0440702753
Riso5777 VDD_B.t22 VDD_B.t97 4323.67774261755
Riso5778 VDD_B.t22 VDD_B.t99 82.663923723346
Riso5779 VDD_B.t23 VDD_B.t24 40197.243530436
Riso5780 VDD_B.t23 VDD_B.t25 1880.42098644039
Riso5781 VDD_B.t23 VDD_B.t26 157.42144870003
Riso5782 VDD_B.t23 VDD_B.t27 339.182369243641
Riso5783 VDD_B.t23 VDD_B.t28 647.395784527673
Riso5784 VDD_B.t23 VDD_B.t3 73850.8467066288
Riso5785 VDD_B.t23 VDD_B.t30 1394.63975671712
Riso5786 VDD_B.t23 VDD_B.t31 219.634108086993
Riso5787 VDD_B.t23 VDD_B.t32 18276.2104688273
Riso5788 VDD_B.t23 VDD_B.t33 177.835502831731
Riso5789 VDD_B.t23 VDD_B.t34 103.836600495235
Riso5790 VDD_B.t23 VDD_B.t35 30559.2932456256
Riso5791 VDD_B.t23 VDD_B.t36 32252.0190499781
Riso5792 VDD_B.t23 VDD_B.t37 250.103104855494
Riso5793 VDD_B.t23 VDD_B.t38 339.182369243641
Riso5794 VDD_B.t23 VDD_B.t39 531.215697597027
Riso5795 VDD_B.t23 VDD_B.t4 1880.42098644039
Riso5796 VDD_B.t23 VDD_B.t41 1023.52881272152
Riso5797 VDD_B.t23 VDD_B.t42 41.3920115011287
Riso5798 VDD_B.t23 VDD_B.t43 138.091970591533
Riso5799 VDD_B.t23 VDD_B.t44 42033.893548202
Riso5800 VDD_B.t23 VDD_B.t45 123395.151036906
Riso5801 VDD_B.t23 VDD_B.t46 714.152537789558
Riso5802 VDD_B.t23 VDD_B.t47 611.914701113251
Riso5803 VDD_B.t23 VDD_B.t48 68.2177320466314
Riso5804 VDD_B.t23 VDD_B.t49 141.234860679856
Riso5805 VDD_B.t23 VDD_B.t50 272.304049543724
Riso5806 VDD_B.t23 VDD_B.t51 219.634108086993
Riso5807 VDD_B.t23 VDD_B.t52 141.234860679856
Riso5808 VDD_B.t23 VDD_B.t53 213.031225003816
Riso5809 VDD_B.t23 VDD_B.t55 1728.97741390606
Riso5810 VDD_B.t23 VDD_B.t56 49.3293239317583
Riso5811 VDD_B.t23 VDD_B.t57 79.3304376476345
Riso5812 VDD_B.t23 VDD_B.t58 84191.8568258212
Riso5813 VDD_B.t23 VDD_B.t59 483.691717930196
Riso5814 VDD_B.t23 VDD_B.t6 1343.76317638053
Riso5815 VDD_B.t23 VDD_B.t60 572.699152676491
Riso5816 VDD_B.t23 VDD_B.t61 103.836600495235
Riso5817 VDD_B.t23 VDD_B.t62 198.819623872392
Riso5818 VDD_B.t23 VDD_B.t63 41.3920115011287
Riso5819 VDD_B.t23 VDD_B.t64 45.6220470774454
Riso5820 VDD_B.t23 VDD_B.t66 1237.84539302469
Riso5821 VDD_B.t23 VDD_B.t67 720.031644267619
Riso5822 VDD_B.t23 VDD_B.t68 715.266641029297
Riso5823 VDD_B.t23 VDD_B.t69 177.835502831731
Riso5824 VDD_B.t23 VDD_B.t70 57.1245731791539
Riso5825 VDD_B.t23 VDD_B.t71 17487.8628397809
Riso5826 VDD_B.t23 VDD_B.t73 1023.52881272152
Riso5827 VDD_B.t23 VDD_B.t75 1237.84539302469
Riso5828 VDD_B.t23 VDD_B.t76 374.445047604797
Riso5829 VDD_B.t23 VDD_B.t77 241.584026004858
Riso5830 VDD_B.t23 VDD_B.t78 272.304049543724
Riso5831 VDD_B.t23 VDD_B.t79 531.215697597027
Riso5832 VDD_B.t23 VDD_B.t8 1819.27678539836
Riso5833 VDD_B.t23 VDD_B.t80 68.2177320466314
Riso5834 VDD_B.t23 VDD_B.t81 44486.0128957175
Riso5835 VDD_B.t23 VDD_B.t82 6853.80365583398
Riso5836 VDD_B.t23 VDD_B.t83 647.395784527673
Riso5837 VDD_B.t23 VDD_B.t85 2102.77921412977
Riso5838 VDD_B.t23 VDD_B.t86 304.958900946666
Riso5839 VDD_B.t23 VDD_B.t87 239.298082847339
Riso5840 VDD_B.t23 VDD_B.t88 241.584026004858
Riso5841 VDD_B.t23 VDD_B.t89 41.5684881807917
Riso5842 VDD_B.t23 VDD_B.t9 162.846338096345
Riso5843 VDD_B.t23 VDD_B.t90 198.819623872392
Riso5844 VDD_B.t23 VDD_B.t91 48.8252232543145
Riso5845 VDD_B.t23 VDD_B.t92 186.771253923217
Riso5846 VDD_B.t23 VDD_B.t94 2074.10938932445
Riso5847 VDD_B.t23 VDD_B.t95 62.3642106207389
Riso5848 VDD_B.t23 VDD_B.t96 9199.19849757761
Riso5849 VDD_B.t23 VDD_B.t97 13205.1088449917
Riso5850 VDD_B.t23 VDD_B.t99 2074.10938932445
Riso5851 VDD_B.t24 VDD_B.t25 700.088812654381
Riso5852 VDD_B.t24 VDD_B.t26 11890.1607444859
Riso5853 VDD_B.t24 VDD_B.t27 139702.413527705
Riso5854 VDD_B.t24 VDD_B.t28 151689.44671656
Riso5855 VDD_B.t24 VDD_B.t3 16259.8537299502
Riso5856 VDD_B.t24 VDD_B.t30 7993.49436237739
Riso5857 VDD_B.t24 VDD_B.t31 7577.16938760411
Riso5858 VDD_B.t24 VDD_B.t32 133921.743341555
Riso5859 VDD_B.t24 VDD_B.t33 10286.6274057894
Riso5860 VDD_B.t24 VDD_B.t34 17701.048116247
Riso5861 VDD_B.t24 VDD_B.t35 223927.921694731
Riso5862 VDD_B.t24 VDD_B.t36 236331.630390513
Riso5863 VDD_B.t24 VDD_B.t37 79173.9172759295
Riso5864 VDD_B.t24 VDD_B.t38 139702.413527705
Riso5865 VDD_B.t24 VDD_B.t39 156351.470344226
Riso5866 VDD_B.t24 VDD_B.t4 700.088812654381
Riso5867 VDD_B.t24 VDD_B.t41 10337.0123609173
Riso5868 VDD_B.t24 VDD_B.t42 36034.7723064292
Riso5869 VDD_B.t24 VDD_B.t43 13664.2108850038
Riso5870 VDD_B.t24 VDD_B.t44 308009.820362381
Riso5871 VDD_B.t24 VDD_B.t45 904196.949085434
Riso5872 VDD_B.t24 VDD_B.t46 116396.881519123
Riso5873 VDD_B.t24 VDD_B.t47 154865.393228737
Riso5874 VDD_B.t24 VDD_B.t48 59709.7188288663
Riso5875 VDD_B.t24 VDD_B.t49 90739.2691702769
Riso5876 VDD_B.t24 VDD_B.t50 127222.5432018
Riso5877 VDD_B.t24 VDD_B.t51 7577.16938760411
Riso5878 VDD_B.t24 VDD_B.t52 90739.2691702769
Riso5879 VDD_B.t24 VDD_B.t53 112902.118977469
Riso5880 VDD_B.t24 VDD_B.t54 158.648
Riso5881 VDD_B.t24 VDD_B.t55 1126.29194237708
Riso5882 VDD_B.t24 VDD_B.t56 49409.435405431
Riso5883 VDD_B.t24 VDD_B.t57 65192.2341235372
Riso5884 VDD_B.t24 VDD_B.t58 1146280.99325588
Riso5885 VDD_B.t24 VDD_B.t59 6551.36819524564
Riso5886 VDD_B.t24 VDD_B.t6 2996.55050361299
Riso5887 VDD_B.t24 VDD_B.t60 156421.979778187
Riso5888 VDD_B.t24 VDD_B.t61 17701.048116247
Riso5889 VDD_B.t24 VDD_B.t62 8851.16802980565
Riso5890 VDD_B.t24 VDD_B.t63 36034.7723064292
Riso5891 VDD_B.t24 VDD_B.t64 10198.0538215095
Riso5892 VDD_B.t24 VDD_B.t66 6133.55144794818
Riso5893 VDD_B.t24 VDD_B.t67 125324.34588921
Riso5894 VDD_B.t24 VDD_B.t68 133568.507162561
Riso5895 VDD_B.t24 VDD_B.t69 10286.6274057894
Riso5896 VDD_B.t24 VDD_B.t70 28606.554161589
Riso5897 VDD_B.t24 VDD_B.t71 128145.004831066
Riso5898 VDD_B.t24 VDD_B.t73 10337.0123609173
Riso5899 VDD_B.t24 VDD_B.t75 6133.55144794818
Riso5900 VDD_B.t24 VDD_B.t76 144764.805086218
Riso5901 VDD_B.t24 VDD_B.t77 120202.199547431
Riso5902 VDD_B.t24 VDD_B.t78 127222.5432018
Riso5903 VDD_B.t24 VDD_B.t79 156351.470344226
Riso5904 VDD_B.t24 VDD_B.t8 5706.53904333327
Riso5905 VDD_B.t24 VDD_B.t80 59709.7188288663
Riso5906 VDD_B.t24 VDD_B.t81 325978.102050805
Riso5907 VDD_B.t24 VDD_B.t82 50222.3004968987
Riso5908 VDD_B.t24 VDD_B.t83 151689.44671656
Riso5909 VDD_B.t24 VDD_B.t85 3919.97974276232
Riso5910 VDD_B.t24 VDD_B.t86 133787.161514991
Riso5911 VDD_B.t24 VDD_B.t87 6455.25432414376
Riso5912 VDD_B.t24 VDD_B.t88 120202.199547431
Riso5913 VDD_B.t24 VDD_B.t89 44658.0524198948
Riso5914 VDD_B.t24 VDD_B.t9 98053.2627783651
Riso5915 VDD_B.t24 VDD_B.t90 8851.16802980565
Riso5916 VDD_B.t24 VDD_B.t91 32172.2232489922
Riso5917 VDD_B.t24 VDD_B.t92 105475.991206477
Riso5918 VDD_B.t24 VDD_B.t94 2643.7627497018
Riso5919 VDD_B.t24 VDD_B.t95 42789.934359817
Riso5920 VDD_B.t24 VDD_B.t96 67408.5419535912
Riso5921 VDD_B.t24 VDD_B.t97 96762.4661880874
Riso5922 VDD_B.t24 VDD_B.t99 2643.7627497018
Riso5923 VDD_B.t25 VDD_B.t26 558.796497242216
Riso5924 VDD_B.t25 VDD_B.t27 6527.96890804708
Riso5925 VDD_B.t25 VDD_B.t28 7076.82453891163
Riso5926 VDD_B.t25 VDD_B.t3 1286.21136783216
Riso5927 VDD_B.t25 VDD_B.t30 381.841992933257
Riso5928 VDD_B.t25 VDD_B.t31 356.854575237474
Riso5929 VDD_B.t25 VDD_B.t32 6243.89201565059
Riso5930 VDD_B.t25 VDD_B.t33 483.766347412629
Riso5931 VDD_B.t25 VDD_B.t34 830.39757040831
Riso5932 VDD_B.t25 VDD_B.t35 10440.2894366826
Riso5933 VDD_B.t25 VDD_B.t36 11018.5929724462
Riso5934 VDD_B.t25 VDD_B.t37 3697.56023664702
Riso5935 VDD_B.t25 VDD_B.t38 6527.96890804708
Riso5936 VDD_B.t25 VDD_B.t39 7300.37904628956
Riso5937 VDD_B.t25 VDD_B.t4 0.824645528347862
Riso5938 VDD_B.t25 VDD_B.t41 493.025349495347
Riso5939 VDD_B.t25 VDD_B.t42 1686.20048534484
Riso5940 VDD_B.t25 VDD_B.t43 641.754643339989
Riso5941 VDD_B.t25 VDD_B.t44 14360.4765747243
Riso5942 VDD_B.t25 VDD_B.t45 42156.7698426037
Riso5943 VDD_B.t25 VDD_B.t46 5420.96024127099
Riso5944 VDD_B.t25 VDD_B.t47 7227.21567081837
Riso5945 VDD_B.t25 VDD_B.t48 2791.12943002009
Riso5946 VDD_B.t25 VDD_B.t49 4240.64734891569
Riso5947 VDD_B.t25 VDD_B.t50 5945.43996164589
Riso5948 VDD_B.t25 VDD_B.t51 356.854575237474
Riso5949 VDD_B.t25 VDD_B.t52 4240.64734891569
Riso5950 VDD_B.t25 VDD_B.t53 5276.36976211128
Riso5951 VDD_B.t25 VDD_B.t55 53.9140956750371
Riso5952 VDD_B.t25 VDD_B.t56 2310.31263419276
Riso5953 VDD_B.t25 VDD_B.t57 3047.13524691727
Riso5954 VDD_B.t25 VDD_B.t58 55813.4085843966
Riso5955 VDD_B.t25 VDD_B.t59 312.275228104277
Riso5956 VDD_B.t25 VDD_B.t6 133.720083242536
Riso5957 VDD_B.t25 VDD_B.t60 7301.88963074068
Riso5958 VDD_B.t25 VDD_B.t61 830.39757040831
Riso5959 VDD_B.t25 VDD_B.t62 416.553414596317
Riso5960 VDD_B.t25 VDD_B.t63 1686.20048534484
Riso5961 VDD_B.t25 VDD_B.t64 478.189397395748
Riso5962 VDD_B.t25 VDD_B.t66 275.665107652895
Riso5963 VDD_B.t25 VDD_B.t67 5838.74168020263
Riso5964 VDD_B.t25 VDD_B.t68 6225.01687632006
Riso5965 VDD_B.t25 VDD_B.t69 483.766347412629
Riso5966 VDD_B.t25 VDD_B.t70 1339.5922175676
Riso5967 VDD_B.t25 VDD_B.t71 5974.56060939679
Riso5968 VDD_B.t25 VDD_B.t73 493.025349495347
Riso5969 VDD_B.t25 VDD_B.t75 275.665107652895
Riso5970 VDD_B.t25 VDD_B.t76 6763.88815608854
Riso5971 VDD_B.t25 VDD_B.t77 5617.48292185749
Riso5972 VDD_B.t25 VDD_B.t78 5945.43996164589
Riso5973 VDD_B.t25 VDD_B.t79 7300.37904628956
Riso5974 VDD_B.t25 VDD_B.t8 272.856186828685
Riso5975 VDD_B.t25 VDD_B.t80 2791.12943002009
Riso5976 VDD_B.t25 VDD_B.t81 15198.2196310044
Riso5977 VDD_B.t25 VDD_B.t82 2341.53628272616
Riso5978 VDD_B.t25 VDD_B.t83 7076.82453891163
Riso5979 VDD_B.t25 VDD_B.t85 187.520176210158
Riso5980 VDD_B.t25 VDD_B.t86 6251.96817798526
Riso5981 VDD_B.t25 VDD_B.t87 304.238883849973
Riso5982 VDD_B.t25 VDD_B.t88 5617.48292185749
Riso5983 VDD_B.t25 VDD_B.t89 2088.57483846032
Riso5984 VDD_B.t25 VDD_B.t9 4582.43535858069
Riso5985 VDD_B.t25 VDD_B.t90 416.553414596317
Riso5986 VDD_B.t25 VDD_B.t91 1505.97516830973
Riso5987 VDD_B.t25 VDD_B.t92 4929.32575849544
Riso5988 VDD_B.t25 VDD_B.t94 126.497171779381
Riso5989 VDD_B.t25 VDD_B.t95 1999.79626533926
Riso5990 VDD_B.t25 VDD_B.t96 3142.81793522678
Riso5991 VDD_B.t25 VDD_B.t97 4511.39878388209
Riso5992 VDD_B.t25 VDD_B.t99 126.497171779381
Riso5993 VDD_B.t26 VDD_B.t27 856.039443662533
Riso5994 VDD_B.t26 VDD_B.t28 1279.63022329726
Riso5995 VDD_B.t26 VDD_B.t3 21844.7426076201
Riso5996 VDD_B.t26 VDD_B.t30 608.486907216966
Riso5997 VDD_B.t26 VDD_B.t31 52.9846070083475
Riso5998 VDD_B.t26 VDD_B.t32 6997.54222193829
Riso5999 VDD_B.t26 VDD_B.t33 39.5838280750919
Riso6000 VDD_B.t26 VDD_B.t34 55.2010235358109
Riso6001 VDD_B.t26 VDD_B.t35 11700.4531723682
Riso6002 VDD_B.t26 VDD_B.t36 12348.5590970797
Riso6003 VDD_B.t26 VDD_B.t37 560.973117519277
Riso6004 VDD_B.t26 VDD_B.t38 856.039443662533
Riso6005 VDD_B.t26 VDD_B.t39 1154.63111927026
Riso6006 VDD_B.t26 VDD_B.t4 558.796497242216
Riso6007 VDD_B.t26 VDD_B.t41 468.657990415764
Riso6008 VDD_B.t26 VDD_B.t42 136.578525030784
Riso6009 VDD_B.t26 VDD_B.t43 39.9666675060675
Riso6010 VDD_B.t26 VDD_B.t44 16093.814708344
Riso6011 VDD_B.t26 VDD_B.t45 47245.1759535141
Riso6012 VDD_B.t26 VDD_B.t46 1214.30158066139
Riso6013 VDD_B.t26 VDD_B.t47 1248.53101019061
Riso6014 VDD_B.t26 VDD_B.t48 263.414040803762
Riso6015 VDD_B.t26 VDD_B.t49 454.685622005334
Riso6016 VDD_B.t26 VDD_B.t50 732.461150170541
Riso6017 VDD_B.t26 VDD_B.t51 52.9846070083475
Riso6018 VDD_B.t26 VDD_B.t52 454.685622005334
Riso6019 VDD_B.t26 VDD_B.t53 613.683441940686
Riso6020 VDD_B.t26 VDD_B.t55 494.195418979469
Riso6021 VDD_B.t26 VDD_B.t56 205.913139082023
Riso6022 VDD_B.t26 VDD_B.t57 295.21089921818
Riso6023 VDD_B.t26 VDD_B.t58 39334.0897052422
Riso6024 VDD_B.t26 VDD_B.t59 225.212948640209
Riso6025 VDD_B.t26 VDD_B.t6 479.317875969705
Riso6026 VDD_B.t26 VDD_B.t60 1206.13781541047
Riso6027 VDD_B.t26 VDD_B.t61 55.2010235358109
Riso6028 VDD_B.t26 VDD_B.t62 46.0837815558315
Riso6029 VDD_B.t26 VDD_B.t63 136.578525030784
Riso6030 VDD_B.t26 VDD_B.t64 32.7610914743486
Riso6031 VDD_B.t26 VDD_B.t66 452.541274015357
Riso6032 VDD_B.t26 VDD_B.t67 1258.62195038939
Riso6033 VDD_B.t26 VDD_B.t68 1287.54249265844
Riso6034 VDD_B.t26 VDD_B.t69 39.5838280750919
Riso6035 VDD_B.t26 VDD_B.t70 101.310050512238
Riso6036 VDD_B.t26 VDD_B.t71 6695.70197834807
Riso6037 VDD_B.t26 VDD_B.t73 468.657990415764
Riso6038 VDD_B.t26 VDD_B.t75 452.541274015357
Riso6039 VDD_B.t26 VDD_B.t76 917.156367384221
Riso6040 VDD_B.t26 VDD_B.t77 672.091219289448
Riso6041 VDD_B.t26 VDD_B.t78 732.461150170541
Riso6042 VDD_B.t26 VDD_B.t79 1154.63111927026
Riso6043 VDD_B.t26 VDD_B.t8 728.12867679719
Riso6044 VDD_B.t26 VDD_B.t80 263.414040803762
Riso6045 VDD_B.t26 VDD_B.t81 17032.6750205919
Riso6046 VDD_B.t26 VDD_B.t82 2624.16437720367
Riso6047 VDD_B.t26 VDD_B.t83 1279.63022329726
Riso6048 VDD_B.t26 VDD_B.t85 748.307968882745
Riso6049 VDD_B.t26 VDD_B.t86 794.085530059845
Riso6050 VDD_B.t26 VDD_B.t87 59.9913776020765
Riso6051 VDD_B.t26 VDD_B.t88 672.091219289448
Riso6052 VDD_B.t26 VDD_B.t89 180.520421687464
Riso6053 VDD_B.t26 VDD_B.t9 504.679876698707
Riso6054 VDD_B.t26 VDD_B.t90 46.0837815558315
Riso6055 VDD_B.t26 VDD_B.t91 117.911430756381
Riso6056 VDD_B.t26 VDD_B.t92 557.758256205885
Riso6057 VDD_B.t26 VDD_B.t94 655.294604097211
Riso6058 VDD_B.t26 VDD_B.t95 208.744267885036
Riso6059 VDD_B.t26 VDD_B.t96 3522.16232159211
Riso6060 VDD_B.t26 VDD_B.t97 5055.93360536788
Riso6061 VDD_B.t26 VDD_B.t99 655.294604097211
Riso6062 VDD_B.t27 VDD_B.t28 106.727427254962
Riso6063 VDD_B.t27 VDD_B.t3 256662.910683635
Riso6064 VDD_B.t27 VDD_B.t30 3720.66055385074
Riso6065 VDD_B.t27 VDD_B.t31 1016.69722738712
Riso6066 VDD_B.t27 VDD_B.t32 37994.591111672
Riso6067 VDD_B.t27 VDD_B.t33 914.677696621613
Riso6068 VDD_B.t27 VDD_B.t34 673.246087337361
Riso6069 VDD_B.t27 VDD_B.t35 63530.0109675158
Riso6070 VDD_B.t27 VDD_B.t36 67049.035051324
Riso6071 VDD_B.t27 VDD_B.t37 31.7848239143496
Riso6072 VDD_B.t27 VDD_B.t38 0.0669626024057374
Riso6073 VDD_B.t27 VDD_B.t39 72.1846190224478
Riso6074 VDD_B.t27 VDD_B.t4 6527.96890804708
Riso6075 VDD_B.t27 VDD_B.t41 2674.99425303275
Riso6076 VDD_B.t27 VDD_B.t42 378.781489044167
Riso6077 VDD_B.t27 VDD_B.t43 795.203617997064
Riso6078 VDD_B.t27 VDD_B.t44 87384.6687703398
Riso6079 VDD_B.t27 VDD_B.t45 256527.375672704
Riso6080 VDD_B.t27 VDD_B.t46 151.419892268732
Riso6081 VDD_B.t27 VDD_B.t47 94.7636818469557
Riso6082 VDD_B.t27 VDD_B.t48 207.525510202921
Riso6083 VDD_B.t27 VDD_B.t49 105.050297983374
Riso6084 VDD_B.t27 VDD_B.t50 48.0822421431112
Riso6085 VDD_B.t27 VDD_B.t51 1016.69722738712
Riso6086 VDD_B.t27 VDD_B.t52 105.050297983374
Riso6087 VDD_B.t27 VDD_B.t53 66.949923758641
Riso6088 VDD_B.t27 VDD_B.t55 6059.25034014014
Riso6089 VDD_B.t27 VDD_B.t56 267.881957822298
Riso6090 VDD_B.t27 VDD_B.t57 181.37425508793
Riso6091 VDD_B.t27 VDD_B.t58 218253.411956214
Riso6092 VDD_B.t27 VDD_B.t59 1255.55086208395
Riso6093 VDD_B.t27 VDD_B.t6 4428.2452779483
Riso6094 VDD_B.t27 VDD_B.t60 83.1384224731862
Riso6095 VDD_B.t27 VDD_B.t61 673.246087337361
Riso6096 VDD_B.t27 VDD_B.t62 969.045848846009
Riso6097 VDD_B.t27 VDD_B.t63 378.781489044167
Riso6098 VDD_B.t27 VDD_B.t64 314.39932239758
Riso6099 VDD_B.t27 VDD_B.t66 3887.38537128005
Riso6100 VDD_B.t27 VDD_B.t67 146.78149483051
Riso6101 VDD_B.t27 VDD_B.t68 139.305376531126
Riso6102 VDD_B.t27 VDD_B.t69 914.677696621613
Riso6103 VDD_B.t27 VDD_B.t70 464.70374391128
Riso6104 VDD_B.t27 VDD_B.t71 36355.6875834728
Riso6105 VDD_B.t27 VDD_B.t73 2674.99425303275
Riso6106 VDD_B.t27 VDD_B.t75 3887.38537128005
Riso6107 VDD_B.t27 VDD_B.t76 39.7497280668417
Riso6108 VDD_B.t27 VDD_B.t77 56.8854613301004
Riso6109 VDD_B.t27 VDD_B.t78 48.0822421431112
Riso6110 VDD_B.t27 VDD_B.t79 72.1846190224478
Riso6111 VDD_B.t27 VDD_B.t8 5054.45481435704
Riso6112 VDD_B.t27 VDD_B.t80 207.525510202921
Riso6113 VDD_B.t27 VDD_B.t81 92482.4034525256
Riso6114 VDD_B.t27 VDD_B.t82 14248.4388603019
Riso6115 VDD_B.t27 VDD_B.t83 106.727427254962
Riso6116 VDD_B.t27 VDD_B.t85 6231.05176025534
Riso6117 VDD_B.t27 VDD_B.t86 40.4503822249444
Riso6118 VDD_B.t27 VDD_B.t87 1054.91151800489
Riso6119 VDD_B.t27 VDD_B.t88 56.8854613301004
Riso6120 VDD_B.t27 VDD_B.t89 302.175878670212
Riso6121 VDD_B.t27 VDD_B.t9 91.0574041308907
Riso6122 VDD_B.t27 VDD_B.t90 969.045848846009
Riso6123 VDD_B.t27 VDD_B.t91 420.745146015028
Riso6124 VDD_B.t27 VDD_B.t92 78.3364549445744
Riso6125 VDD_B.t27 VDD_B.t94 6650.91711656385
Riso6126 VDD_B.t27 VDD_B.t95 61.4822543981564
Riso6127 VDD_B.t27 VDD_B.t96 19124.3029328605
Riso6128 VDD_B.t27 VDD_B.t97 27452.2287870532
Riso6129 VDD_B.t27 VDD_B.t99 6650.91711656385
Riso6130 VDD_B.t28 VDD_B.t3 278685.628480866
Riso6131 VDD_B.t28 VDD_B.t30 4230.2429038013
Riso6132 VDD_B.t28 VDD_B.t31 1387.99479647581
Riso6133 VDD_B.t28 VDD_B.t32 26627.3415542019
Riso6134 VDD_B.t28 VDD_B.t33 1328.136406578
Riso6135 VDD_B.t28 VDD_B.t34 1090.42913724808
Riso6136 VDD_B.t28 VDD_B.t35 44523.0558213472
Riso6137 VDD_B.t28 VDD_B.t36 46989.2557059995
Riso6138 VDD_B.t28 VDD_B.t37 30.1686769789224
Riso6139 VDD_B.t28 VDD_B.t38 106.727427254962
Riso6140 VDD_B.t28 VDD_B.t39 51.0228438057977
Riso6141 VDD_B.t28 VDD_B.t4 7076.82453891163
Riso6142 VDD_B.t28 VDD_B.t41 3045.5334754608
Riso6143 VDD_B.t28 VDD_B.t42 705.248105349679
Riso6144 VDD_B.t28 VDD_B.t43 1222.21303182606
Riso6145 VDD_B.t28 VDD_B.t44 61240.8596557794
Riso6146 VDD_B.t28 VDD_B.t45 179779.327798629
Riso6147 VDD_B.t28 VDD_B.t46 53.0030566254856
Riso6148 VDD_B.t28 VDD_B.t47 37.2327066554401
Riso6149 VDD_B.t28 VDD_B.t48 442.455901798198
Riso6150 VDD_B.t28 VDD_B.t49 260.355326150309
Riso6151 VDD_B.t28 VDD_B.t50 141.238566089594
Riso6152 VDD_B.t28 VDD_B.t51 1387.99479647581
Riso6153 VDD_B.t28 VDD_B.t52 260.355326150309
Riso6154 VDD_B.t28 VDD_B.t53 183.274104258269
Riso6155 VDD_B.t28 VDD_B.t55 6697.05282592639
Riso6156 VDD_B.t28 VDD_B.t56 539.13577302137
Riso6157 VDD_B.t28 VDD_B.t57 398.708258118159
Riso6158 VDD_B.t28 VDD_B.t58 248609.786141785
Riso6159 VDD_B.t28 VDD_B.t59 1430.10821414723
Riso6160 VDD_B.t28 VDD_B.t6 4509.14082502388
Riso6161 VDD_B.t28 VDD_B.t60 43.7541385327606
Riso6162 VDD_B.t28 VDD_B.t61 1090.42913724808
Riso6163 VDD_B.t28 VDD_B.t62 1365.10596445548
Riso6164 VDD_B.t28 VDD_B.t63 705.248105349679
Riso6165 VDD_B.t28 VDD_B.t64 522.106957242127
Riso6166 VDD_B.t28 VDD_B.t66 3715.38351395064
Riso6167 VDD_B.t28 VDD_B.t67 49.876053475966
Riso6168 VDD_B.t28 VDD_B.t68 45.7861323906484
Riso6169 VDD_B.t28 VDD_B.t69 1328.136406578
Riso6170 VDD_B.t28 VDD_B.t70 825.875731144083
Riso6171 VDD_B.t28 VDD_B.t71 25478.766382239
Riso6172 VDD_B.t28 VDD_B.t73 3045.5334754608
Riso6173 VDD_B.t28 VDD_B.t75 3715.38351395064
Riso6174 VDD_B.t28 VDD_B.t76 92.1200427679123
Riso6175 VDD_B.t28 VDD_B.t77 161.29470938391
Riso6176 VDD_B.t28 VDD_B.t78 141.238566089594
Riso6177 VDD_B.t28 VDD_B.t79 51.0228438057977
Riso6178 VDD_B.t28 VDD_B.t8 5730.75439997179
Riso6179 VDD_B.t28 VDD_B.t80 442.455901798198
Riso6180 VDD_B.t28 VDD_B.t81 64813.4503473415
Riso6181 VDD_B.t28 VDD_B.t82 9985.58050098004
Riso6182 VDD_B.t28 VDD_B.t83 0.0669524827871946
Riso6183 VDD_B.t28 VDD_B.t85 7032.07743695652
Riso6184 VDD_B.t28 VDD_B.t86 123.071224444703
Riso6185 VDD_B.t28 VDD_B.t87 1394.59805170296
Riso6186 VDD_B.t28 VDD_B.t88 161.29470938391
Riso6187 VDD_B.t28 VDD_B.t89 591.912234192009
Riso6188 VDD_B.t28 VDD_B.t9 232.910942717714
Riso6189 VDD_B.t28 VDD_B.t90 1365.10596445548
Riso6190 VDD_B.t28 VDD_B.t91 764.972058937407
Riso6191 VDD_B.t28 VDD_B.t92 207.168470363816
Riso6192 VDD_B.t28 VDD_B.t94 7460.47180101343
Riso6193 VDD_B.t28 VDD_B.t95 148.020228051534
Riso6194 VDD_B.t28 VDD_B.t96 13402.6799941759
Riso6195 VDD_B.t28 VDD_B.t97 19239.0509003898
Riso6196 VDD_B.t28 VDD_B.t99 7460.47180101343
Riso6197 VDD_B.t29 VDD_B.t72 158.648
Riso6198 VDD_B.t3 VDD_B.t30 14685.7414827277
Riso6199 VDD_B.t3 VDD_B.t31 13920.8643620157
Riso6200 VDD_B.t3 VDD_B.t32 246042.595699705
Riso6201 VDD_B.t3 VDD_B.t33 18898.7123731
Riso6202 VDD_B.t3 VDD_B.t34 32520.5729589349
Riso6203 VDD_B.t3 VDD_B.t35 411403.000951797
Riso6204 VDD_B.t3 VDD_B.t36 434191.239871519
Riso6205 VDD_B.t3 VDD_B.t37 145459.248305938
Riso6206 VDD_B.t3 VDD_B.t38 256662.910683635
Riso6207 VDD_B.t3 VDD_B.t39 287250.752903111
Riso6208 VDD_B.t3 VDD_B.t4 1286.21136783216
Riso6209 VDD_B.t3 VDD_B.t41 18991.2802028977
Riso6210 VDD_B.t3 VDD_B.t42 66203.5058124174
Riso6211 VDD_B.t3 VDD_B.t43 25104.0483079741
Riso6212 VDD_B.t3 VDD_B.t44 565879.250165384
Riso6213 VDD_B.t3 VDD_B.t45 1661201.22711772
Riso6214 VDD_B.t3 VDD_B.t46 213845.714263709
Riso6215 VDD_B.t3 VDD_B.t47 284520.514617812
Riso6216 VDD_B.t3 VDD_B.t48 109699.39490472
Riso6217 VDD_B.t3 VDD_B.t49 166707.248289096
Riso6218 VDD_B.t3 VDD_B.t50 233734.746724851
Riso6219 VDD_B.t3 VDD_B.t51 13920.8643620157
Riso6220 VDD_B.t3 VDD_B.t52 166707.248289096
Riso6221 VDD_B.t3 VDD_B.t53 207425.095582623
Riso6222 VDD_B.t3 VDD_B.t55 2069.23675053544
Riso6223 VDD_B.t3 VDD_B.t56 90775.5935360272
Riso6224 VDD_B.t3 VDD_B.t57 119771.936229275
Riso6225 VDD_B.t3 VDD_B.t58 2105960.86897264
Riso6226 VDD_B.t3 VDD_B.t59 12036.2503946181
Riso6227 VDD_B.t3 VDD_B.t6 5505.29768847047
Riso6228 VDD_B.t3 VDD_B.t60 287380.293661171
Riso6229 VDD_B.t3 VDD_B.t61 32520.5729589349
Riso6230 VDD_B.t3 VDD_B.t62 16261.4695917857
Riso6231 VDD_B.t3 VDD_B.t63 66203.5058124174
Riso6232 VDD_B.t3 VDD_B.t64 18735.9839464614
Riso6233 VDD_B.t3 VDD_B.t66 11268.6325719491
Riso6234 VDD_B.t3 VDD_B.t67 230247.356385638
Riso6235 VDD_B.t3 VDD_B.t68 245393.626053656
Riso6236 VDD_B.t3 VDD_B.t69 18898.7123731
Riso6237 VDD_B.t3 VDD_B.t70 52556.2964185039
Riso6238 VDD_B.t3 VDD_B.t71 235429.504036358
Riso6239 VDD_B.t3 VDD_B.t73 18991.2802028977
Riso6240 VDD_B.t3 VDD_B.t75 11268.6325719491
Riso6241 VDD_B.t3 VDD_B.t76 265963.595758559
Riso6242 VDD_B.t3 VDD_B.t77 220836.889122897
Riso6243 VDD_B.t3 VDD_B.t78 233734.746724851
Riso6244 VDD_B.t3 VDD_B.t79 287250.752903111
Riso6245 VDD_B.t3 VDD_B.t8 10484.1203799336
Riso6246 VDD_B.t3 VDD_B.t80 109699.39490472
Riso6247 VDD_B.t3 VDD_B.t81 598890.787773644
Riso6248 VDD_B.t3 VDD_B.t82 92268.9988044183
Riso6249 VDD_B.t3 VDD_B.t83 278685.628480866
Riso6250 VDD_B.t3 VDD_B.t85 7201.83270419116
Riso6251 VDD_B.t3 VDD_B.t86 245795.340391378
Riso6252 VDD_B.t3 VDD_B.t87 11859.6688646992
Riso6253 VDD_B.t3 VDD_B.t88 220836.889122897
Riso6254 VDD_B.t3 VDD_B.t89 82046.2970546993
Riso6255 VDD_B.t3 VDD_B.t9 180144.603026
Riso6256 VDD_B.t3 VDD_B.t90 16261.4695917857
Riso6257 VDD_B.t3 VDD_B.t91 59107.1854360804
Riso6258 VDD_B.t3 VDD_B.t92 193781.726648029
Riso6259 VDD_B.t3 VDD_B.t94 4857.15189423598
Riso6260 VDD_B.t3 VDD_B.t95 78614.1686705671
Riso6261 VDD_B.t3 VDD_B.t96 123843.762937693
Riso6262 VDD_B.t3 VDD_B.t97 177773.136409244
Riso6263 VDD_B.t3 VDD_B.t99 4857.15189423598
Riso6264 VDD_B.t30 VDD_B.t31 453.353267823336
Riso6265 VDD_B.t30 VDD_B.t32 7265.69013998444
Riso6266 VDD_B.t30 VDD_B.t33 553.620210800882
Riso6267 VDD_B.t30 VDD_B.t34 791.384268118106
Riso6268 VDD_B.t30 VDD_B.t35 12148.8180494718
Riso6269 VDD_B.t30 VDD_B.t36 12821.7595877277
Riso6270 VDD_B.t30 VDD_B.t37 2124.9264349898
Riso6271 VDD_B.t30 VDD_B.t38 3720.66055385074
Riso6272 VDD_B.t30 VDD_B.t39 4222.58198795935
Riso6273 VDD_B.t30 VDD_B.t4 381.841992933257
Riso6274 VDD_B.t30 VDD_B.t41 46.1317526277642
Riso6275 VDD_B.t30 VDD_B.t42 1290.72996831
Riso6276 VDD_B.t30 VDD_B.t43 666.474886073863
Riso6277 VDD_B.t30 VDD_B.t44 16710.5345180414
Riso6278 VDD_B.t30 VDD_B.t45 49055.625275269
Riso6279 VDD_B.t30 VDD_B.t46 3520.00802913324
Riso6280 VDD_B.t30 VDD_B.t47 4264.18126601093
Riso6281 VDD_B.t30 VDD_B.t48 1863.77952148
Riso6282 VDD_B.t30 VDD_B.t49 2584.93589310823
Riso6283 VDD_B.t30 VDD_B.t50 3419.67505146938
Riso6284 VDD_B.t30 VDD_B.t51 453.353267823336
Riso6285 VDD_B.t30 VDD_B.t52 2584.93589310823
Riso6286 VDD_B.t30 VDD_B.t53 3088.78268562239
Riso6287 VDD_B.t30 VDD_B.t55 261.35200781984
Riso6288 VDD_B.t30 VDD_B.t56 1618.88865514528
Riso6289 VDD_B.t30 VDD_B.t57 1992.89776763278
Riso6290 VDD_B.t30 VDD_B.t58 7998.83271521049
Riso6291 VDD_B.t30 VDD_B.t59 37.3846208212211
Riso6292 VDD_B.t30 VDD_B.t6 947.039711732903
Riso6293 VDD_B.t30 VDD_B.t60 4260.90541004726
Riso6294 VDD_B.t30 VDD_B.t61 791.384268118106
Riso6295 VDD_B.t30 VDD_B.t62 501.909797921408
Riso6296 VDD_B.t30 VDD_B.t63 1290.72996831
Riso6297 VDD_B.t30 VDD_B.t64 439.007137489261
Riso6298 VDD_B.t30 VDD_B.t66 1195.33359480524
Riso6299 VDD_B.t30 VDD_B.t67 3725.34642245692
Riso6300 VDD_B.t30 VDD_B.t68 3903.03347230681
Riso6301 VDD_B.t30 VDD_B.t69 553.620210800882
Riso6302 VDD_B.t30 VDD_B.t70 1099.34358217509
Riso6303 VDD_B.t30 VDD_B.t71 6952.28328767159
Riso6304 VDD_B.t30 VDD_B.t73 46.1317526277642
Riso6305 VDD_B.t30 VDD_B.t75 1195.33359480524
Riso6306 VDD_B.t30 VDD_B.t76 3850.95874433657
Riso6307 VDD_B.t30 VDD_B.t77 3256.36214038667
Riso6308 VDD_B.t30 VDD_B.t78 3419.67505146938
Riso6309 VDD_B.t30 VDD_B.t79 4222.58198795935
Riso6310 VDD_B.t30 VDD_B.t8 42.6023736089367
Riso6311 VDD_B.t30 VDD_B.t80 1863.77952148
Riso6312 VDD_B.t30 VDD_B.t81 17685.3722392252
Riso6313 VDD_B.t30 VDD_B.t82 2724.72314370199
Riso6314 VDD_B.t30 VDD_B.t83 4230.2429038013
Riso6315 VDD_B.t30 VDD_B.t85 65.3997532377392
Riso6316 VDD_B.t30 VDD_B.t86 3575.61367820774
Riso6317 VDD_B.t30 VDD_B.t87 407.922721519227
Riso6318 VDD_B.t30 VDD_B.t88 3256.36214038667
Riso6319 VDD_B.t30 VDD_B.t89 1504.05653041452
Riso6320 VDD_B.t30 VDD_B.t9 2751.05240283671
Riso6321 VDD_B.t30 VDD_B.t90 501.909797921408
Riso6322 VDD_B.t30 VDD_B.t91 1192.32317750969
Riso6323 VDD_B.t30 VDD_B.t92 2919.60390994763
Riso6324 VDD_B.t30 VDD_B.t94 103.067168927486
Riso6325 VDD_B.t30 VDD_B.t95 1239.77818328129
Riso6326 VDD_B.t30 VDD_B.t96 3657.13263882643
Riso6327 VDD_B.t30 VDD_B.t97 5249.67849851171
Riso6328 VDD_B.t30 VDD_B.t99 103.067168927486
Riso6329 VDD_B.t31 VDD_B.t32 4958.56720559949
Riso6330 VDD_B.t31 VDD_B.t33 44.8704683274112
Riso6331 VDD_B.t31 VDD_B.t34 83.980239271134
Riso6332 VDD_B.t31 VDD_B.t35 8291.12301877427
Riso6333 VDD_B.t31 VDD_B.t36 8750.38095278913
Riso6334 VDD_B.t31 VDD_B.t37 639.603755366217
Riso6335 VDD_B.t31 VDD_B.t38 1016.69722738712
Riso6336 VDD_B.t31 VDD_B.t39 1301.15007823717
Riso6337 VDD_B.t31 VDD_B.t4 356.854575237474
Riso6338 VDD_B.t31 VDD_B.t41 358.948451297099
Riso6339 VDD_B.t31 VDD_B.t42 193.02685676173
Riso6340 VDD_B.t31 VDD_B.t43 62.2058663726203
Riso6341 VDD_B.t31 VDD_B.t44 11404.3273044639
Riso6342 VDD_B.t31 VDD_B.t45 33478.666176734
Riso6343 VDD_B.t31 VDD_B.t46 1234.60932912171
Riso6344 VDD_B.t31 VDD_B.t47 1372.19039287798
Riso6345 VDD_B.t31 VDD_B.t48 350.515138833889
Riso6346 VDD_B.t31 VDD_B.t49 576.43861864076
Riso6347 VDD_B.t31 VDD_B.t50 886.250024290431
Riso6348 VDD_B.t31 VDD_B.t51 0.0669535133181615
Riso6349 VDD_B.t31 VDD_B.t52 576.43861864076
Riso6350 VDD_B.t31 VDD_B.t53 756.280915938284
Riso6351 VDD_B.t31 VDD_B.t55 310.030467080106
Riso6352 VDD_B.t31 VDD_B.t56 280.27215774529
Riso6353 VDD_B.t31 VDD_B.t57 388.821234441287
Riso6354 VDD_B.t31 VDD_B.t58 30495.3179471376
Riso6355 VDD_B.t31 VDD_B.t59 174.23899607331
Riso6356 VDD_B.t31 VDD_B.t6 336.585540761763
Riso6357 VDD_B.t31 VDD_B.t60 1342.62467603233
Riso6358 VDD_B.t31 VDD_B.t61 83.980239271134
Riso6359 VDD_B.t31 VDD_B.t62 37.8049972619828
Riso6360 VDD_B.t31 VDD_B.t63 193.02685676173
Riso6361 VDD_B.t31 VDD_B.t64 49.3059648334659
Riso6362 VDD_B.t31 VDD_B.t66 322.10750870867
Riso6363 VDD_B.t31 VDD_B.t67 1295.11954997426
Riso6364 VDD_B.t31 VDD_B.t68 1341.84217438033
Riso6365 VDD_B.t31 VDD_B.t69 44.8704683274112
Riso6366 VDD_B.t31 VDD_B.t70 147.002291314987
Riso6367 VDD_B.t31 VDD_B.t71 4744.67851643884
Riso6368 VDD_B.t31 VDD_B.t73 358.948451297099
Riso6369 VDD_B.t31 VDD_B.t75 322.10750870867
Riso6370 VDD_B.t31 VDD_B.t76 1078.93465399877
Riso6371 VDD_B.t31 VDD_B.t77 820.693736881239
Riso6372 VDD_B.t31 VDD_B.t78 886.250024290431
Riso6373 VDD_B.t31 VDD_B.t79 1301.15007823717
Riso6374 VDD_B.t31 VDD_B.t8 518.872992482942
Riso6375 VDD_B.t31 VDD_B.t80 350.515138833889
Riso6376 VDD_B.t31 VDD_B.t81 12069.6183176936
Riso6377 VDD_B.t31 VDD_B.t82 1859.52367419946
Riso6378 VDD_B.t31 VDD_B.t83 1387.99479647581
Riso6379 VDD_B.t31 VDD_B.t85 506.151998271241
Riso6380 VDD_B.t31 VDD_B.t86 951.985589242418
Riso6381 VDD_B.t31 VDD_B.t87 36.2974257318178
Riso6382 VDD_B.t31 VDD_B.t88 820.693736881239
Riso6383 VDD_B.t31 VDD_B.t89 248.714445032871
Riso6384 VDD_B.t31 VDD_B.t9 633.678702739493
Riso6385 VDD_B.t31 VDD_B.t90 37.8049972619828
Riso6386 VDD_B.t31 VDD_B.t91 168.843613905278
Riso6387 VDD_B.t31 VDD_B.t92 693.757510749727
Riso6388 VDD_B.t31 VDD_B.t94 423.851913481244
Riso6389 VDD_B.t31 VDD_B.t95 267.280661297341
Riso6390 VDD_B.t31 VDD_B.t96 2495.85897829811
Riso6391 VDD_B.t31 VDD_B.t97 3582.71315472266
Riso6392 VDD_B.t31 VDD_B.t99 423.851913481244
Riso6393 VDD_B.t32 VDD_B.t33 6262.80740367622
Riso6394 VDD_B.t32 VDD_B.t34 9524.27771588171
Riso6395 VDD_B.t32 VDD_B.t35 50.5521162622936
Riso6396 VDD_B.t32 VDD_B.t36 55.0416369045299
Riso6397 VDD_B.t32 VDD_B.t37 17237.242654954
Riso6398 VDD_B.t32 VDD_B.t38 37994.591111672
Riso6399 VDD_B.t32 VDD_B.t39 32201.2676758828
Riso6400 VDD_B.t32 VDD_B.t4 6243.89201565059
Riso6401 VDD_B.t32 VDD_B.t41 5563.50521726137
Riso6402 VDD_B.t32 VDD_B.t42 16755.3761581167
Riso6403 VDD_B.t32 VDD_B.t43 7787.44255796848
Riso6404 VDD_B.t32 VDD_B.t44 71.5794743267212
Riso6405 VDD_B.t32 VDD_B.t45 227.403746589983
Riso6406 VDD_B.t32 VDD_B.t46 16650.0179828789
Riso6407 VDD_B.t32 VDD_B.t47 28615.7244035349
Riso6408 VDD_B.t32 VDD_B.t48 24882.3325834241
Riso6409 VDD_B.t32 VDD_B.t49 33236.1052906307
Riso6410 VDD_B.t32 VDD_B.t50 38265.6914342361
Riso6411 VDD_B.t32 VDD_B.t51 4958.56720559949
Riso6412 VDD_B.t32 VDD_B.t52 33236.1052906307
Riso6413 VDD_B.t32 VDD_B.t53 37103.1899919827
Riso6414 VDD_B.t32 VDD_B.t55 5984.08126362644
Riso6415 VDD_B.t32 VDD_B.t56 21507.0794262237
Riso6416 VDD_B.t32 VDD_B.t57 26563.5153321959
Riso6417 VDD_B.t32 VDD_B.t58 465643.829301872
Riso6418 VDD_B.t32 VDD_B.t59 2667.95780685669
Riso6419 VDD_B.t32 VDD_B.t6 3943.63785137666
Riso6420 VDD_B.t32 VDD_B.t60 30492.7294688072
Riso6421 VDD_B.t32 VDD_B.t61 9524.27771588171
Riso6422 VDD_B.t32 VDD_B.t62 5583.42837868211
Riso6423 VDD_B.t32 VDD_B.t63 16755.3761581167
Riso6424 VDD_B.t32 VDD_B.t64 5353.51595619102
Riso6425 VDD_B.t32 VDD_B.t66 3257.86559246382
Riso6426 VDD_B.t32 VDD_B.t67 18529.6763684688
Riso6427 VDD_B.t32 VDD_B.t68 20495.8693649195
Riso6428 VDD_B.t32 VDD_B.t69 6262.80740367622
Riso6429 VDD_B.t32 VDD_B.t70 13946.1761570717
Riso6430 VDD_B.t32 VDD_B.t71 22.6162718076388
Riso6431 VDD_B.t32 VDD_B.t73 5563.50521726137
Riso6432 VDD_B.t32 VDD_B.t75 3257.86559246382
Riso6433 VDD_B.t32 VDD_B.t76 37306.2250540183
Riso6434 VDD_B.t32 VDD_B.t77 37853.0271231892
Riso6435 VDD_B.t32 VDD_B.t78 38265.6914342361
Riso6436 VDD_B.t32 VDD_B.t79 32201.2676758828
Riso6437 VDD_B.t32 VDD_B.t8 8780.12803570229
Riso6438 VDD_B.t32 VDD_B.t80 24882.3325834241
Riso6439 VDD_B.t32 VDD_B.t81 75.8513067050424
Riso6440 VDD_B.t32 VDD_B.t82 78.5400275212488
Riso6441 VDD_B.t32 VDD_B.t83 26627.3415542019
Riso6442 VDD_B.t32 VDD_B.t85 9134.37452622244
Riso6443 VDD_B.t32 VDD_B.t86 38316.3074218807
Riso6444 VDD_B.t32 VDD_B.t87 4386.66549105279
Riso6445 VDD_B.t32 VDD_B.t88 37853.0271231892
Riso6446 VDD_B.t32 VDD_B.t89 19864.284740491
Riso6447 VDD_B.t32 VDD_B.t9 34747.3771861688
Riso6448 VDD_B.t32 VDD_B.t90 5583.42837868211
Riso6449 VDD_B.t32 VDD_B.t91 15310.2891832687
Riso6450 VDD_B.t32 VDD_B.t92 36052.9410127026
Riso6451 VDD_B.t32 VDD_B.t94 8088.46475721949
Riso6452 VDD_B.t32 VDD_B.t95 16155.4070018085
Riso6453 VDD_B.t32 VDD_B.t96 51.3838786337213
Riso6454 VDD_B.t32 VDD_B.t97 47.6128600802863
Riso6455 VDD_B.t32 VDD_B.t99 8088.46475721949
Riso6456 VDD_B.t33 VDD_B.t34 64.2037083534986
Riso6457 VDD_B.t33 VDD_B.t35 10471.9174861908
Riso6458 VDD_B.t33 VDD_B.t36 11051.9729477962
Riso6459 VDD_B.t33 VDD_B.t37 591.571131339548
Riso6460 VDD_B.t33 VDD_B.t38 914.677696621613
Riso6461 VDD_B.t33 VDD_B.t39 1213.06085769696
Riso6462 VDD_B.t33 VDD_B.t4 483.766347412629
Riso6463 VDD_B.t33 VDD_B.t41 429.951815934158
Riso6464 VDD_B.t33 VDD_B.t42 154.974774007329
Riso6465 VDD_B.t33 VDD_B.t43 46.8317310473358
Riso6466 VDD_B.t33 VDD_B.t44 14403.9805280219
Riso6467 VDD_B.t33 VDD_B.t45 42284.4805168885
Riso6468 VDD_B.t33 VDD_B.t46 1234.40706803717
Riso6469 VDD_B.t33 VDD_B.t47 1301.29742843352
Riso6470 VDD_B.t33 VDD_B.t48 292.707517761633
Riso6471 VDD_B.t33 VDD_B.t49 496.746267963036
Riso6472 VDD_B.t33 VDD_B.t50 787.476359420122
Riso6473 VDD_B.t33 VDD_B.t51 44.8704683274112
Riso6474 VDD_B.t33 VDD_B.t52 496.746267963036
Riso6475 VDD_B.t33 VDD_B.t53 663.897246192005
Riso6476 VDD_B.t33 VDD_B.t55 425.379040728978
Riso6477 VDD_B.t33 VDD_B.t56 230.629949709841
Riso6478 VDD_B.t33 VDD_B.t57 326.863238510299
Riso6479 VDD_B.t33 VDD_B.t58 36215.9105342638
Riso6480 VDD_B.t33 VDD_B.t59 207.231021136054
Riso6481 VDD_B.t33 VDD_B.t6 427.477744596284
Riso6482 VDD_B.t33 VDD_B.t60 1262.23032054234
Riso6483 VDD_B.t33 VDD_B.t61 64.2037083534986
Riso6484 VDD_B.t33 VDD_B.t62 38.8784573734981
Riso6485 VDD_B.t33 VDD_B.t63 154.974774007329
Riso6486 VDD_B.t33 VDD_B.t64 37.9688211171305
Riso6487 VDD_B.t33 VDD_B.t66 405.254176411202
Riso6488 VDD_B.t33 VDD_B.t67 1284.44218100213
Riso6489 VDD_B.t33 VDD_B.t68 1319.35740874291
Riso6490 VDD_B.t33 VDD_B.t69 0.0669601629633736
Riso6491 VDD_B.t33 VDD_B.t70 115.990000349392
Riso6492 VDD_B.t33 VDD_B.t71 5992.66007875438
Riso6493 VDD_B.t33 VDD_B.t73 429.951815934158
Riso6494 VDD_B.t33 VDD_B.t75 405.254176411202
Riso6495 VDD_B.t33 VDD_B.t76 976.93610203862
Riso6496 VDD_B.t33 VDD_B.t77 724.811415644704
Riso6497 VDD_B.t33 VDD_B.t78 787.476359420122
Riso6498 VDD_B.t33 VDD_B.t79 1213.06085769696
Riso6499 VDD_B.t33 VDD_B.t8 653.449270643896
Riso6500 VDD_B.t33 VDD_B.t80 292.707517761633
Riso6501 VDD_B.t33 VDD_B.t81 15244.2614621089
Riso6502 VDD_B.t33 VDD_B.t82 2348.62978582532
Riso6503 VDD_B.t33 VDD_B.t83 1328.136406578
Riso6504 VDD_B.t33 VDD_B.t85 660.493614333177
Riso6505 VDD_B.t33 VDD_B.t86 851.103574195367
Riso6506 VDD_B.t33 VDD_B.t87 50.997256328444
Riso6507 VDD_B.t33 VDD_B.t88 724.811415644704
Riso6508 VDD_B.t33 VDD_B.t89 203.045249718331
Riso6509 VDD_B.t33 VDD_B.t9 549.512017645556
Riso6510 VDD_B.t33 VDD_B.t90 38.8784573734981
Riso6511 VDD_B.t33 VDD_B.t91 134.393340920908
Riso6512 VDD_B.t33 VDD_B.t92 605.32356241931
Riso6513 VDD_B.t33 VDD_B.t94 569.943814372967
Riso6514 VDD_B.t33 VDD_B.t95 228.849142171826
Riso6515 VDD_B.t33 VDD_B.t96 3152.33885912965
Riso6516 VDD_B.t33 VDD_B.t97 4525.06571763456
Riso6517 VDD_B.t33 VDD_B.t99 569.943814372967
Riso6518 VDD_B.t34 VDD_B.t35 15925.3580587093
Riso6519 VDD_B.t34 VDD_B.t36 16807.4879009428
Riso6520 VDD_B.t34 VDD_B.t37 457.876446383002
Riso6521 VDD_B.t34 VDD_B.t38 673.246087337361
Riso6522 VDD_B.t34 VDD_B.t39 952.193033498697
Riso6523 VDD_B.t34 VDD_B.t4 830.39757040831
Riso6524 VDD_B.t34 VDD_B.t41 597.62008537286
Riso6525 VDD_B.t34 VDD_B.t42 88.8935313299817
Riso6526 VDD_B.t34 VDD_B.t43 47.04742990776
Riso6527 VDD_B.t34 VDD_B.t44 21905.1140998692
Riso6528 VDD_B.t34 VDD_B.t45 64304.8890946633
Riso6529 VDD_B.t34 VDD_B.t46 1093.83975794761
Riso6530 VDD_B.t34 VDD_B.t47 1052.07213623634
Riso6531 VDD_B.t34 VDD_B.t48 182.904658816646
Riso6532 VDD_B.t34 VDD_B.t49 333.47333641704
Riso6533 VDD_B.t34 VDD_B.t50 565.438212585315
Riso6534 VDD_B.t34 VDD_B.t51 83.980239271134
Riso6535 VDD_B.t34 VDD_B.t52 333.47333641704
Riso6536 VDD_B.t34 VDD_B.t53 464.5865169346
Riso6537 VDD_B.t34 VDD_B.t55 745.628923911632
Riso6538 VDD_B.t34 VDD_B.t56 139.454109786367
Riso6539 VDD_B.t34 VDD_B.t57 207.351631817083
Riso6540 VDD_B.t34 VDD_B.t58 49738.1265796545
Riso6541 VDD_B.t34 VDD_B.t59 285.190568207631
Riso6542 VDD_B.t34 VDD_B.t6 661.326016101953
Riso6543 VDD_B.t34 VDD_B.t60 1005.29345326171
Riso6544 VDD_B.t34 VDD_B.t61 0.0669609640433875
Riso6545 VDD_B.t34 VDD_B.t62 73.8945834462551
Riso6546 VDD_B.t34 VDD_B.t63 88.8935313299817
Riso6547 VDD_B.t34 VDD_B.t64 20.0602825025868
Riso6548 VDD_B.t34 VDD_B.t66 618.274290665295
Riso6549 VDD_B.t34 VDD_B.t67 1122.00063371797
Riso6550 VDD_B.t34 VDD_B.t68 1135.25452657619
Riso6551 VDD_B.t34 VDD_B.t69 64.2037083534986
Riso6552 VDD_B.t34 VDD_B.t70 64.2216494213787
Riso6553 VDD_B.t34 VDD_B.t71 9113.44628184339
Riso6554 VDD_B.t34 VDD_B.t73 597.62008537286
Riso6555 VDD_B.t34 VDD_B.t75 618.274290665295
Riso6556 VDD_B.t34 VDD_B.t76 727.875881690861
Riso6557 VDD_B.t34 VDD_B.t77 513.864907268585
Riso6558 VDD_B.t34 VDD_B.t78 565.438212585315
Riso6559 VDD_B.t34 VDD_B.t79 952.193033498697
Riso6560 VDD_B.t34 VDD_B.t8 979.610675941647
Riso6561 VDD_B.t34 VDD_B.t80 182.904658816646
Riso6562 VDD_B.t34 VDD_B.t81 23182.9865394572
Riso6563 VDD_B.t34 VDD_B.t82 3571.72125696563
Riso6564 VDD_B.t34 VDD_B.t83 1090.42913724808
Riso6565 VDD_B.t34 VDD_B.t85 1051.29795958366
Riso6566 VDD_B.t34 VDD_B.t86 618.79687499204
Riso6567 VDD_B.t34 VDD_B.t87 94.0062714363984
Riso6568 VDD_B.t34 VDD_B.t88 513.864907268585
Riso6569 VDD_B.t34 VDD_B.t89 120.666385408099
Riso6570 VDD_B.t34 VDD_B.t9 374.210447745653
Riso6571 VDD_B.t34 VDD_B.t90 73.8945834462551
Riso6572 VDD_B.t34 VDD_B.t91 75.7311391634842
Riso6573 VDD_B.t34 VDD_B.t92 417.95833367095
Riso6574 VDD_B.t34 VDD_B.t94 958.797192176575
Riso6575 VDD_B.t34 VDD_B.t95 151.371948492542
Riso6576 VDD_B.t34 VDD_B.t96 4793.97637731806
Riso6577 VDD_B.t34 VDD_B.t97 6881.57559372957
Riso6578 VDD_B.t34 VDD_B.t99 958.797192176575
Riso6579 VDD_B.t35 VDD_B.t36 40.9202176058122
Riso6580 VDD_B.t35 VDD_B.t37 28822.055531545
Riso6581 VDD_B.t35 VDD_B.t38 63530.0109675158
Riso6582 VDD_B.t35 VDD_B.t39 53843.1084204585
Riso6583 VDD_B.t35 VDD_B.t4 10440.2894366826
Riso6584 VDD_B.t35 VDD_B.t41 9302.62800911855
Riso6585 VDD_B.t35 VDD_B.t42 28016.3360084956
Riso6586 VDD_B.t35 VDD_B.t43 13021.2300393635
Riso6587 VDD_B.t35 VDD_B.t44 54.8331679660258
Riso6588 VDD_B.t35 VDD_B.t45 173.693800142505
Riso6589 VDD_B.t35 VDD_B.t46 27840.1686690789
Riso6590 VDD_B.t35 VDD_B.t47 47847.7918042788
Riso6591 VDD_B.t35 VDD_B.t48 41605.2605297467
Riso6592 VDD_B.t35 VDD_B.t49 55573.4401095483
Riso6593 VDD_B.t35 VDD_B.t50 63983.3125023361
Riso6594 VDD_B.t35 VDD_B.t51 8291.12301877427
Riso6595 VDD_B.t35 VDD_B.t52 55573.4401095483
Riso6596 VDD_B.t35 VDD_B.t53 62039.5166299437
Riso6597 VDD_B.t35 VDD_B.t55 10005.8649714461
Riso6598 VDD_B.t35 VDD_B.t56 35961.5658926641
Riso6599 VDD_B.t35 VDD_B.t57 44416.3332467541
Riso6600 VDD_B.t35 VDD_B.t58 778593.918685871
Riso6601 VDD_B.t35 VDD_B.t59 4461.03994729938
Riso6602 VDD_B.t35 VDD_B.t6 6594.07954183521
Riso6603 VDD_B.t35 VDD_B.t60 50986.2951778864
Riso6604 VDD_B.t35 VDD_B.t61 15925.3580587093
Riso6605 VDD_B.t35 VDD_B.t62 9335.94113676472
Riso6606 VDD_B.t35 VDD_B.t63 28016.3360084956
Riso6607 VDD_B.t35 VDD_B.t64 8951.50908222578
Riso6608 VDD_B.t35 VDD_B.t66 5447.41319130388
Riso6609 VDD_B.t35 VDD_B.t67 30983.1086075751
Riso6610 VDD_B.t35 VDD_B.t68 34270.7413725029
Riso6611 VDD_B.t35 VDD_B.t69 10471.9174861908
Riso6612 VDD_B.t35 VDD_B.t70 23319.1277571479
Riso6613 VDD_B.t35 VDD_B.t71 73.9984566957766
Riso6614 VDD_B.t35 VDD_B.t73 9302.62800911855
Riso6615 VDD_B.t35 VDD_B.t75 5447.41319130388
Riso6616 VDD_B.t35 VDD_B.t76 62379.0075769578
Riso6617 VDD_B.t35 VDD_B.t77 63293.3045975359
Riso6618 VDD_B.t35 VDD_B.t78 63983.3125023361
Riso6619 VDD_B.t35 VDD_B.t79 53843.1084204585
Riso6620 VDD_B.t35 VDD_B.t8 14681.0799664851
Riso6621 VDD_B.t35 VDD_B.t80 41605.2605297467
Riso6622 VDD_B.t35 VDD_B.t81 58.0269571470953
Riso6623 VDD_B.t35 VDD_B.t82 131.190561044535
Riso6624 VDD_B.t35 VDD_B.t83 44523.0558213472
Riso6625 VDD_B.t35 VDD_B.t85 15273.4085787815
Riso6626 VDD_B.t35 VDD_B.t86 64067.9465030219
Riso6627 VDD_B.t35 VDD_B.t87 7334.85737320633
Riso6628 VDD_B.t35 VDD_B.t88 63293.3045975359
Riso6629 VDD_B.t35 VDD_B.t89 33214.6811033208
Riso6630 VDD_B.t35 VDD_B.t9 58100.4082197259
Riso6631 VDD_B.t35 VDD_B.t90 9335.94113676472
Riso6632 VDD_B.t35 VDD_B.t91 25600.0344067422
Riso6633 VDD_B.t35 VDD_B.t92 60283.4159003376
Riso6634 VDD_B.t35 VDD_B.t94 13524.5633576159
Riso6635 VDD_B.t35 VDD_B.t95 27013.139343781
Riso6636 VDD_B.t35 VDD_B.t96 86.0113441627793
Riso6637 VDD_B.t35 VDD_B.t97 82.6001825511385
Riso6638 VDD_B.t35 VDD_B.t99 13524.5633576159
Riso6639 VDD_B.t36 VDD_B.t37 30418.5530925516
Riso6640 VDD_B.t36 VDD_B.t38 67049.035051324
Riso6641 VDD_B.t36 VDD_B.t39 56825.560215966
Riso6642 VDD_B.t36 VDD_B.t4 11018.5929724462
Riso6643 VDD_B.t36 VDD_B.t41 9817.91474539087
Riso6644 VDD_B.t36 VDD_B.t42 29568.2035377547
Riso6645 VDD_B.t36 VDD_B.t43 13742.4958066991
Riso6646 VDD_B.t36 VDD_B.t44 27.8199933685879
Riso6647 VDD_B.t36 VDD_B.t45 89.9934577429492
Riso6648 VDD_B.t36 VDD_B.t46 29382.2780210489
Riso6649 VDD_B.t36 VDD_B.t47 50498.1538796511
Riso6650 VDD_B.t36 VDD_B.t48 43909.8392884715
Riso6651 VDD_B.t36 VDD_B.t49 58651.7376131575
Riso6652 VDD_B.t36 VDD_B.t50 67527.4456486798
Riso6653 VDD_B.t36 VDD_B.t51 8750.38095278913
Riso6654 VDD_B.t36 VDD_B.t52 58651.7376131575
Riso6655 VDD_B.t36 VDD_B.t53 65475.9799618989
Riso6656 VDD_B.t36 VDD_B.t55 10560.1050743142
Riso6657 VDD_B.t36 VDD_B.t56 37953.5318083074
Riso6658 VDD_B.t36 VDD_B.t57 46876.6216054275
Riso6659 VDD_B.t36 VDD_B.t58 821721.421886886
Riso6660 VDD_B.t36 VDD_B.t59 4708.14374555629
Riso6661 VDD_B.t36 VDD_B.t6 6959.33565252799
Riso6662 VDD_B.t36 VDD_B.t60 53810.5037360571
Riso6663 VDD_B.t36 VDD_B.t61 16807.4879009428
Riso6664 VDD_B.t36 VDD_B.t62 9853.0731379238
Riso6665 VDD_B.t36 VDD_B.t63 29568.2035377547
Riso6666 VDD_B.t36 VDD_B.t64 9447.34680627224
Riso6667 VDD_B.t36 VDD_B.t66 5749.15370610489
Riso6668 VDD_B.t36 VDD_B.t67 32699.3101904309
Riso6669 VDD_B.t36 VDD_B.t68 36169.0499423134
Riso6670 VDD_B.t36 VDD_B.t69 11051.9729477962
Riso6671 VDD_B.t36 VDD_B.t70 24610.8097660296
Riso6672 VDD_B.t36 VDD_B.t71 78.1284249182901
Riso6673 VDD_B.t36 VDD_B.t73 9817.91474539087
Riso6674 VDD_B.t36 VDD_B.t75 5749.15370610489
Riso6675 VDD_B.t36 VDD_B.t76 65834.2758296203
Riso6676 VDD_B.t36 VDD_B.t77 66799.2171549319
Riso6677 VDD_B.t36 VDD_B.t78 67527.4456486798
Riso6678 VDD_B.t36 VDD_B.t79 56825.560215966
Riso6679 VDD_B.t36 VDD_B.t8 15494.2873497609
Riso6680 VDD_B.t36 VDD_B.t80 43909.8392884715
Riso6681 VDD_B.t36 VDD_B.t81 17.6932665323264
Riso6682 VDD_B.t36 VDD_B.t82 138.185658958397
Riso6683 VDD_B.t36 VDD_B.t83 46989.2557059995
Riso6684 VDD_B.t36 VDD_B.t85 16119.4259461964
Riso6685 VDD_B.t36 VDD_B.t86 67616.7676555877
Riso6686 VDD_B.t36 VDD_B.t87 7741.14629641788
Riso6687 VDD_B.t36 VDD_B.t88 66799.2171549319
Riso6688 VDD_B.t36 VDD_B.t89 35054.4928861073
Riso6689 VDD_B.t36 VDD_B.t9 61318.6783363301
Riso6690 VDD_B.t36 VDD_B.t90 9853.0731379238
Riso6691 VDD_B.t36 VDD_B.t91 27018.0593094878
Riso6692 VDD_B.t36 VDD_B.t92 63622.6061377827
Riso6693 VDD_B.t36 VDD_B.t94 14273.7095241855
Riso6694 VDD_B.t36 VDD_B.t95 28509.4382815954
Riso6695 VDD_B.t36 VDD_B.t96 90.6348063156418
Riso6696 VDD_B.t36 VDD_B.t97 87.0570407241907
Riso6697 VDD_B.t36 VDD_B.t99 14273.7095241855
Riso6698 VDD_B.t37 VDD_B.t38 31.7848239143496
Riso6699 VDD_B.t37 VDD_B.t39 19.3212167564643
Riso6700 VDD_B.t37 VDD_B.t4 3697.56023664702
Riso6701 VDD_B.t37 VDD_B.t41 1527.60623076927
Riso6702 VDD_B.t37 VDD_B.t42 275.791080910332
Riso6703 VDD_B.t37 VDD_B.t43 527.771546250669
Riso6704 VDD_B.t37 VDD_B.t44 39644.3466252856
Riso6705 VDD_B.t37 VDD_B.t45 116380.371330027
Riso6706 VDD_B.t37 VDD_B.t46 46.6896882408974
Riso6707 VDD_B.t37 VDD_B.t47 26.2878457374936
Riso6708 VDD_B.t37 VDD_B.t48 161.928741035105
Riso6709 VDD_B.t37 VDD_B.t49 88.3181155612572
Riso6710 VDD_B.t37 VDD_B.t50 43.7447368507025
Riso6711 VDD_B.t37 VDD_B.t51 639.603755366217
Riso6712 VDD_B.t37 VDD_B.t52 88.3181155612572
Riso6713 VDD_B.t37 VDD_B.t53 58.9921546880129
Riso6714 VDD_B.t37 VDD_B.t55 3456.12113736201
Riso6715 VDD_B.t37 VDD_B.t56 202.962813717142
Riso6716 VDD_B.t37 VDD_B.t57 143.729229549927
Riso6717 VDD_B.t37 VDD_B.t58 124632.323850914
Riso6718 VDD_B.t37 VDD_B.t59 716.986893747448
Riso6719 VDD_B.t37 VDD_B.t6 2449.04886472678
Riso6720 VDD_B.t37 VDD_B.t60 22.6455881365276
Riso6721 VDD_B.t37 VDD_B.t61 457.876446383002
Riso6722 VDD_B.t37 VDD_B.t62 618.258154975889
Riso6723 VDD_B.t37 VDD_B.t63 275.791080910332
Riso6724 VDD_B.t37 VDD_B.t64 216.389076093372
Riso6725 VDD_B.t37 VDD_B.t66 2086.11121472647
Riso6726 VDD_B.t37 VDD_B.t67 44.6038753514892
Riso6727 VDD_B.t37 VDD_B.t68 41.6356178966998
Riso6728 VDD_B.t37 VDD_B.t69 591.571131339548
Riso6729 VDD_B.t37 VDD_B.t70 330.532502773391
Riso6730 VDD_B.t37 VDD_B.t71 16493.7110896162
Riso6731 VDD_B.t37 VDD_B.t73 1527.60623076927
Riso6732 VDD_B.t37 VDD_B.t75 2086.11121472647
Riso6733 VDD_B.t37 VDD_B.t76 26.9073107231071
Riso6734 VDD_B.t37 VDD_B.t77 50.9372586823911
Riso6735 VDD_B.t37 VDD_B.t78 43.7447368507025
Riso6736 VDD_B.t37 VDD_B.t79 19.3212167564643
Riso6737 VDD_B.t37 VDD_B.t8 2887.15346504163
Riso6738 VDD_B.t37 VDD_B.t80 161.928741035105
Riso6739 VDD_B.t37 VDD_B.t81 41957.0676504744
Riso6740 VDD_B.t37 VDD_B.t82 6464.17795015697
Riso6741 VDD_B.t37 VDD_B.t83 30.1686769789224
Riso6742 VDD_B.t37 VDD_B.t85 3560.22147592733
Riso6743 VDD_B.t37 VDD_B.t86 37.3775601693822
Riso6744 VDD_B.t37 VDD_B.t87 654.153276315015
Riso6745 VDD_B.t37 VDD_B.t88 50.9372586823911
Riso6746 VDD_B.t37 VDD_B.t89 225.792145981379
Riso6747 VDD_B.t37 VDD_B.t9 77.7204092124238
Riso6748 VDD_B.t37 VDD_B.t90 618.258154975889
Riso6749 VDD_B.t37 VDD_B.t91 302.685730117834
Riso6750 VDD_B.t37 VDD_B.t92 67.9250920188268
Riso6751 VDD_B.t37 VDD_B.t94 3801.50253822139
Riso6752 VDD_B.t37 VDD_B.t95 50.9678905110056
Riso6753 VDD_B.t37 VDD_B.t96 8676.24155479584
Riso6754 VDD_B.t37 VDD_B.t97 12454.423515993
Riso6755 VDD_B.t37 VDD_B.t99 3801.50253822139
Riso6756 VDD_B.t38 VDD_B.t39 72.1846190224478
Riso6757 VDD_B.t38 VDD_B.t4 6527.96890804708
Riso6758 VDD_B.t38 VDD_B.t41 2674.99425303275
Riso6759 VDD_B.t38 VDD_B.t42 378.781489044167
Riso6760 VDD_B.t38 VDD_B.t43 795.203617997064
Riso6761 VDD_B.t38 VDD_B.t44 87384.6687703398
Riso6762 VDD_B.t38 VDD_B.t45 256527.375672704
Riso6763 VDD_B.t38 VDD_B.t46 151.419892268732
Riso6764 VDD_B.t38 VDD_B.t47 94.7636818469557
Riso6765 VDD_B.t38 VDD_B.t48 207.525510202921
Riso6766 VDD_B.t38 VDD_B.t49 105.050297983374
Riso6767 VDD_B.t38 VDD_B.t50 48.0822421431112
Riso6768 VDD_B.t38 VDD_B.t51 1016.69722738712
Riso6769 VDD_B.t38 VDD_B.t52 105.050297983374
Riso6770 VDD_B.t38 VDD_B.t53 66.949923758641
Riso6771 VDD_B.t38 VDD_B.t55 6059.25034014014
Riso6772 VDD_B.t38 VDD_B.t56 267.881957822298
Riso6773 VDD_B.t38 VDD_B.t57 181.37425508793
Riso6774 VDD_B.t38 VDD_B.t58 218253.411956214
Riso6775 VDD_B.t38 VDD_B.t59 1255.55086208395
Riso6776 VDD_B.t38 VDD_B.t6 4428.2452779483
Riso6777 VDD_B.t38 VDD_B.t60 83.1384224731862
Riso6778 VDD_B.t38 VDD_B.t61 673.246087337361
Riso6779 VDD_B.t38 VDD_B.t62 969.045848846009
Riso6780 VDD_B.t38 VDD_B.t63 378.781489044167
Riso6781 VDD_B.t38 VDD_B.t64 314.39932239758
Riso6782 VDD_B.t38 VDD_B.t66 3887.38537128005
Riso6783 VDD_B.t38 VDD_B.t67 146.78149483051
Riso6784 VDD_B.t38 VDD_B.t68 139.305376531126
Riso6785 VDD_B.t38 VDD_B.t69 914.677696621613
Riso6786 VDD_B.t38 VDD_B.t70 464.70374391128
Riso6787 VDD_B.t38 VDD_B.t71 36355.6875834728
Riso6788 VDD_B.t38 VDD_B.t73 2674.99425303275
Riso6789 VDD_B.t38 VDD_B.t75 3887.38537128005
Riso6790 VDD_B.t38 VDD_B.t76 39.7497280668417
Riso6791 VDD_B.t38 VDD_B.t77 56.8854613301004
Riso6792 VDD_B.t38 VDD_B.t78 48.0822421431112
Riso6793 VDD_B.t38 VDD_B.t79 72.1846190224478
Riso6794 VDD_B.t38 VDD_B.t8 5054.45481435704
Riso6795 VDD_B.t38 VDD_B.t80 207.525510202921
Riso6796 VDD_B.t38 VDD_B.t81 92482.4034525256
Riso6797 VDD_B.t38 VDD_B.t82 14248.4388603019
Riso6798 VDD_B.t38 VDD_B.t83 106.727427254962
Riso6799 VDD_B.t38 VDD_B.t85 6231.05176025534
Riso6800 VDD_B.t38 VDD_B.t86 40.4503822249444
Riso6801 VDD_B.t38 VDD_B.t87 1054.91151800489
Riso6802 VDD_B.t38 VDD_B.t88 56.8854613301004
Riso6803 VDD_B.t38 VDD_B.t89 302.175878670212
Riso6804 VDD_B.t38 VDD_B.t9 91.0574041308907
Riso6805 VDD_B.t38 VDD_B.t90 969.045848846009
Riso6806 VDD_B.t38 VDD_B.t91 420.745146015028
Riso6807 VDD_B.t38 VDD_B.t92 78.3364549445744
Riso6808 VDD_B.t38 VDD_B.t94 6650.91711656385
Riso6809 VDD_B.t38 VDD_B.t95 61.4822543981564
Riso6810 VDD_B.t38 VDD_B.t96 19124.3029328605
Riso6811 VDD_B.t38 VDD_B.t97 27452.2287870532
Riso6812 VDD_B.t38 VDD_B.t99 6650.91711656385
Riso6813 VDD_B.t39 VDD_B.t4 7300.37904628956
Riso6814 VDD_B.t39 VDD_B.t41 3036.19486338636
Riso6815 VDD_B.t39 VDD_B.t42 583.898712656351
Riso6816 VDD_B.t39 VDD_B.t43 1090.18678301823
Riso6817 VDD_B.t39 VDD_B.t44 74060.465648165
Riso6818 VDD_B.t39 VDD_B.t45 217412.701348715
Riso6819 VDD_B.t39 VDD_B.t46 80.5373243605827
Riso6820 VDD_B.t39 VDD_B.t47 44.2811508841418
Riso6821 VDD_B.t39 VDD_B.t48 348.940700276732
Riso6822 VDD_B.t39 VDD_B.t49 194.166673421351
Riso6823 VDD_B.t39 VDD_B.t50 98.4078575867183
Riso6824 VDD_B.t39 VDD_B.t51 1301.15007823717
Riso6825 VDD_B.t39 VDD_B.t52 194.166673421351
Riso6826 VDD_B.t39 VDD_B.t53 131.445007397423
Riso6827 VDD_B.t39 VDD_B.t55 6840.86153357507
Riso6828 VDD_B.t39 VDD_B.t56 434.071186710436
Riso6829 VDD_B.t39 VDD_B.t57 310.975042715586
Riso6830 VDD_B.t39 VDD_B.t58 247730.60391005
Riso6831 VDD_B.t39 VDD_B.t59 1425.13764711225
Riso6832 VDD_B.t39 VDD_B.t6 4796.09214619394
Riso6833 VDD_B.t39 VDD_B.t60 38.000455444543
Riso6834 VDD_B.t39 VDD_B.t61 952.193033498697
Riso6835 VDD_B.t39 VDD_B.t62 1262.8386679426
Riso6836 VDD_B.t39 VDD_B.t63 583.898712656351
Riso6837 VDD_B.t39 VDD_B.t64 451.444358690894
Riso6838 VDD_B.t39 VDD_B.t66 4051.84810965164
Riso6839 VDD_B.t39 VDD_B.t67 76.6746762189946
Riso6840 VDD_B.t39 VDD_B.t68 71.2970558025263
Riso6841 VDD_B.t39 VDD_B.t69 1213.06085769696
Riso6842 VDD_B.t39 VDD_B.t70 695.612159943584
Riso6843 VDD_B.t39 VDD_B.t71 30812.260197124
Riso6844 VDD_B.t39 VDD_B.t73 3036.19486338636
Riso6845 VDD_B.t39 VDD_B.t75 4051.84810965164
Riso6846 VDD_B.t39 VDD_B.t76 61.3893765559523
Riso6847 VDD_B.t39 VDD_B.t77 114.039456880474
Riso6848 VDD_B.t39 VDD_B.t78 98.4078575867183
Riso6849 VDD_B.t39 VDD_B.t79 0.0669561364620722
Riso6850 VDD_B.t39 VDD_B.t8 5734.99739178471
Riso6851 VDD_B.t39 VDD_B.t80 348.940700276732
Riso6852 VDD_B.t39 VDD_B.t81 78380.9100650881
Riso6853 VDD_B.t39 VDD_B.t82 12075.8713353565
Riso6854 VDD_B.t39 VDD_B.t83 51.0228438057977
Riso6855 VDD_B.t39 VDD_B.t85 7067.31247307198
Riso6856 VDD_B.t39 VDD_B.t86 84.4870650437975
Riso6857 VDD_B.t39 VDD_B.t87 1325.2197119911
Riso6858 VDD_B.t39 VDD_B.t88 114.039456880474
Riso6859 VDD_B.t39 VDD_B.t89 481.195821401675
Riso6860 VDD_B.t39 VDD_B.t9 171.59443552587
Riso6861 VDD_B.t39 VDD_B.t90 1262.8386679426
Riso6862 VDD_B.t39 VDD_B.t91 638.877364666105
Riso6863 VDD_B.t39 VDD_B.t92 150.644179089864
Riso6864 VDD_B.t39 VDD_B.t94 7539.736577732
Riso6865 VDD_B.t39 VDD_B.t95 111.617615744286
Riso6866 VDD_B.t39 VDD_B.t96 16208.2754370405
Riso6867 VDD_B.t39 VDD_B.t97 23266.3792820739
Riso6868 VDD_B.t39 VDD_B.t99 7539.736577732
Riso6869 VDD_B.t4 VDD_B.t41 493.025349495347
Riso6870 VDD_B.t4 VDD_B.t42 1686.20048534484
Riso6871 VDD_B.t4 VDD_B.t43 641.754643339989
Riso6872 VDD_B.t4 VDD_B.t44 14360.4765747243
Riso6873 VDD_B.t4 VDD_B.t45 42156.7698426037
Riso6874 VDD_B.t4 VDD_B.t46 5420.96024127099
Riso6875 VDD_B.t4 VDD_B.t47 7227.21567081837
Riso6876 VDD_B.t4 VDD_B.t48 2791.12943002009
Riso6877 VDD_B.t4 VDD_B.t49 4240.64734891569
Riso6878 VDD_B.t4 VDD_B.t50 5945.43996164589
Riso6879 VDD_B.t4 VDD_B.t51 356.854575237474
Riso6880 VDD_B.t4 VDD_B.t52 4240.64734891569
Riso6881 VDD_B.t4 VDD_B.t53 5276.36976211128
Riso6882 VDD_B.t4 VDD_B.t55 53.9140956750371
Riso6883 VDD_B.t4 VDD_B.t56 2310.31263419276
Riso6884 VDD_B.t4 VDD_B.t57 3047.13524691727
Riso6885 VDD_B.t4 VDD_B.t58 55813.4085843966
Riso6886 VDD_B.t4 VDD_B.t59 312.275228104277
Riso6887 VDD_B.t4 VDD_B.t6 133.720083242536
Riso6888 VDD_B.t4 VDD_B.t60 7301.88963074068
Riso6889 VDD_B.t4 VDD_B.t61 830.39757040831
Riso6890 VDD_B.t4 VDD_B.t62 416.553414596317
Riso6891 VDD_B.t4 VDD_B.t63 1686.20048534484
Riso6892 VDD_B.t4 VDD_B.t64 478.189397395748
Riso6893 VDD_B.t4 VDD_B.t66 275.665107652895
Riso6894 VDD_B.t4 VDD_B.t67 5838.74168020263
Riso6895 VDD_B.t4 VDD_B.t68 6225.01687632006
Riso6896 VDD_B.t4 VDD_B.t69 483.766347412629
Riso6897 VDD_B.t4 VDD_B.t70 1339.5922175676
Riso6898 VDD_B.t4 VDD_B.t71 5974.56060939679
Riso6899 VDD_B.t4 VDD_B.t73 493.025349495347
Riso6900 VDD_B.t4 VDD_B.t75 275.665107652895
Riso6901 VDD_B.t4 VDD_B.t76 6763.88815608854
Riso6902 VDD_B.t4 VDD_B.t77 5617.48292185749
Riso6903 VDD_B.t4 VDD_B.t78 5945.43996164589
Riso6904 VDD_B.t4 VDD_B.t79 7300.37904628956
Riso6905 VDD_B.t4 VDD_B.t8 272.856186828685
Riso6906 VDD_B.t4 VDD_B.t80 2791.12943002009
Riso6907 VDD_B.t4 VDD_B.t81 15198.2196310044
Riso6908 VDD_B.t4 VDD_B.t82 2341.53628272616
Riso6909 VDD_B.t4 VDD_B.t83 7076.82453891163
Riso6910 VDD_B.t4 VDD_B.t85 187.520176210158
Riso6911 VDD_B.t4 VDD_B.t86 6251.96817798526
Riso6912 VDD_B.t4 VDD_B.t87 304.238883849973
Riso6913 VDD_B.t4 VDD_B.t88 5617.48292185749
Riso6914 VDD_B.t4 VDD_B.t89 2088.57483846032
Riso6915 VDD_B.t4 VDD_B.t9 4582.43535858069
Riso6916 VDD_B.t4 VDD_B.t90 416.553414596317
Riso6917 VDD_B.t4 VDD_B.t91 1505.97516830973
Riso6918 VDD_B.t4 VDD_B.t92 4929.32575849544
Riso6919 VDD_B.t4 VDD_B.t94 126.497171779381
Riso6920 VDD_B.t4 VDD_B.t95 1999.79626533926
Riso6921 VDD_B.t4 VDD_B.t96 3142.81793522678
Riso6922 VDD_B.t4 VDD_B.t97 4511.39878388209
Riso6923 VDD_B.t4 VDD_B.t99 126.497171779381
Riso6924 VDD_B.t40 VDD_B.t58 158.648
Riso6925 VDD_B.t40 VDD_B.t72 158.648
Riso6926 VDD_B.t41 VDD_B.t42 950.175454502726
Riso6927 VDD_B.t41 VDD_B.t43 509.524837149119
Riso6928 VDD_B.t41 VDD_B.t44 12795.6387050864
Riso6929 VDD_B.t41 VDD_B.t45 37563.0149231167
Riso6930 VDD_B.t41 VDD_B.t46 2543.65465044876
Riso6931 VDD_B.t41 VDD_B.t47 3068.35210327971
Riso6932 VDD_B.t41 VDD_B.t48 1355.35539676315
Riso6933 VDD_B.t41 VDD_B.t49 1867.12862299107
Riso6934 VDD_B.t41 VDD_B.t50 2460.36383169968
Riso6935 VDD_B.t41 VDD_B.t51 358.948451297099
Riso6936 VDD_B.t41 VDD_B.t52 1867.12862299107
Riso6937 VDD_B.t41 VDD_B.t53 2224.96530765422
Riso6938 VDD_B.t41 VDD_B.t55 353.870298318363
Riso6939 VDD_B.t41 VDD_B.t56 1182.00625743825
Riso6940 VDD_B.t41 VDD_B.t57 1446.88762081331
Riso6941 VDD_B.t41 VDD_B.t58 5362.04209336701
Riso6942 VDD_B.t41 VDD_B.t59 24.8024632669895
Riso6943 VDD_B.t41 VDD_B.t6 934.448435905108
Riso6944 VDD_B.t41 VDD_B.t60 3064.70123292227
Riso6945 VDD_B.t41 VDD_B.t61 597.62008537286
Riso6946 VDD_B.t41 VDD_B.t62 393.393450276987
Riso6947 VDD_B.t41 VDD_B.t63 950.175454502726
Riso6948 VDD_B.t41 VDD_B.t64 329.897192619806
Riso6949 VDD_B.t41 VDD_B.t66 1048.68990135543
Riso6950 VDD_B.t41 VDD_B.t67 2689.79641015534
Riso6951 VDD_B.t41 VDD_B.t68 2815.8163882465
Riso6952 VDD_B.t41 VDD_B.t69 429.951815934158
Riso6953 VDD_B.t41 VDD_B.t70 815.196284422307
Riso6954 VDD_B.t41 VDD_B.t71 5323.52241805384
Riso6955 VDD_B.t41 VDD_B.t73 0.823892111511786
Riso6956 VDD_B.t41 VDD_B.t75 1048.68990135543
Riso6957 VDD_B.t41 VDD_B.t76 2768.18499926195
Riso6958 VDD_B.t41 VDD_B.t77 2344.12957593811
Riso6959 VDD_B.t41 VDD_B.t78 2460.36383169968
Riso6960 VDD_B.t41 VDD_B.t79 3036.19486338636
Riso6961 VDD_B.t41 VDD_B.t8 69.6517274744538
Riso6962 VDD_B.t41 VDD_B.t80 1355.35539676315
Riso6963 VDD_B.t41 VDD_B.t81 13542.0942575937
Riso6964 VDD_B.t41 VDD_B.t82 2086.38286708044
Riso6965 VDD_B.t41 VDD_B.t83 3045.5334754608
Riso6966 VDD_B.t41 VDD_B.t85 105.563039339753
Riso6967 VDD_B.t41 VDD_B.t86 2571.47894241195
Riso6968 VDD_B.t41 VDD_B.t87 326.568614115345
Riso6969 VDD_B.t41 VDD_B.t88 2344.12957593811
Riso6970 VDD_B.t41 VDD_B.t89 1100.82418265034
Riso6971 VDD_B.t41 VDD_B.t9 1985.04566139556
Riso6972 VDD_B.t41 VDD_B.t90 393.393450276987
Riso6973 VDD_B.t41 VDD_B.t91 880.7522491079
Riso6974 VDD_B.t41 VDD_B.t92 2104.7484590425
Riso6975 VDD_B.t41 VDD_B.t94 161.393787791799
Riso6976 VDD_B.t41 VDD_B.t95 896.565655414365
Riso6977 VDD_B.t41 VDD_B.t96 2800.35015591392
Riso6978 VDD_B.t41 VDD_B.t97 4019.79896647193
Riso6979 VDD_B.t41 VDD_B.t99 161.393787791799
Riso6980 VDD_B.t42 VDD_B.t43 119.273400956248
Riso6981 VDD_B.t42 VDD_B.t44 38536.0903449669
Riso6982 VDD_B.t42 VDD_B.t45 113126.962246219
Riso6983 VDD_B.t42 VDD_B.t46 768.533272286051
Riso6984 VDD_B.t42 VDD_B.t47 668.516697855381
Riso6985 VDD_B.t42 VDD_B.t48 79.8446121707502
Riso6986 VDD_B.t42 VDD_B.t49 162.190745762159
Riso6987 VDD_B.t42 VDD_B.t50 306.331850879008
Riso6988 VDD_B.t42 VDD_B.t51 193.02685676173
Riso6989 VDD_B.t42 VDD_B.t52 162.190745762159
Riso6990 VDD_B.t42 VDD_B.t53 241.569088670328
Riso6991 VDD_B.t42 VDD_B.t55 1546.62429810543
Riso6992 VDD_B.t42 VDD_B.t56 58.1688930301409
Riso6993 VDD_B.t42 VDD_B.t57 92.5097092801871
Riso6994 VDD_B.t42 VDD_B.t58 78254.5897181212
Riso6995 VDD_B.t42 VDD_B.t59 449.489646939332
Riso6996 VDD_B.t42 VDD_B.t6 1218.31751522826
Riso6997 VDD_B.t42 VDD_B.t60 627.547473797455
Riso6998 VDD_B.t42 VDD_B.t61 88.8935313299817
Riso6999 VDD_B.t42 VDD_B.t62 174.011932998834
Riso7000 VDD_B.t42 VDD_B.t63 0.0669655922695506
Riso7001 VDD_B.t42 VDD_B.t64 38.8882440172144
Riso7002 VDD_B.t42 VDD_B.t66 1124.23942973812
Riso7003 VDD_B.t42 VDD_B.t67 776.473830232273
Riso7004 VDD_B.t42 VDD_B.t68 773.100248946967
Riso7005 VDD_B.t42 VDD_B.t69 154.974774007329
Riso7006 VDD_B.t42 VDD_B.t70 48.1728345616373
Riso7007 VDD_B.t42 VDD_B.t71 16032.6299908759
Riso7008 VDD_B.t42 VDD_B.t73 950.175454502726
Riso7009 VDD_B.t42 VDD_B.t75 1124.23942973812
Riso7010 VDD_B.t42 VDD_B.t76 416.763816278014
Riso7011 VDD_B.t42 VDD_B.t77 272.839985497828
Riso7012 VDD_B.t42 VDD_B.t78 306.331850879008
Riso7013 VDD_B.t42 VDD_B.t79 583.898712656351
Riso7014 VDD_B.t42 VDD_B.t8 1673.9372431538
Riso7015 VDD_B.t42 VDD_B.t80 79.8446121707502
Riso7016 VDD_B.t42 VDD_B.t81 40784.1593372942
Riso7017 VDD_B.t42 VDD_B.t82 6283.47208866119
Riso7018 VDD_B.t42 VDD_B.t83 705.248105349679
Riso7019 VDD_B.t42 VDD_B.t85 1917.9739088099
Riso7020 VDD_B.t42 VDD_B.t86 341.78018350013
Riso7021 VDD_B.t42 VDD_B.t87 211.124795053716
Riso7022 VDD_B.t42 VDD_B.t88 272.839985497828
Riso7023 VDD_B.t42 VDD_B.t89 49.1949353744108
Riso7024 VDD_B.t42 VDD_B.t9 186.213572902435
Riso7025 VDD_B.t42 VDD_B.t90 174.011932998834
Riso7026 VDD_B.t42 VDD_B.t91 41.0331913276019
Riso7027 VDD_B.t42 VDD_B.t92 212.671981891566
Riso7028 VDD_B.t42 VDD_B.t94 1873.26072252893
Riso7029 VDD_B.t42 VDD_B.t95 71.9241477592766
Riso7030 VDD_B.t42 VDD_B.t96 8433.69753500028
Riso7031 VDD_B.t42 VDD_B.t97 12106.260555715
Riso7032 VDD_B.t42 VDD_B.t99 1873.26072252893
Riso7033 VDD_B.t43 VDD_B.t44 17910.5253823108
Riso7034 VDD_B.t43 VDD_B.t45 52578.3313926461
Riso7035 VDD_B.t43 VDD_B.t46 1182.89065080842
Riso7036 VDD_B.t43 VDD_B.t47 1187.7966646101
Riso7037 VDD_B.t43 VDD_B.t48 235.011518435468
Riso7038 VDD_B.t43 VDD_B.t49 412.890131074196
Riso7039 VDD_B.t43 VDD_B.t50 676.228696049545
Riso7040 VDD_B.t43 VDD_B.t51 62.2058663726203
Riso7041 VDD_B.t43 VDD_B.t52 412.890131074196
Riso7042 VDD_B.t43 VDD_B.t53 562.98341506506
Riso7043 VDD_B.t43 VDD_B.t55 570.68270695557
Riso7044 VDD_B.t43 VDD_B.t56 182.216445000381
Riso7045 VDD_B.t43 VDD_B.t57 264.364454111805
Riso7046 VDD_B.t43 VDD_B.t58 42627.8205423887
Riso7047 VDD_B.t43 VDD_B.t59 244.204791402687
Riso7048 VDD_B.t43 VDD_B.t6 535.581887327304
Riso7049 VDD_B.t43 VDD_B.t60 1143.05845264111
Riso7050 VDD_B.t43 VDD_B.t61 47.04742990776
Riso7051 VDD_B.t43 VDD_B.t62 54.3145058406859
Riso7052 VDD_B.t43 VDD_B.t63 119.273400956248
Riso7053 VDD_B.t43 VDD_B.t64 28.0181519169638
Riso7054 VDD_B.t43 VDD_B.t66 503.800473198831
Riso7055 VDD_B.t43 VDD_B.t67 1221.53730480182
Riso7056 VDD_B.t43 VDD_B.t68 1244.74727447657
Riso7057 VDD_B.t43 VDD_B.t69 46.8317310473358
Riso7058 VDD_B.t43 VDD_B.t70 87.6858063015415
Riso7059 VDD_B.t43 VDD_B.t71 7451.52982116888
Riso7060 VDD_B.t43 VDD_B.t73 509.524837149119
Riso7061 VDD_B.t43 VDD_B.t75 503.800473198831
Riso7062 VDD_B.t43 VDD_B.t76 854.581657081732
Riso7063 VDD_B.t43 VDD_B.t77 618.546963611092
Riso7064 VDD_B.t43 VDD_B.t78 676.228696049545
Riso7065 VDD_B.t43 VDD_B.t79 1090.18678301823
Riso7066 VDD_B.t43 VDD_B.t8 807.574592495743
Riso7067 VDD_B.t43 VDD_B.t80 235.011518435468
Riso7068 VDD_B.t43 VDD_B.t81 18955.3666308087
Riso7069 VDD_B.t43 VDD_B.t82 2920.3867160776
Riso7070 VDD_B.t43 VDD_B.t83 1222.21303182606
Riso7071 VDD_B.t43 VDD_B.t85 843.028368179205
Riso7072 VDD_B.t43 VDD_B.t86 735.394482847858
Riso7073 VDD_B.t43 VDD_B.t87 70.1615262061326
Riso7074 VDD_B.t43 VDD_B.t88 618.546963611092
Riso7075 VDD_B.t43 VDD_B.t89 159.056474678991
Riso7076 VDD_B.t43 VDD_B.t9 459.899801970358
Riso7077 VDD_B.t43 VDD_B.t90 54.3145058406859
Riso7078 VDD_B.t43 VDD_B.t91 102.510625682154
Riso7079 VDD_B.t43 VDD_B.t92 509.996514282912
Riso7080 VDD_B.t43 VDD_B.t94 748.856878481855
Riso7081 VDD_B.t43 VDD_B.t95 188.868471237304
Riso7082 VDD_B.t43 VDD_B.t96 3919.7529488635
Riso7083 VDD_B.t43 VDD_B.t97 5626.6602301113
Riso7084 VDD_B.t43 VDD_B.t99 748.856878481855
Riso7085 VDD_B.t44 VDD_B.t45 63.3000697810084
Riso7086 VDD_B.t44 VDD_B.t46 38293.7745580083
Riso7087 VDD_B.t44 VDD_B.t47 65813.9889248089
Riso7088 VDD_B.t44 VDD_B.t48 57227.4717905304
Riso7089 VDD_B.t44 VDD_B.t49 76440.5134273358
Riso7090 VDD_B.t44 VDD_B.t50 88008.1788857972
Riso7091 VDD_B.t44 VDD_B.t51 11404.3273044639
Riso7092 VDD_B.t44 VDD_B.t52 76440.5134273358
Riso7093 VDD_B.t44 VDD_B.t53 85334.5140165588
Riso7094 VDD_B.t44 VDD_B.t55 13762.9316125513
Riso7095 VDD_B.t44 VDD_B.t56 49464.6463322668
Riso7096 VDD_B.t44 VDD_B.t57 61094.0642013302
Riso7097 VDD_B.t44 VDD_B.t58 1070945.37927523
Riso7098 VDD_B.t44 VDD_B.t59 6136.09996644477
Riso7099 VDD_B.t44 VDD_B.t6 9070.06700979756
Riso7100 VDD_B.t44 VDD_B.t60 70130.9577645834
Riso7101 VDD_B.t44 VDD_B.t61 21905.1140998692
Riso7102 VDD_B.t44 VDD_B.t62 12841.4604605171
Riso7103 VDD_B.t44 VDD_B.t63 38536.0903449669
Riso7104 VDD_B.t44 VDD_B.t64 12312.6793814808
Riso7105 VDD_B.t44 VDD_B.t66 7492.84299070352
Riso7106 VDD_B.t44 VDD_B.t67 42616.8458326378
Riso7107 VDD_B.t44 VDD_B.t68 47138.9401283342
Riso7108 VDD_B.t44 VDD_B.t69 14403.9805280219
Riso7109 VDD_B.t44 VDD_B.t70 32075.1440781827
Riso7110 VDD_B.t44 VDD_B.t71 101.587568119242
Riso7111 VDD_B.t44 VDD_B.t73 12795.6387050864
Riso7112 VDD_B.t44 VDD_B.t75 7492.84299070352
Riso7113 VDD_B.t44 VDD_B.t76 85801.4792114887
Riso7114 VDD_B.t44 VDD_B.t77 87059.0823676061
Riso7115 VDD_B.t44 VDD_B.t78 88008.1788857972
Riso7116 VDD_B.t44 VDD_B.t79 74060.465648165
Riso7117 VDD_B.t44 VDD_B.t8 20193.626453459
Riso7118 VDD_B.t44 VDD_B.t80 57227.4717905304
Riso7119 VDD_B.t44 VDD_B.t81 18.1237173562668
Riso7120 VDD_B.t44 VDD_B.t82 179.506415690956
Riso7121 VDD_B.t44 VDD_B.t83 61240.8596557794
Riso7122 VDD_B.t44 VDD_B.t85 21008.3664291091
Riso7123 VDD_B.t44 VDD_B.t86 88124.5918063048
Riso7124 VDD_B.t44 VDD_B.t87 10088.9968736674
Riso7125 VDD_B.t44 VDD_B.t88 87059.0823676061
Riso7126 VDD_B.t44 VDD_B.t89 45686.3435457335
Riso7127 VDD_B.t44 VDD_B.t9 79916.3238032223
Riso7128 VDD_B.t44 VDD_B.t90 12841.4604605171
Riso7129 VDD_B.t44 VDD_B.t91 35212.5002510437
Riso7130 VDD_B.t44 VDD_B.t92 82919.0212715245
Riso7131 VDD_B.t44 VDD_B.t94 18602.8535375673
Riso7132 VDD_B.t44 VDD_B.t95 37156.2069336068
Riso7133 VDD_B.t44 VDD_B.t96 117.81667564784
Riso7134 VDD_B.t44 VDD_B.t97 113.184536225848
Riso7135 VDD_B.t44 VDD_B.t99 18602.8535375673
Riso7136 VDD_B.t45 VDD_B.t46 112415.617409794
Riso7137 VDD_B.t45 VDD_B.t47 193204.255380369
Riso7138 VDD_B.t45 VDD_B.t48 167997.58311599
Riso7139 VDD_B.t45 VDD_B.t49 224399.595266811
Riso7140 VDD_B.t45 VDD_B.t50 258357.758689249
Riso7141 VDD_B.t45 VDD_B.t51 33478.666176734
Riso7142 VDD_B.t45 VDD_B.t52 224399.595266811
Riso7143 VDD_B.t45 VDD_B.t53 250508.919276278
Riso7144 VDD_B.t45 VDD_B.t55 40402.6104099514
Riso7145 VDD_B.t45 VDD_B.t56 145208.949015342
Riso7146 VDD_B.t45 VDD_B.t57 179348.393480053
Riso7147 VDD_B.t45 VDD_B.t58 3143878.8004828
Riso7148 VDD_B.t45 VDD_B.t59 18013.2012103217
Riso7149 VDD_B.t45 VDD_B.t6 26626.1864917508
Riso7150 VDD_B.t45 VDD_B.t60 205877.195644509
Riso7151 VDD_B.t45 VDD_B.t61 64304.8890946633
Riso7152 VDD_B.t45 VDD_B.t62 37697.5297623302
Riso7153 VDD_B.t45 VDD_B.t63 113126.962246219
Riso7154 VDD_B.t45 VDD_B.t64 36145.2343263076
Riso7155 VDD_B.t45 VDD_B.t66 21996.0706583944
Riso7156 VDD_B.t45 VDD_B.t67 125106.47204748
Riso7157 VDD_B.t45 VDD_B.t68 138381.580811333
Riso7158 VDD_B.t45 VDD_B.t69 42284.4805168885
Riso7159 VDD_B.t45 VDD_B.t70 94160.1387346899
Riso7160 VDD_B.t45 VDD_B.t71 323.599484976376
Riso7161 VDD_B.t45 VDD_B.t73 37563.0149231167
Riso7162 VDD_B.t45 VDD_B.t75 21996.0706583944
Riso7163 VDD_B.t45 VDD_B.t76 251879.747336527
Riso7164 VDD_B.t45 VDD_B.t77 255571.580718929
Riso7165 VDD_B.t45 VDD_B.t78 258357.758689249
Riso7166 VDD_B.t45 VDD_B.t79 217412.701348715
Riso7167 VDD_B.t45 VDD_B.t8 59280.6275095592
Riso7168 VDD_B.t45 VDD_B.t80 167997.58311599
Riso7169 VDD_B.t45 VDD_B.t81 90.4285194164666
Riso7170 VDD_B.t45 VDD_B.t82 592.294048362026
Riso7171 VDD_B.t45 VDD_B.t83 179779.327798629
Riso7172 VDD_B.t45 VDD_B.t85 61672.3869651962
Riso7173 VDD_B.t45 VDD_B.t86 258699.501713654
Riso7174 VDD_B.t45 VDD_B.t87 29617.3679844679
Riso7175 VDD_B.t45 VDD_B.t88 255571.580718929
Riso7176 VDD_B.t45 VDD_B.t89 134117.322624064
Riso7177 VDD_B.t45 VDD_B.t9 234603.221676444
Riso7178 VDD_B.t45 VDD_B.t90 37697.5297623302
Riso7179 VDD_B.t45 VDD_B.t91 103370.195337293
Riso7180 VDD_B.t45 VDD_B.t92 243417.972734288
Riso7181 VDD_B.t45 VDD_B.t94 54610.7373887029
Riso7182 VDD_B.t45 VDD_B.t95 109076.161628312
Riso7183 VDD_B.t45 VDD_B.t96 379.041691126047
Riso7184 VDD_B.t45 VDD_B.t97 361.951601138204
Riso7185 VDD_B.t45 VDD_B.t99 54610.7373887029
Riso7186 VDD_B.t46 VDD_B.t47 61.3378808219145
Riso7187 VDD_B.t46 VDD_B.t48 513.202659108967
Riso7188 VDD_B.t46 VDD_B.t49 323.490581907348
Riso7189 VDD_B.t46 VDD_B.t50 191.951853962472
Riso7190 VDD_B.t46 VDD_B.t51 1234.60932912171
Riso7191 VDD_B.t46 VDD_B.t52 323.490581907348
Riso7192 VDD_B.t46 VDD_B.t53 239.452844778716
Riso7193 VDD_B.t46 VDD_B.t55 5233.8111804537
Riso7194 VDD_B.t46 VDD_B.t56 609.521114357658
Riso7195 VDD_B.t46 VDD_B.t57 468.748400508824
Riso7196 VDD_B.t46 VDD_B.t58 207934.329927149
Riso7197 VDD_B.t46 VDD_B.t59 1195.89505466038
Riso7198 VDD_B.t46 VDD_B.t6 3260.52280503279
Riso7199 VDD_B.t46 VDD_B.t60 70.5330285157058
Riso7200 VDD_B.t46 VDD_B.t61 1093.83975794761
Riso7201 VDD_B.t46 VDD_B.t62 1241.57120409661
Riso7202 VDD_B.t46 VDD_B.t63 768.533272286051
Riso7203 VDD_B.t46 VDD_B.t64 532.271754705587
Riso7204 VDD_B.t46 VDD_B.t66 2597.25862726329
Riso7205 VDD_B.t46 VDD_B.t67 27.9996315515264
Riso7206 VDD_B.t46 VDD_B.t68 33.08388586534
Riso7207 VDD_B.t46 VDD_B.t69 1234.40706803717
Riso7208 VDD_B.t46 VDD_B.t70 877.875351770822
Riso7209 VDD_B.t46 VDD_B.t71 15931.8164594958
Riso7210 VDD_B.t46 VDD_B.t73 2543.65465044876
Riso7211 VDD_B.t46 VDD_B.t75 2597.25862726329
Riso7212 VDD_B.t46 VDD_B.t76 133.667697620118
Riso7213 VDD_B.t46 VDD_B.t77 214.82155380833
Riso7214 VDD_B.t46 VDD_B.t78 191.951853962472
Riso7215 VDD_B.t46 VDD_B.t79 80.5373243605827
Riso7216 VDD_B.t46 VDD_B.t8 4732.99175164582
Riso7217 VDD_B.t46 VDD_B.t80 513.202659108967
Riso7218 VDD_B.t46 VDD_B.t81 40527.7076428749
Riso7219 VDD_B.t46 VDD_B.t82 6243.96147742983
Riso7220 VDD_B.t46 VDD_B.t83 53.0030566254856
Riso7221 VDD_B.t46 VDD_B.t85 5736.55402399576
Riso7222 VDD_B.t46 VDD_B.t86 170.830208185722
Riso7223 VDD_B.t46 VDD_B.t87 1212.96009175209
Riso7224 VDD_B.t46 VDD_B.t88 214.82155380833
Riso7225 VDD_B.t46 VDD_B.t89 660.97206460934
Riso7226 VDD_B.t46 VDD_B.t9 293.880653239758
Riso7227 VDD_B.t46 VDD_B.t90 1241.57120409661
Riso7228 VDD_B.t46 VDD_B.t91 823.409042058134
Riso7229 VDD_B.t46 VDD_B.t92 265.826951320732
Riso7230 VDD_B.t46 VDD_B.t94 5990.43022766224
Riso7231 VDD_B.t46 VDD_B.t95 181.387517153135
Riso7232 VDD_B.t46 VDD_B.t96 8380.66625868578
Riso7233 VDD_B.t46 VDD_B.t97 12030.1361220368
Riso7234 VDD_B.t46 VDD_B.t99 5990.43022766224
Riso7235 VDD_B.t47 VDD_B.t48 412.988783347162
Riso7236 VDD_B.t47 VDD_B.t49 238.736056687114
Riso7237 VDD_B.t47 VDD_B.t50 126.664818243705
Riso7238 VDD_B.t47 VDD_B.t51 1372.19039287798
Riso7239 VDD_B.t47 VDD_B.t52 238.736056687114
Riso7240 VDD_B.t47 VDD_B.t53 165.940875239316
Riso7241 VDD_B.t47 VDD_B.t55 6814.64027993373
Riso7242 VDD_B.t47 VDD_B.t56 506.526271819467
Riso7243 VDD_B.t47 VDD_B.t57 370.855388422495
Riso7244 VDD_B.t47 VDD_B.t58 250422.883727675
Riso7245 VDD_B.t47 VDD_B.t59 1440.5757267653
Riso7246 VDD_B.t47 VDD_B.t6 4656.07704379451
Riso7247 VDD_B.t47 VDD_B.t60 37.8140902361695
Riso7248 VDD_B.t47 VDD_B.t61 1052.07213623634
Riso7249 VDD_B.t47 VDD_B.t62 1343.41514117875
Riso7250 VDD_B.t47 VDD_B.t63 668.516697855381
Riso7251 VDD_B.t47 VDD_B.t64 502.068156916961
Riso7252 VDD_B.t47 VDD_B.t66 3868.0817367061
Riso7253 VDD_B.t47 VDD_B.t67 57.9511109446611
Riso7254 VDD_B.t47 VDD_B.t68 53.4328166500979
Riso7255 VDD_B.t47 VDD_B.t69 1301.29742843352
Riso7256 VDD_B.t47 VDD_B.t70 787.249139229879
Riso7257 VDD_B.t47 VDD_B.t71 27381.379979375
Riso7258 VDD_B.t47 VDD_B.t73 3068.35210327971
Riso7259 VDD_B.t47 VDD_B.t75 3868.0817367061
Riso7260 VDD_B.t47 VDD_B.t76 81.3824084705324
Riso7261 VDD_B.t47 VDD_B.t77 145.355394122071
Riso7262 VDD_B.t47 VDD_B.t78 126.664818243705
Riso7263 VDD_B.t47 VDD_B.t79 44.2811508841418
Riso7264 VDD_B.t47 VDD_B.t8 5782.89391805527
Riso7265 VDD_B.t47 VDD_B.t80 412.988783347162
Riso7266 VDD_B.t47 VDD_B.t81 69653.360963819
Riso7267 VDD_B.t47 VDD_B.t82 10731.2485192599
Riso7268 VDD_B.t47 VDD_B.t83 37.2327066554401
Riso7269 VDD_B.t47 VDD_B.t85 7108.66349745628
Riso7270 VDD_B.t47 VDD_B.t86 109.825767153291
Riso7271 VDD_B.t47 VDD_B.t87 1385.16711053232
Riso7272 VDD_B.t47 VDD_B.t88 145.355394122071
Riso7273 VDD_B.t47 VDD_B.t89 557.818178857911
Riso7274 VDD_B.t47 VDD_B.t9 212.733777281075
Riso7275 VDD_B.t47 VDD_B.t90 1343.41514117875
Riso7276 VDD_B.t47 VDD_B.t91 727.174073727447
Riso7277 VDD_B.t47 VDD_B.t92 188.420748276079
Riso7278 VDD_B.t47 VDD_B.t94 7559.20666168931
Riso7279 VDD_B.t47 VDD_B.t95 136.21108352287
Riso7280 VDD_B.t47 VDD_B.t96 14403.5181357257
Riso7281 VDD_B.t47 VDD_B.t97 20675.7169967747
Riso7282 VDD_B.t47 VDD_B.t99 7559.20666168931
Riso7283 VDD_B.t48 VDD_B.t49 76.7119107723172
Riso7284 VDD_B.t48 VDD_B.t50 161.300179496584
Riso7285 VDD_B.t48 VDD_B.t51 350.515138833889
Riso7286 VDD_B.t48 VDD_B.t52 76.7119107723172
Riso7287 VDD_B.t48 VDD_B.t53 121.926977238574
Riso7288 VDD_B.t48 VDD_B.t55 2581.58241131643
Riso7289 VDD_B.t48 VDD_B.t56 48.9282161536782
Riso7290 VDD_B.t48 VDD_B.t57 40.5835127895311
Riso7291 VDD_B.t48 VDD_B.t58 111079.976428749
Riso7292 VDD_B.t48 VDD_B.t59 638.549732830836
Riso7293 VDD_B.t48 VDD_B.t6 1939.06084880104
Riso7294 VDD_B.t48 VDD_B.t60 381.440886084003
Riso7295 VDD_B.t48 VDD_B.t61 182.904658816646
Riso7296 VDD_B.t48 VDD_B.t62 322.09686258248
Riso7297 VDD_B.t48 VDD_B.t63 79.8446121707502
Riso7298 VDD_B.t48 VDD_B.t64 81.7572110961627
Riso7299 VDD_B.t48 VDD_B.t66 1774.8010135732
Riso7300 VDD_B.t48 VDD_B.t67 513.260655270333
Riso7301 VDD_B.t48 VDD_B.t68 505.221388468467
Riso7302 VDD_B.t48 VDD_B.t69 292.707517761633
Riso7303 VDD_B.t48 VDD_B.t70 107.007209533177
Riso7304 VDD_B.t48 VDD_B.t71 23809.0286875895
Riso7305 VDD_B.t48 VDD_B.t73 1355.35539676315
Riso7306 VDD_B.t48 VDD_B.t75 1774.8010135732
Riso7307 VDD_B.t48 VDD_B.t76 232.548353443667
Riso7308 VDD_B.t48 VDD_B.t77 140.687634426246
Riso7309 VDD_B.t48 VDD_B.t78 161.300179496584
Riso7310 VDD_B.t48 VDD_B.t79 348.940700276732
Riso7311 VDD_B.t48 VDD_B.t8 2474.82559674226
Riso7312 VDD_B.t48 VDD_B.t80 0.0669646590990348
Riso7313 VDD_B.t48 VDD_B.t81 60565.9346104457
Riso7314 VDD_B.t48 VDD_B.t82 9331.18067976002
Riso7315 VDD_B.t48 VDD_B.t83 442.455901798198
Riso7316 VDD_B.t48 VDD_B.t85 2939.9141081304
Riso7317 VDD_B.t48 VDD_B.t86 183.653937923129
Riso7318 VDD_B.t48 VDD_B.t87 376.618586813059
Riso7319 VDD_B.t48 VDD_B.t88 140.687634426246
Riso7320 VDD_B.t48 VDD_B.t89 57.9296081415201
Riso7321 VDD_B.t48 VDD_B.t9 89.9988743869116
Riso7322 VDD_B.t48 VDD_B.t90 322.09686258248
Riso7323 VDD_B.t48 VDD_B.t91 92.8051382314512
Riso7324 VDD_B.t48 VDD_B.t92 105.04328197021
Riso7325 VDD_B.t48 VDD_B.t94 2994.63381866876
Riso7326 VDD_B.t48 VDD_B.t95 33.299403625693
Riso7327 VDD_B.t48 VDD_B.t96 12524.3423360702
Riso7328 VDD_B.t48 VDD_B.t97 17978.2297124357
Riso7329 VDD_B.t48 VDD_B.t99 2994.63381866876
Riso7330 VDD_B.t49 VDD_B.t50 78.4447259643222
Riso7331 VDD_B.t49 VDD_B.t51 576.43861864076
Riso7332 VDD_B.t49 VDD_B.t52 0.0669625435020825
Riso7333 VDD_B.t49 VDD_B.t53 56.9633774977882
Riso7334 VDD_B.t49 VDD_B.t55 3927.93661949008
Riso7335 VDD_B.t49 VDD_B.t56 105.196956340579
Riso7336 VDD_B.t49 VDD_B.t57 65.0420364872093
Riso7337 VDD_B.t49 VDD_B.t58 152616.794902004
Riso7338 VDD_B.t49 VDD_B.t59 877.703211094709
Riso7339 VDD_B.t49 VDD_B.t6 2912.87855427483
Riso7340 VDD_B.t49 VDD_B.t60 216.417010761325
Riso7341 VDD_B.t49 VDD_B.t61 333.47333641704
Riso7342 VDD_B.t49 VDD_B.t62 537.850227445891
Riso7343 VDD_B.t49 VDD_B.t63 162.190745762159
Riso7344 VDD_B.t49 VDD_B.t64 151.949919307285
Riso7345 VDD_B.t49 VDD_B.t66 2639.04308314558
Riso7346 VDD_B.t49 VDD_B.t67 320.141519509919
Riso7347 VDD_B.t49 VDD_B.t68 311.27816115513
Riso7348 VDD_B.t49 VDD_B.t69 496.746267963036
Riso7349 VDD_B.t49 VDD_B.t70 209.517441736027
Riso7350 VDD_B.t49 VDD_B.t71 31802.4599050463
Riso7351 VDD_B.t49 VDD_B.t73 1867.12862299107
Riso7352 VDD_B.t49 VDD_B.t75 2639.04308314558
Riso7353 VDD_B.t49 VDD_B.t76 119.995852336775
Riso7354 VDD_B.t49 VDD_B.t77 67.0524790042405
Riso7355 VDD_B.t49 VDD_B.t78 78.4447259643222
Riso7356 VDD_B.t49 VDD_B.t79 194.166673421351
Riso7357 VDD_B.t49 VDD_B.t8 3478.74662995015
Riso7358 VDD_B.t49 VDD_B.t80 76.7119107723172
Riso7359 VDD_B.t49 VDD_B.t81 80899.8020177262
Riso7360 VDD_B.t49 VDD_B.t82 12463.9481655753
Riso7361 VDD_B.t49 VDD_B.t83 260.355326150309
Riso7362 VDD_B.t49 VDD_B.t85 4222.40273335279
Riso7363 VDD_B.t49 VDD_B.t86 91.1373571735049
Riso7364 VDD_B.t49 VDD_B.t87 610.630452785079
Riso7365 VDD_B.t49 VDD_B.t88 67.0524790042405
Riso7366 VDD_B.t49 VDD_B.t89 122.236935638833
Riso7367 VDD_B.t49 VDD_B.t9 40.4635901850547
Riso7368 VDD_B.t49 VDD_B.t90 537.850227445891
Riso7369 VDD_B.t49 VDD_B.t91 185.019291688917
Riso7370 VDD_B.t49 VDD_B.t92 48.1278836535006
Riso7371 VDD_B.t49 VDD_B.t94 4417.27557575547
Riso7372 VDD_B.t49 VDD_B.t95 20.3038205507568
Riso7373 VDD_B.t49 VDD_B.t96 16729.1534739324
Riso7374 VDD_B.t49 VDD_B.t97 24014.0804186385
Riso7375 VDD_B.t49 VDD_B.t99 4417.27557575547
Riso7376 VDD_B.t50 VDD_B.t51 886.250024290431
Riso7377 VDD_B.t50 VDD_B.t52 78.4447259643222
Riso7378 VDD_B.t50 VDD_B.t53 48.8371511613795
Riso7379 VDD_B.t50 VDD_B.t55 5510.34212473785
Riso7380 VDD_B.t50 VDD_B.t56 211.71789279396
Riso7381 VDD_B.t50 VDD_B.t57 139.767452979804
Riso7382 VDD_B.t50 VDD_B.t58 200798.210858579
Riso7383 VDD_B.t50 VDD_B.t59 1155.08145827159
Riso7384 VDD_B.t50 VDD_B.t6 4057.51618882136
Riso7385 VDD_B.t50 VDD_B.t60 112.237981803285
Riso7386 VDD_B.t50 VDD_B.t61 565.438212585315
Riso7387 VDD_B.t50 VDD_B.t62 839.469149870837
Riso7388 VDD_B.t50 VDD_B.t63 306.331850879008
Riso7389 VDD_B.t50 VDD_B.t64 262.378714968458
Riso7390 VDD_B.t50 VDD_B.t66 3604.60460749125
Riso7391 VDD_B.t50 VDD_B.t67 187.356634410366
Riso7392 VDD_B.t50 VDD_B.t68 179.237488911634
Riso7393 VDD_B.t50 VDD_B.t69 787.476359420122
Riso7394 VDD_B.t50 VDD_B.t70 380.886158773004
Riso7395 VDD_B.t50 VDD_B.t71 36615.0939448138
Riso7396 VDD_B.t50 VDD_B.t73 2460.36383169968
Riso7397 VDD_B.t50 VDD_B.t75 3604.60460749125
Riso7398 VDD_B.t50 VDD_B.t76 55.9981285599394
Riso7399 VDD_B.t50 VDD_B.t77 41.1772421081864
Riso7400 VDD_B.t50 VDD_B.t78 0.0669651379221535
Riso7401 VDD_B.t50 VDD_B.t79 98.4078575867183
Riso7402 VDD_B.t50 VDD_B.t8 4638.80519249675
Riso7403 VDD_B.t50 VDD_B.t80 161.300179496584
Riso7404 VDD_B.t50 VDD_B.t81 93142.2871010637
Riso7405 VDD_B.t50 VDD_B.t82 14350.1048147981
Riso7406 VDD_B.t50 VDD_B.t83 141.238566089594
Riso7407 VDD_B.t50 VDD_B.t85 5704.73119290188
Riso7408 VDD_B.t50 VDD_B.t86 40.910588145584
Riso7409 VDD_B.t50 VDD_B.t87 925.310421778704
Riso7410 VDD_B.t50 VDD_B.t88 41.1772421081864
Riso7411 VDD_B.t50 VDD_B.t89 240.737547150155
Riso7412 VDD_B.t50 VDD_B.t9 67.4747308681969
Riso7413 VDD_B.t50 VDD_B.t90 839.469149870837
Riso7414 VDD_B.t50 VDD_B.t91 342.633297850902
Riso7415 VDD_B.t50 VDD_B.t92 57.5935900397299
Riso7416 VDD_B.t50 VDD_B.t94 6069.69850162889
Riso7417 VDD_B.t50 VDD_B.t95 46.2461596296543
Riso7418 VDD_B.t50 VDD_B.t96 19260.7593215784
Riso7419 VDD_B.t50 VDD_B.t97 27648.1068807902
Riso7420 VDD_B.t50 VDD_B.t99 6069.69850162889
Riso7421 VDD_B.t51 VDD_B.t52 576.43861864076
Riso7422 VDD_B.t51 VDD_B.t53 756.280915938284
Riso7423 VDD_B.t51 VDD_B.t55 310.030467080106
Riso7424 VDD_B.t51 VDD_B.t56 280.27215774529
Riso7425 VDD_B.t51 VDD_B.t57 388.821234441287
Riso7426 VDD_B.t51 VDD_B.t58 30495.3179471376
Riso7427 VDD_B.t51 VDD_B.t59 174.23899607331
Riso7428 VDD_B.t51 VDD_B.t6 336.585540761763
Riso7429 VDD_B.t51 VDD_B.t60 1342.62467603233
Riso7430 VDD_B.t51 VDD_B.t61 83.980239271134
Riso7431 VDD_B.t51 VDD_B.t62 37.8049972619828
Riso7432 VDD_B.t51 VDD_B.t63 193.02685676173
Riso7433 VDD_B.t51 VDD_B.t64 49.3059648334659
Riso7434 VDD_B.t51 VDD_B.t66 322.10750870867
Riso7435 VDD_B.t51 VDD_B.t67 1295.11954997426
Riso7436 VDD_B.t51 VDD_B.t68 1341.84217438033
Riso7437 VDD_B.t51 VDD_B.t69 44.8704683274112
Riso7438 VDD_B.t51 VDD_B.t70 147.002291314987
Riso7439 VDD_B.t51 VDD_B.t71 4744.67851643884
Riso7440 VDD_B.t51 VDD_B.t73 358.948451297099
Riso7441 VDD_B.t51 VDD_B.t75 322.10750870867
Riso7442 VDD_B.t51 VDD_B.t76 1078.93465399877
Riso7443 VDD_B.t51 VDD_B.t77 820.693736881239
Riso7444 VDD_B.t51 VDD_B.t78 886.250024290431
Riso7445 VDD_B.t51 VDD_B.t79 1301.15007823717
Riso7446 VDD_B.t51 VDD_B.t8 518.872992482942
Riso7447 VDD_B.t51 VDD_B.t80 350.515138833889
Riso7448 VDD_B.t51 VDD_B.t81 12069.6183176936
Riso7449 VDD_B.t51 VDD_B.t82 1859.52367419946
Riso7450 VDD_B.t51 VDD_B.t83 1387.99479647581
Riso7451 VDD_B.t51 VDD_B.t85 506.151998271241
Riso7452 VDD_B.t51 VDD_B.t86 951.985589242418
Riso7453 VDD_B.t51 VDD_B.t87 36.2974257318178
Riso7454 VDD_B.t51 VDD_B.t88 820.693736881239
Riso7455 VDD_B.t51 VDD_B.t89 248.714445032871
Riso7456 VDD_B.t51 VDD_B.t9 633.678702739493
Riso7457 VDD_B.t51 VDD_B.t90 37.8049972619828
Riso7458 VDD_B.t51 VDD_B.t91 168.843613905278
Riso7459 VDD_B.t51 VDD_B.t92 693.757510749727
Riso7460 VDD_B.t51 VDD_B.t94 423.851913481244
Riso7461 VDD_B.t51 VDD_B.t95 267.280661297341
Riso7462 VDD_B.t51 VDD_B.t96 2495.85897829811
Riso7463 VDD_B.t51 VDD_B.t97 3582.71315472266
Riso7464 VDD_B.t51 VDD_B.t99 423.851913481244
Riso7465 VDD_B.t52 VDD_B.t53 56.9633774977882
Riso7466 VDD_B.t52 VDD_B.t55 3927.93661949008
Riso7467 VDD_B.t52 VDD_B.t56 105.196956340579
Riso7468 VDD_B.t52 VDD_B.t57 65.0420364872093
Riso7469 VDD_B.t52 VDD_B.t58 152616.794902004
Riso7470 VDD_B.t52 VDD_B.t59 877.703211094709
Riso7471 VDD_B.t52 VDD_B.t6 2912.87855427483
Riso7472 VDD_B.t52 VDD_B.t60 216.417010761325
Riso7473 VDD_B.t52 VDD_B.t61 333.47333641704
Riso7474 VDD_B.t52 VDD_B.t62 537.850227445891
Riso7475 VDD_B.t52 VDD_B.t63 162.190745762159
Riso7476 VDD_B.t52 VDD_B.t64 151.949919307285
Riso7477 VDD_B.t52 VDD_B.t66 2639.04308314558
Riso7478 VDD_B.t52 VDD_B.t67 320.141519509919
Riso7479 VDD_B.t52 VDD_B.t68 311.27816115513
Riso7480 VDD_B.t52 VDD_B.t69 496.746267963036
Riso7481 VDD_B.t52 VDD_B.t70 209.517441736027
Riso7482 VDD_B.t52 VDD_B.t71 31802.4599050463
Riso7483 VDD_B.t52 VDD_B.t73 1867.12862299107
Riso7484 VDD_B.t52 VDD_B.t75 2639.04308314558
Riso7485 VDD_B.t52 VDD_B.t76 119.995852336775
Riso7486 VDD_B.t52 VDD_B.t77 67.0524790042405
Riso7487 VDD_B.t52 VDD_B.t78 78.4447259643222
Riso7488 VDD_B.t52 VDD_B.t79 194.166673421351
Riso7489 VDD_B.t52 VDD_B.t8 3478.74662995015
Riso7490 VDD_B.t52 VDD_B.t80 76.7119107723172
Riso7491 VDD_B.t52 VDD_B.t81 80899.8020177262
Riso7492 VDD_B.t52 VDD_B.t82 12463.9481655753
Riso7493 VDD_B.t52 VDD_B.t83 260.355326150309
Riso7494 VDD_B.t52 VDD_B.t85 4222.40273335279
Riso7495 VDD_B.t52 VDD_B.t86 91.1373571735049
Riso7496 VDD_B.t52 VDD_B.t87 610.630452785079
Riso7497 VDD_B.t52 VDD_B.t88 67.0524790042405
Riso7498 VDD_B.t52 VDD_B.t89 122.236935638833
Riso7499 VDD_B.t52 VDD_B.t9 40.4635901850547
Riso7500 VDD_B.t52 VDD_B.t90 537.850227445891
Riso7501 VDD_B.t52 VDD_B.t91 185.019291688917
Riso7502 VDD_B.t52 VDD_B.t92 48.1278836535006
Riso7503 VDD_B.t52 VDD_B.t94 4417.27557575547
Riso7504 VDD_B.t52 VDD_B.t95 20.3038205507568
Riso7505 VDD_B.t52 VDD_B.t96 16729.1534739324
Riso7506 VDD_B.t52 VDD_B.t97 24014.0804186385
Riso7507 VDD_B.t52 VDD_B.t99 4417.27557575547
Riso7508 VDD_B.t53 VDD_B.t55 4887.60783314019
Riso7509 VDD_B.t53 VDD_B.t56 162.868371593627
Riso7510 VDD_B.t53 VDD_B.t57 104.719655127377
Riso7511 VDD_B.t53 VDD_B.t58 181671.661998326
Riso7512 VDD_B.t53 VDD_B.t59 1044.97770516464
Riso7513 VDD_B.t53 VDD_B.t6 3612.74254819908
Riso7514 VDD_B.t53 VDD_B.t60 148.47272685887
Riso7515 VDD_B.t53 VDD_B.t61 464.5865169346
Riso7516 VDD_B.t53 VDD_B.t62 712.071722925605
Riso7517 VDD_B.t53 VDD_B.t63 241.569088670328
Riso7518 VDD_B.t53 VDD_B.t64 214.103763192313
Riso7519 VDD_B.t53 VDD_B.t66 3239.97849025458
Riso7520 VDD_B.t53 VDD_B.t67 235.161528588896
Riso7521 VDD_B.t53 VDD_B.t68 226.594590021552
Riso7522 VDD_B.t53 VDD_B.t69 663.897246192005
Riso7523 VDD_B.t53 VDD_B.t70 304.788213404466
Riso7524 VDD_B.t53 VDD_B.t71 35502.7372115703
Riso7525 VDD_B.t53 VDD_B.t73 2224.96530765422
Riso7526 VDD_B.t53 VDD_B.t75 3239.97849025458
Riso7527 VDD_B.t53 VDD_B.t76 77.3711031012669
Riso7528 VDD_B.t53 VDD_B.t77 41.2746361723095
Riso7529 VDD_B.t53 VDD_B.t78 48.8371511613795
Riso7530 VDD_B.t53 VDD_B.t79 131.445007397423
Riso7531 VDD_B.t53 VDD_B.t8 4179.77469338731
Riso7532 VDD_B.t53 VDD_B.t80 121.926977238574
Riso7533 VDD_B.t53 VDD_B.t81 90312.649401302
Riso7534 VDD_B.t53 VDD_B.t82 13914.1524794703
Riso7535 VDD_B.t53 VDD_B.t83 183.274104258269
Riso7536 VDD_B.t53 VDD_B.t85 5119.4859963894
Riso7537 VDD_B.t53 VDD_B.t86 57.4034092010417
Riso7538 VDD_B.t53 VDD_B.t87 794.26544619251
Riso7539 VDD_B.t53 VDD_B.t88 41.2746361723095
Riso7540 VDD_B.t53 VDD_B.t89 186.780690835071
Riso7541 VDD_B.t53 VDD_B.t9 48.6363324302585
Riso7542 VDD_B.t53 VDD_B.t90 712.071722925605
Riso7543 VDD_B.t53 VDD_B.t91 272.246827493601
Riso7544 VDD_B.t53 VDD_B.t92 41.2053257384006
Riso7545 VDD_B.t53 VDD_B.t94 5418.41009254307
Riso7546 VDD_B.t53 VDD_B.t95 33.8208261170467
Riso7547 VDD_B.t53 VDD_B.t96 18675.6226194569
Riso7548 VDD_B.t53 VDD_B.t97 26808.1648094511
Riso7549 VDD_B.t53 VDD_B.t99 5418.41009254307
Riso7550 VDD_B.t55 VDD_B.t56 2132.07741398524
Riso7551 VDD_B.t55 VDD_B.t57 2820.21569597943
Riso7552 VDD_B.t55 VDD_B.t58 43898.7437538545
Riso7553 VDD_B.t55 VDD_B.t59 233.374529747708
Riso7554 VDD_B.t55 VDD_B.t6 215.874985774212
Riso7555 VDD_B.t55 VDD_B.t60 6862.33970362313
Riso7556 VDD_B.t55 VDD_B.t61 745.628923911632
Riso7557 VDD_B.t55 VDD_B.t62 364.101012482955
Riso7558 VDD_B.t55 VDD_B.t63 1546.62429810543
Riso7559 VDD_B.t55 VDD_B.t64 431.086409225212
Riso7560 VDD_B.t55 VDD_B.t66 403.511860550076
Riso7561 VDD_B.t55 VDD_B.t67 5614.86453860527
Riso7562 VDD_B.t55 VDD_B.t68 5962.0042154897
Riso7563 VDD_B.t55 VDD_B.t69 425.379040728978
Riso7564 VDD_B.t55 VDD_B.t70 1221.18880426444
Riso7565 VDD_B.t55 VDD_B.t71 5725.95684093787
Riso7566 VDD_B.t55 VDD_B.t73 353.870298318363
Riso7567 VDD_B.t55 VDD_B.t75 403.511860550076
Riso7568 VDD_B.t55 VDD_B.t76 6285.95539472171
Riso7569 VDD_B.t55 VDD_B.t77 5204.51825645559
Riso7570 VDD_B.t55 VDD_B.t78 5510.34212473785
Riso7571 VDD_B.t55 VDD_B.t79 6840.86153357507
Riso7572 VDD_B.t55 VDD_B.t8 181.745860055113
Riso7573 VDD_B.t55 VDD_B.t80 2581.58241131643
Riso7574 VDD_B.t55 VDD_B.t81 14565.8158575468
Riso7575 VDD_B.t55 VDD_B.t82 2244.10405600249
Riso7576 VDD_B.t55 VDD_B.t83 6697.05282592639
Riso7577 VDD_B.t55 VDD_B.t85 123.280317449893
Riso7578 VDD_B.t55 VDD_B.t86 5797.90152692882
Riso7579 VDD_B.t55 VDD_B.t87 262.708103286429
Riso7580 VDD_B.t55 VDD_B.t88 5204.51825645559
Riso7581 VDD_B.t55 VDD_B.t89 1924.27406503396
Riso7582 VDD_B.t55 VDD_B.t9 4244.53906980745
Riso7583 VDD_B.t55 VDD_B.t90 364.101012482955
Riso7584 VDD_B.t55 VDD_B.t91 1377.37747272439
Riso7585 VDD_B.t55 VDD_B.t92 4565.86054433696
Riso7586 VDD_B.t55 VDD_B.t94 82.663923723346
Riso7587 VDD_B.t55 VDD_B.t95 1852.20993968716
Riso7588 VDD_B.t55 VDD_B.t96 3012.0440702753
Riso7589 VDD_B.t55 VDD_B.t97 4323.67774261755
Riso7590 VDD_B.t55 VDD_B.t99 82.663923723346
Riso7591 VDD_B.t56 VDD_B.t57 57.3081010506099
Riso7592 VDD_B.t56 VDD_B.t58 97027.5695097284
Riso7593 VDD_B.t56 VDD_B.t59 557.623336739093
Riso7594 VDD_B.t56 VDD_B.t6 1623.08256251083
Riso7595 VDD_B.t56 VDD_B.t60 471.074235523445
Riso7596 VDD_B.t56 VDD_B.t61 139.454109786367
Riso7597 VDD_B.t56 VDD_B.t62 255.716093645484
Riso7598 VDD_B.t56 VDD_B.t63 58.1688930301409
Riso7599 VDD_B.t56 VDD_B.t64 61.8084507520292
Riso7600 VDD_B.t56 VDD_B.t66 1490.31456468833
Riso7601 VDD_B.t56 VDD_B.t67 612.060808773836
Riso7602 VDD_B.t56 VDD_B.t68 605.26808998638
Riso7603 VDD_B.t56 VDD_B.t69 230.629949709841
Riso7604 VDD_B.t56 VDD_B.t70 79.1267619347386
Riso7605 VDD_B.t56 VDD_B.t71 20579.36768301
Riso7606 VDD_B.t56 VDD_B.t73 1182.00625743825
Riso7607 VDD_B.t56 VDD_B.t75 1490.31456468833
Riso7608 VDD_B.t56 VDD_B.t76 297.865452168809
Riso7609 VDD_B.t56 VDD_B.t77 186.278348880019
Riso7610 VDD_B.t56 VDD_B.t78 211.71789279396
Riso7611 VDD_B.t56 VDD_B.t79 434.071186710436
Riso7612 VDD_B.t56 VDD_B.t8 2132.85209255722
Riso7613 VDD_B.t56 VDD_B.t80 48.9282161536782
Riso7614 VDD_B.t56 VDD_B.t81 52350.2514011921
Riso7615 VDD_B.t56 VDD_B.t82 8065.41924263702
Riso7616 VDD_B.t56 VDD_B.t83 539.13577302137
Riso7617 VDD_B.t56 VDD_B.t85 2502.83042855636
Riso7618 VDD_B.t56 VDD_B.t86 239.017022991723
Riso7619 VDD_B.t56 VDD_B.t87 303.13959386059
Riso7620 VDD_B.t56 VDD_B.t88 186.278348880019
Riso7621 VDD_B.t56 VDD_B.t89 41.5860517205105
Riso7622 VDD_B.t56 VDD_B.t9 122.355721588228
Riso7623 VDD_B.t56 VDD_B.t90 255.716093645484
Riso7624 VDD_B.t56 VDD_B.t91 68.1202504788932
Riso7625 VDD_B.t56 VDD_B.t92 141.561062639702
Riso7626 VDD_B.t56 VDD_B.t94 2512.40588943168
Riso7627 VDD_B.t56 VDD_B.t95 46.05144591768
Riso7628 VDD_B.t56 VDD_B.t96 10825.4330449114
Riso7629 VDD_B.t56 VDD_B.t97 15539.5083267165
Riso7630 VDD_B.t56 VDD_B.t99 2512.40588943168
Riso7631 VDD_B.t57 VDD_B.t58 118505.143766734
Riso7632 VDD_B.t57 VDD_B.t59 681.305120325379
Riso7633 VDD_B.t57 VDD_B.t6 2109.07322322493
Riso7634 VDD_B.t57 VDD_B.t60 341.260689685434
Riso7635 VDD_B.t57 VDD_B.t61 207.351631817083
Riso7636 VDD_B.t57 VDD_B.t62 358.451346833996
Riso7637 VDD_B.t57 VDD_B.t63 92.5097092801871
Riso7638 VDD_B.t57 VDD_B.t64 93.05361734914
Riso7639 VDD_B.t57 VDD_B.t66 1927.20330461878
Riso7640 VDD_B.t57 VDD_B.t67 467.825231444376
Riso7641 VDD_B.t57 VDD_B.t68 459.386310049506
Riso7642 VDD_B.t57 VDD_B.t69 326.863238510299
Riso7643 VDD_B.t57 VDD_B.t70 123.084447404108
Riso7644 VDD_B.t57 VDD_B.t71 25417.6933158106
Riso7645 VDD_B.t57 VDD_B.t73 1446.88762081331
Riso7646 VDD_B.t57 VDD_B.t75 1927.20330461878
Riso7647 VDD_B.t57 VDD_B.t76 204.066265477054
Riso7648 VDD_B.t57 VDD_B.t77 121.36883749847
Riso7649 VDD_B.t57 VDD_B.t78 139.767452979804
Riso7650 VDD_B.t57 VDD_B.t79 310.975042715586
Riso7651 VDD_B.t57 VDD_B.t8 2654.79584131428
Riso7652 VDD_B.t57 VDD_B.t80 40.5835127895311
Riso7653 VDD_B.t57 VDD_B.t81 64658.091328026
Riso7654 VDD_B.t57 VDD_B.t82 9961.64488290054
Riso7655 VDD_B.t57 VDD_B.t83 398.708258118159
Riso7656 VDD_B.t57 VDD_B.t85 3169.80427257127
Riso7657 VDD_B.t57 VDD_B.t86 159.832418010433
Riso7658 VDD_B.t57 VDD_B.t87 416.533006028838
Riso7659 VDD_B.t57 VDD_B.t88 121.36883749847
Riso7660 VDD_B.t57 VDD_B.t89 67.6116675155874
Riso7661 VDD_B.t57 VDD_B.t9 76.6283258798225
Riso7662 VDD_B.t57 VDD_B.t90 358.451346833996
Riso7663 VDD_B.t57 VDD_B.t91 107.131630596703
Riso7664 VDD_B.t57 VDD_B.t92 89.8237517697841
Riso7665 VDD_B.t57 VDD_B.t94 3248.87048401795
Riso7666 VDD_B.t57 VDD_B.t95 28.119594706761
Riso7667 VDD_B.t57 VDD_B.t96 13370.5535264607
Riso7668 VDD_B.t57 VDD_B.t97 19192.93454546
Riso7669 VDD_B.t57 VDD_B.t99 3248.87048401795
Riso7670 VDD_B.t58 VDD_B.t59 2022.86202371983
Riso7671 VDD_B.t58 VDD_B.t6 87898.474316144
Riso7672 VDD_B.t58 VDD_B.t60 250085.361290453
Riso7673 VDD_B.t58 VDD_B.t61 49738.1265796545
Riso7674 VDD_B.t58 VDD_B.t62 33270.9741880175
Riso7675 VDD_B.t58 VDD_B.t63 78254.5897181212
Riso7676 VDD_B.t58 VDD_B.t64 27400.0824143038
Riso7677 VDD_B.t58 VDD_B.t66 92994.7462948276
Riso7678 VDD_B.t58 VDD_B.t67 219811.155451191
Riso7679 VDD_B.t58 VDD_B.t68 230038.946592346
Riso7680 VDD_B.t58 VDD_B.t69 36215.9105342638
Riso7681 VDD_B.t58 VDD_B.t70 67336.6937861202
Riso7682 VDD_B.t58 VDD_B.t71 445558.198889795
Riso7683 VDD_B.t58 VDD_B.t73 5362.04209336701
Riso7684 VDD_B.t58 VDD_B.t75 92994.7462948276
Riso7685 VDD_B.t58 VDD_B.t76 225840.921388403
Riso7686 VDD_B.t58 VDD_B.t77 191352.276394743
Riso7687 VDD_B.t58 VDD_B.t78 200798.210858579
Riso7688 VDD_B.t58 VDD_B.t79 247730.60391005
Riso7689 VDD_B.t58 VDD_B.t8 11933.8904869867
Riso7690 VDD_B.t58 VDD_B.t80 111079.976428749
Riso7691 VDD_B.t58 VDD_B.t81 1133420.8166658
Riso7692 VDD_B.t58 VDD_B.t82 174622.161690968
Riso7693 VDD_B.t58 VDD_B.t83 248609.786141785
Riso7694 VDD_B.t58 VDD_B.t85 17609.3689352921
Riso7695 VDD_B.t58 VDD_B.t86 209832.230160195
Riso7696 VDD_B.t58 VDD_B.t87 27883.9198585425
Riso7697 VDD_B.t58 VDD_B.t88 191352.276394743
Riso7698 VDD_B.t58 VDD_B.t89 90450.9355962875
Riso7699 VDD_B.t58 VDD_B.t9 162189.066091354
Riso7700 VDD_B.t58 VDD_B.t90 33270.9741880175
Riso7701 VDD_B.t58 VDD_B.t91 72637.9697302635
Riso7702 VDD_B.t58 VDD_B.t92 171908.328659705
Riso7703 VDD_B.t58 VDD_B.t94 25370.8549985757
Riso7704 VDD_B.t58 VDD_B.t95 73318.1241957191
Riso7705 VDD_B.t58 VDD_B.t96 234378.457297058
Riso7706 VDD_B.t58 VDD_B.t97 336441.597639607
Riso7707 VDD_B.t58 VDD_B.t99 25370.8549985757
Riso7708 VDD_B.t59 VDD_B.t6 499.100708681504
Riso7709 VDD_B.t59 VDD_B.t60 1438.66353309968
Riso7710 VDD_B.t59 VDD_B.t61 285.190568207631
Riso7711 VDD_B.t59 VDD_B.t62 190.24693114704
Riso7712 VDD_B.t59 VDD_B.t63 449.489646939332
Riso7713 VDD_B.t59 VDD_B.t64 157.162205201161
Riso7714 VDD_B.t59 VDD_B.t66 530.260291996252
Riso7715 VDD_B.t59 VDD_B.t67 1264.25774154746
Riso7716 VDD_B.t59 VDD_B.t68 1323.13936480607
Riso7717 VDD_B.t59 VDD_B.t69 207.231021136054
Riso7718 VDD_B.t59 VDD_B.t70 386.587729486926
Riso7719 VDD_B.t59 VDD_B.t71 2552.87496651521
Riso7720 VDD_B.t59 VDD_B.t73 24.8024632669895
Riso7721 VDD_B.t59 VDD_B.t75 530.260291996252
Riso7722 VDD_B.t59 VDD_B.t76 1299.21658398545
Riso7723 VDD_B.t59 VDD_B.t77 1100.70647422056
Riso7724 VDD_B.t59 VDD_B.t78 1155.08145827159
Riso7725 VDD_B.t59 VDD_B.t79 1425.13764711225
Riso7726 VDD_B.t59 VDD_B.t8 56.0435161016815
Riso7727 VDD_B.t59 VDD_B.t80 638.549732830836
Riso7728 VDD_B.t59 VDD_B.t81 6494.05989296819
Riso7729 VDD_B.t59 VDD_B.t82 1000.51698361835
Riso7730 VDD_B.t59 VDD_B.t83 1430.10821414723
Riso7731 VDD_B.t59 VDD_B.t85 83.5785513738191
Riso7732 VDD_B.t59 VDD_B.t86 1207.08194325826
Riso7733 VDD_B.t59 VDD_B.t87 159.179396888598
Riso7734 VDD_B.t59 VDD_B.t88 1100.70647422056
Riso7735 VDD_B.t59 VDD_B.t89 519.744517430427
Riso7736 VDD_B.t59 VDD_B.t9 932.814587160631
Riso7737 VDD_B.t59 VDD_B.t90 190.24693114704
Riso7738 VDD_B.t59 VDD_B.t91 417.131772523135
Riso7739 VDD_B.t59 VDD_B.t92 988.770335029649
Riso7740 VDD_B.t59 VDD_B.t94 123.210424739454
Riso7741 VDD_B.t59 VDD_B.t95 421.623090017679
Riso7742 VDD_B.t59 VDD_B.t96 1342.89728662833
Riso7743 VDD_B.t59 VDD_B.t97 1927.67933448122
Riso7744 VDD_B.t59 VDD_B.t99 123.210424739454
Riso7745 VDD_B.t6 VDD_B.t60 4752.73779026102
Riso7746 VDD_B.t6 VDD_B.t61 661.326016101953
Riso7747 VDD_B.t6 VDD_B.t62 379.955159424618
Riso7748 VDD_B.t6 VDD_B.t63 1218.31751522826
Riso7749 VDD_B.t6 VDD_B.t64 373.776725603589
Riso7750 VDD_B.t6 VDD_B.t66 80.2998669021003
Riso7751 VDD_B.t6 VDD_B.t67 3550.69587617647
Riso7752 VDD_B.t6 VDD_B.t68 3829.41585898366
Riso7753 VDD_B.t6 VDD_B.t69 427.477744596284
Riso7754 VDD_B.t6 VDD_B.t70 994.942310609999
Riso7755 VDD_B.t6 VDD_B.t71 3773.52832263967
Riso7756 VDD_B.t6 VDD_B.t73 934.448435905108
Riso7757 VDD_B.t6 VDD_B.t75 80.2998669021003
Riso7758 VDD_B.t6 VDD_B.t76 4567.8685499347
Riso7759 VDD_B.t6 VDD_B.t77 3840.95993824727
Riso7760 VDD_B.t6 VDD_B.t78 4057.51618882136
Riso7761 VDD_B.t6 VDD_B.t79 4796.09214619394
Riso7762 VDD_B.t6 VDD_B.t8 829.099684498729
Riso7763 VDD_B.t6 VDD_B.t80 1939.06084880104
Riso7764 VDD_B.t6 VDD_B.t81 9599.18494108035
Riso7765 VDD_B.t6 VDD_B.t82 1478.91268647581
Riso7766 VDD_B.t6 VDD_B.t83 4509.14082502388
Riso7767 VDD_B.t6 VDD_B.t85 640.631791416729
Riso7768 VDD_B.t6 VDD_B.t86 4255.68791110627
Riso7769 VDD_B.t6 VDD_B.t87 297.167847432962
Riso7770 VDD_B.t6 VDD_B.t88 3840.95993824727
Riso7771 VDD_B.t6 VDD_B.t89 1478.68071966304
Riso7772 VDD_B.t6 VDD_B.t9 3144.16548350801
Riso7773 VDD_B.t6 VDD_B.t90 379.955159424618
Riso7774 VDD_B.t6 VDD_B.t91 1102.15039058509
Riso7775 VDD_B.t6 VDD_B.t92 3378.80555528526
Riso7776 VDD_B.t6 VDD_B.t94 458.586147308415
Riso7777 VDD_B.t6 VDD_B.t95 1375.59560703552
Riso7778 VDD_B.t6 VDD_B.t96 1985.00162050839
Riso7779 VDD_B.t6 VDD_B.t97 2849.3963319957
Riso7780 VDD_B.t6 VDD_B.t99 458.586147308415
Riso7781 VDD_B.t60 VDD_B.t61 1005.29345326171
Riso7782 VDD_B.t60 VDD_B.t62 1308.65358916245
Riso7783 VDD_B.t60 VDD_B.t63 627.547473797455
Riso7784 VDD_B.t60 VDD_B.t64 478.169142887386
Riso7785 VDD_B.t60 VDD_B.t66 3981.64794142567
Riso7786 VDD_B.t60 VDD_B.t67 66.8999607684956
Riso7787 VDD_B.t60 VDD_B.t68 61.9506250589044
Riso7788 VDD_B.t60 VDD_B.t69 1262.23032054234
Riso7789 VDD_B.t60 VDD_B.t70 743.245942885437
Riso7790 VDD_B.t60 VDD_B.t71 29177.4200932182
Riso7791 VDD_B.t60 VDD_B.t73 3064.70123292227
Riso7792 VDD_B.t60 VDD_B.t75 3981.64794142567
Riso7793 VDD_B.t60 VDD_B.t76 71.0455665511807
Riso7794 VDD_B.t60 VDD_B.t77 129.433013647641
Riso7795 VDD_B.t60 VDD_B.t78 112.237981803285
Riso7796 VDD_B.t60 VDD_B.t79 38.000455444543
Riso7797 VDD_B.t60 VDD_B.t8 5783.40209967898
Riso7798 VDD_B.t60 VDD_B.t80 381.440886084003
Riso7799 VDD_B.t60 VDD_B.t81 74222.1675926029
Riso7800 VDD_B.t60 VDD_B.t82 11435.1484989808
Riso7801 VDD_B.t60 VDD_B.t83 43.7541385327606
Riso7802 VDD_B.t60 VDD_B.t85 7119.45673052605
Riso7803 VDD_B.t60 VDD_B.t86 96.8344202230685
Riso7804 VDD_B.t60 VDD_B.t87 1361.49624109379
Riso7805 VDD_B.t60 VDD_B.t88 129.433013647641
Riso7806 VDD_B.t60 VDD_B.t89 520.453534288652
Riso7807 VDD_B.t60 VDD_B.t9 192.060293434033
Riso7808 VDD_B.t60 VDD_B.t90 1308.65358916245
Riso7809 VDD_B.t60 VDD_B.t91 684.591880602263
Riso7810 VDD_B.t60 VDD_B.t92 169.366146229877
Riso7811 VDD_B.t60 VDD_B.t94 7584.86512023775
Riso7812 VDD_B.t60 VDD_B.t95 123.934730405559
Riso7813 VDD_B.t60 VDD_B.t96 15348.2950743504
Riso7814 VDD_B.t60 VDD_B.t97 22031.909312014
Riso7815 VDD_B.t60 VDD_B.t99 7584.86512023775
Riso7816 VDD_B.t61 VDD_B.t62 73.8945834462551
Riso7817 VDD_B.t61 VDD_B.t63 88.8935313299817
Riso7818 VDD_B.t61 VDD_B.t64 20.0602825025868
Riso7819 VDD_B.t61 VDD_B.t66 618.274290665295
Riso7820 VDD_B.t61 VDD_B.t67 1122.00063371797
Riso7821 VDD_B.t61 VDD_B.t68 1135.25452657619
Riso7822 VDD_B.t61 VDD_B.t69 64.2037083534986
Riso7823 VDD_B.t61 VDD_B.t70 64.2216494213787
Riso7824 VDD_B.t61 VDD_B.t71 9113.44628184339
Riso7825 VDD_B.t61 VDD_B.t73 597.62008537286
Riso7826 VDD_B.t61 VDD_B.t75 618.274290665295
Riso7827 VDD_B.t61 VDD_B.t76 727.875881690861
Riso7828 VDD_B.t61 VDD_B.t77 513.864907268585
Riso7829 VDD_B.t61 VDD_B.t78 565.438212585315
Riso7830 VDD_B.t61 VDD_B.t79 952.193033498697
Riso7831 VDD_B.t61 VDD_B.t8 979.610675941647
Riso7832 VDD_B.t61 VDD_B.t80 182.904658816646
Riso7833 VDD_B.t61 VDD_B.t81 23182.9865394572
Riso7834 VDD_B.t61 VDD_B.t82 3571.72125696563
Riso7835 VDD_B.t61 VDD_B.t83 1090.42913724808
Riso7836 VDD_B.t61 VDD_B.t85 1051.29795958366
Riso7837 VDD_B.t61 VDD_B.t86 618.79687499204
Riso7838 VDD_B.t61 VDD_B.t87 94.0062714363984
Riso7839 VDD_B.t61 VDD_B.t88 513.864907268585
Riso7840 VDD_B.t61 VDD_B.t89 120.666385408099
Riso7841 VDD_B.t61 VDD_B.t9 374.210447745653
Riso7842 VDD_B.t61 VDD_B.t90 73.8945834462551
Riso7843 VDD_B.t61 VDD_B.t91 75.7311391634842
Riso7844 VDD_B.t61 VDD_B.t92 417.95833367095
Riso7845 VDD_B.t61 VDD_B.t94 958.797192176575
Riso7846 VDD_B.t61 VDD_B.t95 151.371948492542
Riso7847 VDD_B.t61 VDD_B.t96 4793.97637731806
Riso7848 VDD_B.t61 VDD_B.t97 6881.57559372957
Riso7849 VDD_B.t61 VDD_B.t99 958.797192176575
Riso7850 VDD_B.t62 VDD_B.t63 174.011932998834
Riso7851 VDD_B.t62 VDD_B.t64 43.5417723368949
Riso7852 VDD_B.t62 VDD_B.t66 361.828976666159
Riso7853 VDD_B.t62 VDD_B.t67 1297.10331324526
Riso7854 VDD_B.t62 VDD_B.t68 1338.05430346699
Riso7855 VDD_B.t62 VDD_B.t69 38.8784573734981
Riso7856 VDD_B.t62 VDD_B.t70 131.393669676639
Riso7857 VDD_B.t62 VDD_B.t71 5342.58619031971
Riso7858 VDD_B.t62 VDD_B.t73 393.393450276987
Riso7859 VDD_B.t62 VDD_B.t75 361.828976666159
Riso7860 VDD_B.t62 VDD_B.t76 1031.71610663939
Riso7861 VDD_B.t62 VDD_B.t77 775.031219689428
Riso7862 VDD_B.t62 VDD_B.t78 839.469149870837
Riso7863 VDD_B.t62 VDD_B.t79 1262.8386679426
Riso7864 VDD_B.t62 VDD_B.t8 583.678004662029
Riso7865 VDD_B.t62 VDD_B.t80 322.09686258248
Riso7866 VDD_B.t62 VDD_B.t81 13590.5891037982
Riso7867 VDD_B.t62 VDD_B.t82 2093.85429759467
Riso7868 VDD_B.t62 VDD_B.t83 1365.10596445548
Riso7869 VDD_B.t62 VDD_B.t85 579.769743714541
Riso7870 VDD_B.t62 VDD_B.t86 904.51052747062
Riso7871 VDD_B.t62 VDD_B.t87 43.1256938546101
Riso7872 VDD_B.t62 VDD_B.t88 775.031219689428
Riso7873 VDD_B.t62 VDD_B.t89 226.049442604235
Riso7874 VDD_B.t62 VDD_B.t9 593.070328988428
Riso7875 VDD_B.t62 VDD_B.t90 0.0669575420742649
Riso7876 VDD_B.t62 VDD_B.t91 151.567174872951
Riso7877 VDD_B.t62 VDD_B.t92 651.256195069261
Riso7878 VDD_B.t62 VDD_B.t94 492.854328892185
Riso7879 VDD_B.t62 VDD_B.t95 248.608109923728
Riso7880 VDD_B.t62 VDD_B.t96 2810.37833527426
Riso7881 VDD_B.t62 VDD_B.t97 4034.19404665259
Riso7882 VDD_B.t62 VDD_B.t99 492.854328892185
Riso7883 VDD_B.t63 VDD_B.t64 38.8882440172144
Riso7884 VDD_B.t63 VDD_B.t66 1124.23942973812
Riso7885 VDD_B.t63 VDD_B.t67 776.473830232273
Riso7886 VDD_B.t63 VDD_B.t68 773.100248946967
Riso7887 VDD_B.t63 VDD_B.t69 154.974774007329
Riso7888 VDD_B.t63 VDD_B.t70 48.1728345616373
Riso7889 VDD_B.t63 VDD_B.t71 16032.6299908759
Riso7890 VDD_B.t63 VDD_B.t73 950.175454502726
Riso7891 VDD_B.t63 VDD_B.t75 1124.23942973812
Riso7892 VDD_B.t63 VDD_B.t76 416.763816278014
Riso7893 VDD_B.t63 VDD_B.t77 272.839985497828
Riso7894 VDD_B.t63 VDD_B.t78 306.331850879008
Riso7895 VDD_B.t63 VDD_B.t79 583.898712656351
Riso7896 VDD_B.t63 VDD_B.t8 1673.9372431538
Riso7897 VDD_B.t63 VDD_B.t80 79.8446121707502
Riso7898 VDD_B.t63 VDD_B.t81 40784.1593372942
Riso7899 VDD_B.t63 VDD_B.t82 6283.47208866119
Riso7900 VDD_B.t63 VDD_B.t83 705.248105349679
Riso7901 VDD_B.t63 VDD_B.t85 1917.9739088099
Riso7902 VDD_B.t63 VDD_B.t86 341.78018350013
Riso7903 VDD_B.t63 VDD_B.t87 211.124795053716
Riso7904 VDD_B.t63 VDD_B.t88 272.839985497828
Riso7905 VDD_B.t63 VDD_B.t89 49.1949353744108
Riso7906 VDD_B.t63 VDD_B.t9 186.213572902435
Riso7907 VDD_B.t63 VDD_B.t90 174.011932998834
Riso7908 VDD_B.t63 VDD_B.t91 41.0331913276019
Riso7909 VDD_B.t63 VDD_B.t92 212.671981891566
Riso7910 VDD_B.t63 VDD_B.t94 1873.26072252893
Riso7911 VDD_B.t63 VDD_B.t95 71.9241477592766
Riso7912 VDD_B.t63 VDD_B.t96 8433.69753500028
Riso7913 VDD_B.t63 VDD_B.t97 12106.260555715
Riso7914 VDD_B.t63 VDD_B.t99 1873.26072252893
Riso7915 VDD_B.t64 VDD_B.t66 348.593989994787
Riso7916 VDD_B.t64 VDD_B.t67 544.331831628513
Riso7917 VDD_B.t64 VDD_B.t68 549.0144279268
Riso7918 VDD_B.t64 VDD_B.t69 37.9688211171305
Riso7919 VDD_B.t64 VDD_B.t70 27.8616748686167
Riso7920 VDD_B.t64 VDD_B.t71 5122.59108156651
Riso7921 VDD_B.t64 VDD_B.t73 329.897192619806
Riso7922 VDD_B.t64 VDD_B.t75 348.593989994787
Riso7923 VDD_B.t64 VDD_B.t76 340.932999014875
Riso7924 VDD_B.t64 VDD_B.t77 237.644780643534
Riso7925 VDD_B.t64 VDD_B.t78 262.378714968458
Riso7926 VDD_B.t64 VDD_B.t79 451.444358690894
Riso7927 VDD_B.t64 VDD_B.t8 548.177502812587
Riso7928 VDD_B.t64 VDD_B.t80 81.7572110961627
Riso7929 VDD_B.t64 VDD_B.t81 13030.9606726599
Riso7930 VDD_B.t64 VDD_B.t82 2007.63431208516
Riso7931 VDD_B.t64 VDD_B.t83 522.106957242127
Riso7932 VDD_B.t64 VDD_B.t85 595.211341186378
Riso7933 VDD_B.t64 VDD_B.t86 288.07150969814
Riso7934 VDD_B.t64 VDD_B.t87 54.9986716946682
Riso7935 VDD_B.t64 VDD_B.t88 237.644780643534
Riso7936 VDD_B.t64 VDD_B.t89 53.2484682365991
Riso7937 VDD_B.t64 VDD_B.t9 171.180062558322
Riso7938 VDD_B.t64 VDD_B.t90 43.5417723368949
Riso7939 VDD_B.t64 VDD_B.t91 32.990189722719
Riso7940 VDD_B.t64 VDD_B.t92 191.915525696733
Riso7941 VDD_B.t64 VDD_B.t94 549.161500343343
Riso7942 VDD_B.t64 VDD_B.t95 68.69605042716
Riso7943 VDD_B.t64 VDD_B.t96 2694.6535784839
Riso7944 VDD_B.t64 VDD_B.t97 3868.07544296344
Riso7945 VDD_B.t64 VDD_B.t99 549.161500343343
Riso7946 VDD_B.t65 VDD_B.t74 158.648
Riso7947 VDD_B.t66 VDD_B.t67 2844.04103398603
Riso7948 VDD_B.t66 VDD_B.t68 3086.33192714286
Riso7949 VDD_B.t66 VDD_B.t69 405.254176411202
Riso7950 VDD_B.t66 VDD_B.t70 921.691392777901
Riso7951 VDD_B.t66 VDD_B.t71 3117.33697358239
Riso7952 VDD_B.t66 VDD_B.t73 1048.68990135543
Riso7953 VDD_B.t66 VDD_B.t75 0.826718515773902
Riso7954 VDD_B.t66 VDD_B.t76 3982.61478290965
Riso7955 VDD_B.t66 VDD_B.t77 3429.4204525504
Riso7956 VDD_B.t66 VDD_B.t78 3604.60460749125
Riso7957 VDD_B.t66 VDD_B.t79 4051.84810965164
Riso7958 VDD_B.t66 VDD_B.t8 1187.88141428875
Riso7959 VDD_B.t66 VDD_B.t80 1774.8010135732
Riso7960 VDD_B.t66 VDD_B.t81 7929.95085091945
Riso7961 VDD_B.t66 VDD_B.t82 1221.73965691243
Riso7962 VDD_B.t66 VDD_B.t83 3715.38351395064
Riso7963 VDD_B.t66 VDD_B.t85 1010.19807980837
Riso7964 VDD_B.t66 VDD_B.t86 3759.36841339703
Riso7965 VDD_B.t66 VDD_B.t87 285.902394478638
Riso7966 VDD_B.t66 VDD_B.t88 3429.4204525504
Riso7967 VDD_B.t66 VDD_B.t89 1359.88788403463
Riso7968 VDD_B.t66 VDD_B.t9 2840.25218025019
Riso7969 VDD_B.t66 VDD_B.t90 361.828976666159
Riso7970 VDD_B.t66 VDD_B.t91 1018.94074082064
Riso7971 VDD_B.t66 VDD_B.t92 3041.94027309122
Riso7972 VDD_B.t66 VDD_B.t94 765.745225326263
Riso7973 VDD_B.t66 VDD_B.t95 1249.46633138747
Riso7974 VDD_B.t66 VDD_B.t96 1639.82310854981
Riso7975 VDD_B.t66 VDD_B.t97 2353.90535823691
Riso7976 VDD_B.t66 VDD_B.t99 765.745225326263
Riso7977 VDD_B.t67 VDD_B.t68 30.7617494333052
Riso7978 VDD_B.t67 VDD_B.t69 1284.44218100213
Riso7979 VDD_B.t67 VDD_B.t70 890.856638297177
Riso7980 VDD_B.t67 VDD_B.t71 17730.3954422071
Riso7981 VDD_B.t67 VDD_B.t73 2689.79641015534
Riso7982 VDD_B.t67 VDD_B.t75 2844.04103398603
Riso7983 VDD_B.t67 VDD_B.t76 129.096756728179
Riso7984 VDD_B.t67 VDD_B.t77 210.344679350232
Riso7985 VDD_B.t67 VDD_B.t78 187.356634410366
Riso7986 VDD_B.t67 VDD_B.t79 76.6746762189946
Riso7987 VDD_B.t67 VDD_B.t8 5017.45990908873
Riso7988 VDD_B.t67 VDD_B.t80 513.260655270333
Riso7989 VDD_B.t67 VDD_B.t81 45102.9727025281
Riso7990 VDD_B.t67 VDD_B.t82 6948.85648489586
Riso7991 VDD_B.t67 VDD_B.t83 49.876053475966
Riso7992 VDD_B.t67 VDD_B.t85 6097.94683489035
Riso7993 VDD_B.t67 VDD_B.t86 166.182218609996
Riso7994 VDD_B.t67 VDD_B.t87 1277.61498351961
Riso7995 VDD_B.t67 VDD_B.t88 210.344679350232
Riso7996 VDD_B.t67 VDD_B.t89 665.060543059074
Riso7997 VDD_B.t67 VDD_B.t9 290.158016329461
Riso7998 VDD_B.t67 VDD_B.t90 1297.10331324526
Riso7999 VDD_B.t67 VDD_B.t91 833.709464325643
Riso8000 VDD_B.t67 VDD_B.t92 261.788045661227
Riso8001 VDD_B.t67 VDD_B.t94 6389.90276072235
Riso8002 VDD_B.t67 VDD_B.t95 179.888338143804
Riso8003 VDD_B.t67 VDD_B.t96 9326.77872692258
Riso8004 VDD_B.t67 VDD_B.t97 13388.2455405867
Riso8005 VDD_B.t67 VDD_B.t99 6389.90276072235
Riso8006 VDD_B.t68 VDD_B.t69 1319.35740874291
Riso8007 VDD_B.t68 VDD_B.t70 891.207645899146
Riso8008 VDD_B.t68 VDD_B.t71 19611.7763497599
Riso8009 VDD_B.t68 VDD_B.t73 2815.8163882465
Riso8010 VDD_B.t68 VDD_B.t75 3086.33192714286
Riso8011 VDD_B.t68 VDD_B.t76 122.004214673235
Riso8012 VDD_B.t68 VDD_B.t77 201.975792436794
Riso8013 VDD_B.t68 VDD_B.t78 179.237488911634
Riso8014 VDD_B.t68 VDD_B.t79 71.2970558025263
Riso8015 VDD_B.t68 VDD_B.t8 5265.31361470027
Riso8016 VDD_B.t68 VDD_B.t80 505.221388468467
Riso8017 VDD_B.t68 VDD_B.t81 49888.871132882
Riso8018 VDD_B.t68 VDD_B.t82 7686.20303549148
Riso8019 VDD_B.t68 VDD_B.t83 45.7861323906484
Riso8020 VDD_B.t68 VDD_B.t85 6416.2309050866
Riso8021 VDD_B.t68 VDD_B.t86 158.362052168784
Riso8022 VDD_B.t68 VDD_B.t87 1329.5030221273
Riso8023 VDD_B.t68 VDD_B.t88 201.975792436794
Riso8024 VDD_B.t68 VDD_B.t89 659.167993352583
Riso8025 VDD_B.t68 VDD_B.t9 281.348299017911
Riso8026 VDD_B.t68 VDD_B.t90 1338.05430346699
Riso8027 VDD_B.t68 VDD_B.t91 832.029142007966
Riso8028 VDD_B.t68 VDD_B.t92 253.075018707156
Riso8029 VDD_B.t68 VDD_B.t94 6746.32558952612
Riso8030 VDD_B.t68 VDD_B.t95 175.341344923328
Riso8031 VDD_B.t68 VDD_B.t96 10316.4477663412
Riso8032 VDD_B.t68 VDD_B.t97 14808.8788043958
Riso8033 VDD_B.t68 VDD_B.t99 6746.32558952612
Riso8034 VDD_B.t69 VDD_B.t70 115.990000349392
Riso8035 VDD_B.t69 VDD_B.t71 5992.66007875438
Riso8036 VDD_B.t69 VDD_B.t73 429.951815934158
Riso8037 VDD_B.t69 VDD_B.t75 405.254176411202
Riso8038 VDD_B.t69 VDD_B.t76 976.93610203862
Riso8039 VDD_B.t69 VDD_B.t77 724.811415644704
Riso8040 VDD_B.t69 VDD_B.t78 787.476359420122
Riso8041 VDD_B.t69 VDD_B.t79 1213.06085769696
Riso8042 VDD_B.t69 VDD_B.t8 653.449270643896
Riso8043 VDD_B.t69 VDD_B.t80 292.707517761633
Riso8044 VDD_B.t69 VDD_B.t81 15244.2614621089
Riso8045 VDD_B.t69 VDD_B.t82 2348.62978582532
Riso8046 VDD_B.t69 VDD_B.t83 1328.136406578
Riso8047 VDD_B.t69 VDD_B.t85 660.493614333177
Riso8048 VDD_B.t69 VDD_B.t86 851.103574195367
Riso8049 VDD_B.t69 VDD_B.t87 50.997256328444
Riso8050 VDD_B.t69 VDD_B.t88 724.811415644704
Riso8051 VDD_B.t69 VDD_B.t89 203.045249718331
Riso8052 VDD_B.t69 VDD_B.t9 549.512017645556
Riso8053 VDD_B.t69 VDD_B.t90 38.8784573734981
Riso8054 VDD_B.t69 VDD_B.t91 134.393340920908
Riso8055 VDD_B.t69 VDD_B.t92 605.32356241931
Riso8056 VDD_B.t69 VDD_B.t94 569.943814372967
Riso8057 VDD_B.t69 VDD_B.t95 228.849142171826
Riso8058 VDD_B.t69 VDD_B.t96 3152.33885912965
Riso8059 VDD_B.t69 VDD_B.t97 4525.06571763456
Riso8060 VDD_B.t69 VDD_B.t99 569.943814372967
Riso8061 VDD_B.t70 VDD_B.t71 13344.6053376481
Riso8062 VDD_B.t70 VDD_B.t73 815.196284422307
Riso8063 VDD_B.t70 VDD_B.t75 921.691392777901
Riso8064 VDD_B.t70 VDD_B.t76 508.175705284665
Riso8065 VDD_B.t70 VDD_B.t77 341.687336636814
Riso8066 VDD_B.t70 VDD_B.t78 380.886158773004
Riso8067 VDD_B.t70 VDD_B.t79 695.612159943584
Riso8068 VDD_B.t70 VDD_B.t8 1406.40127914736
Riso8069 VDD_B.t70 VDD_B.t80 107.007209533177
Riso8070 VDD_B.t70 VDD_B.t81 33946.3026773323
Riso8071 VDD_B.t70 VDD_B.t82 5229.98754546386
Riso8072 VDD_B.t70 VDD_B.t83 825.875731144083
Riso8073 VDD_B.t70 VDD_B.t85 1579.61353774627
Riso8074 VDD_B.t70 VDD_B.t86 422.05261915235
Riso8075 VDD_B.t70 VDD_B.t87 162.086657646599
Riso8076 VDD_B.t70 VDD_B.t88 341.687336636814
Riso8077 VDD_B.t70 VDD_B.t89 67.4118804049838
Riso8078 VDD_B.t70 VDD_B.t9 238.629528730753
Riso8079 VDD_B.t70 VDD_B.t90 131.393669676639
Riso8080 VDD_B.t70 VDD_B.t91 40.4447158719027
Riso8081 VDD_B.t70 VDD_B.t92 270.398290654681
Riso8082 VDD_B.t70 VDD_B.t94 1509.43205394979
Riso8083 VDD_B.t70 VDD_B.t95 93.6677855526443
Riso8084 VDD_B.t70 VDD_B.t96 7019.70701037342
Riso8085 VDD_B.t70 VDD_B.t97 10076.5295102982
Riso8086 VDD_B.t70 VDD_B.t99 1509.43205394979
Riso8087 VDD_B.t71 VDD_B.t73 5323.52241805384
Riso8088 VDD_B.t71 VDD_B.t75 3117.33697358239
Riso8089 VDD_B.t71 VDD_B.t76 35697.0143196504
Riso8090 VDD_B.t71 VDD_B.t77 36220.2299831206
Riso8091 VDD_B.t71 VDD_B.t78 36615.0939448138
Riso8092 VDD_B.t71 VDD_B.t79 30812.260197124
Riso8093 VDD_B.t71 VDD_B.t8 8401.39563209622
Riso8094 VDD_B.t71 VDD_B.t80 23809.0286875895
Riso8095 VDD_B.t71 VDD_B.t81 107.655070547569
Riso8096 VDD_B.t71 VDD_B.t82 75.1674388716428
Riso8097 VDD_B.t71 VDD_B.t83 25478.766382239
Riso8098 VDD_B.t71 VDD_B.t85 8740.36163646877
Riso8099 VDD_B.t71 VDD_B.t86 36663.5266027184
Riso8100 VDD_B.t71 VDD_B.t87 4197.44588531507
Riso8101 VDD_B.t71 VDD_B.t88 36220.2299831206
Riso8102 VDD_B.t71 VDD_B.t89 19007.4352418174
Riso8103 VDD_B.t71 VDD_B.t9 33248.5428152789
Riso8104 VDD_B.t71 VDD_B.t90 5342.58619031971
Riso8105 VDD_B.t71 VDD_B.t91 14649.8771028634
Riso8106 VDD_B.t71 VDD_B.t92 34497.7909110997
Riso8107 VDD_B.t71 VDD_B.t94 7739.56737365876
Riso8108 VDD_B.t71 VDD_B.t95 15458.5406121443
Riso8109 VDD_B.t71 VDD_B.t96 47.5783995249538
Riso8110 VDD_B.t71 VDD_B.t97 23.9173869686254
Riso8111 VDD_B.t71 VDD_B.t99 7739.56737365876
Riso8112 VDD_B.t73 VDD_B.t75 1048.68990135543
Riso8113 VDD_B.t73 VDD_B.t76 2768.18499926195
Riso8114 VDD_B.t73 VDD_B.t77 2344.12957593811
Riso8115 VDD_B.t73 VDD_B.t78 2460.36383169968
Riso8116 VDD_B.t73 VDD_B.t79 3036.19486338636
Riso8117 VDD_B.t73 VDD_B.t8 69.6517274744538
Riso8118 VDD_B.t73 VDD_B.t80 1355.35539676315
Riso8119 VDD_B.t73 VDD_B.t81 13542.0942575937
Riso8120 VDD_B.t73 VDD_B.t82 2086.38286708044
Riso8121 VDD_B.t73 VDD_B.t83 3045.5334754608
Riso8122 VDD_B.t73 VDD_B.t85 105.563039339753
Riso8123 VDD_B.t73 VDD_B.t86 2571.47894241195
Riso8124 VDD_B.t73 VDD_B.t87 326.568614115345
Riso8125 VDD_B.t73 VDD_B.t88 2344.12957593811
Riso8126 VDD_B.t73 VDD_B.t89 1100.82418265034
Riso8127 VDD_B.t73 VDD_B.t9 1985.04566139556
Riso8128 VDD_B.t73 VDD_B.t90 393.393450276987
Riso8129 VDD_B.t73 VDD_B.t91 880.7522491079
Riso8130 VDD_B.t73 VDD_B.t92 2104.7484590425
Riso8131 VDD_B.t73 VDD_B.t94 161.393787791799
Riso8132 VDD_B.t73 VDD_B.t95 896.565655414365
Riso8133 VDD_B.t73 VDD_B.t96 2800.35015591392
Riso8134 VDD_B.t73 VDD_B.t97 4019.79896647193
Riso8135 VDD_B.t73 VDD_B.t99 161.393787791799
Riso8136 VDD_B.t75 VDD_B.t76 3982.61478290965
Riso8137 VDD_B.t75 VDD_B.t77 3429.4204525504
Riso8138 VDD_B.t75 VDD_B.t78 3604.60460749125
Riso8139 VDD_B.t75 VDD_B.t79 4051.84810965164
Riso8140 VDD_B.t75 VDD_B.t8 1187.88141428875
Riso8141 VDD_B.t75 VDD_B.t80 1774.8010135732
Riso8142 VDD_B.t75 VDD_B.t81 7929.95085091945
Riso8143 VDD_B.t75 VDD_B.t82 1221.73965691243
Riso8144 VDD_B.t75 VDD_B.t83 3715.38351395064
Riso8145 VDD_B.t75 VDD_B.t85 1010.19807980837
Riso8146 VDD_B.t75 VDD_B.t86 3759.36841339703
Riso8147 VDD_B.t75 VDD_B.t87 285.902394478638
Riso8148 VDD_B.t75 VDD_B.t88 3429.4204525504
Riso8149 VDD_B.t75 VDD_B.t89 1359.88788403463
Riso8150 VDD_B.t75 VDD_B.t9 2840.25218025019
Riso8151 VDD_B.t75 VDD_B.t90 361.828976666159
Riso8152 VDD_B.t75 VDD_B.t91 1018.94074082064
Riso8153 VDD_B.t75 VDD_B.t92 3041.94027309122
Riso8154 VDD_B.t75 VDD_B.t94 765.745225326263
Riso8155 VDD_B.t75 VDD_B.t95 1249.46633138747
Riso8156 VDD_B.t75 VDD_B.t96 1639.82310854981
Riso8157 VDD_B.t75 VDD_B.t97 2353.90535823691
Riso8158 VDD_B.t75 VDD_B.t99 765.745225326263
Riso8159 VDD_B.t76 VDD_B.t77 65.9977652110945
Riso8160 VDD_B.t76 VDD_B.t78 55.9981285599394
Riso8161 VDD_B.t76 VDD_B.t79 61.3893765559523
Riso8162 VDD_B.t76 VDD_B.t8 5233.33835052928
Riso8163 VDD_B.t76 VDD_B.t80 232.548353443667
Riso8164 VDD_B.t76 VDD_B.t81 90806.8558126038
Riso8165 VDD_B.t76 VDD_B.t82 13990.2931243166
Riso8166 VDD_B.t76 VDD_B.t83 92.1200427679123
Riso8167 VDD_B.t76 VDD_B.t85 6455.4526314342
Riso8168 VDD_B.t76 VDD_B.t86 47.2842410931188
Riso8169 VDD_B.t76 VDD_B.t87 1115.79455147991
Riso8170 VDD_B.t76 VDD_B.t88 65.9977652110945
Riso8171 VDD_B.t76 VDD_B.t89 334.766279402891
Riso8172 VDD_B.t76 VDD_B.t9 104.407077306238
Riso8173 VDD_B.t76 VDD_B.t90 1031.71610663939
Riso8174 VDD_B.t76 VDD_B.t91 461.472663733068
Riso8175 VDD_B.t76 VDD_B.t92 90.1733346564786
Riso8176 VDD_B.t76 VDD_B.t94 6895.89034505393
Riso8177 VDD_B.t76 VDD_B.t95 69.9803584485665
Riso8178 VDD_B.t76 VDD_B.t96 18777.8188510454
Riso8179 VDD_B.t76 VDD_B.t97 26954.8637161037
Riso8180 VDD_B.t76 VDD_B.t99 6895.89034505393
Riso8181 VDD_B.t77 VDD_B.t78 41.1772421081864
Riso8182 VDD_B.t77 VDD_B.t79 114.039456880474
Riso8183 VDD_B.t77 VDD_B.t8 4412.44019655296
Riso8184 VDD_B.t77 VDD_B.t80 140.687634426246
Riso8185 VDD_B.t77 VDD_B.t81 92137.8234079942
Riso8186 VDD_B.t77 VDD_B.t82 14195.3506239056
Riso8187 VDD_B.t77 VDD_B.t83 161.29470938391
Riso8188 VDD_B.t77 VDD_B.t85 5416.47039084265
Riso8189 VDD_B.t77 VDD_B.t86 48.5842721859194
Riso8190 VDD_B.t77 VDD_B.t87 859.412735815155
Riso8191 VDD_B.t77 VDD_B.t88 0.0669656152523054
Riso8192 VDD_B.t77 VDD_B.t89 212.707377609448
Riso8193 VDD_B.t77 VDD_B.t9 57.4591687892165
Riso8194 VDD_B.t77 VDD_B.t90 775.031219689428
Riso8195 VDD_B.t77 VDD_B.t91 306.307547366975
Riso8196 VDD_B.t77 VDD_B.t92 48.8584510272282
Riso8197 VDD_B.t77 VDD_B.t94 5749.29801925029
Riso8198 VDD_B.t77 VDD_B.t95 39.6721558096688
Riso8199 VDD_B.t77 VDD_B.t96 19053.0477220288
Riso8200 VDD_B.t77 VDD_B.t97 27349.9445701125
Riso8201 VDD_B.t77 VDD_B.t99 5749.29801925029
Riso8202 VDD_B.t78 VDD_B.t79 98.4078575867183
Riso8203 VDD_B.t78 VDD_B.t8 4638.80519249675
Riso8204 VDD_B.t78 VDD_B.t80 161.300179496584
Riso8205 VDD_B.t78 VDD_B.t81 93142.2871010637
Riso8206 VDD_B.t78 VDD_B.t82 14350.1048147981
Riso8207 VDD_B.t78 VDD_B.t83 141.238566089594
Riso8208 VDD_B.t78 VDD_B.t85 5704.73119290188
Riso8209 VDD_B.t78 VDD_B.t86 40.910588145584
Riso8210 VDD_B.t78 VDD_B.t87 925.310421778704
Riso8211 VDD_B.t78 VDD_B.t88 41.1772421081864
Riso8212 VDD_B.t78 VDD_B.t89 240.737547150155
Riso8213 VDD_B.t78 VDD_B.t9 67.4747308681969
Riso8214 VDD_B.t78 VDD_B.t90 839.469149870837
Riso8215 VDD_B.t78 VDD_B.t91 342.633297850902
Riso8216 VDD_B.t78 VDD_B.t92 57.5935900397299
Riso8217 VDD_B.t78 VDD_B.t94 6069.69850162889
Riso8218 VDD_B.t78 VDD_B.t95 46.2461596296543
Riso8219 VDD_B.t78 VDD_B.t96 19260.7593215784
Riso8220 VDD_B.t78 VDD_B.t97 27648.1068807902
Riso8221 VDD_B.t78 VDD_B.t99 6069.69850162889
Riso8222 VDD_B.t79 VDD_B.t8 5734.99739178471
Riso8223 VDD_B.t79 VDD_B.t80 348.940700276732
Riso8224 VDD_B.t79 VDD_B.t81 78380.9100650881
Riso8225 VDD_B.t79 VDD_B.t82 12075.8713353565
Riso8226 VDD_B.t79 VDD_B.t83 51.0228438057977
Riso8227 VDD_B.t79 VDD_B.t85 7067.31247307198
Riso8228 VDD_B.t79 VDD_B.t86 84.4870650437975
Riso8229 VDD_B.t79 VDD_B.t87 1325.2197119911
Riso8230 VDD_B.t79 VDD_B.t88 114.039456880474
Riso8231 VDD_B.t79 VDD_B.t89 481.195821401675
Riso8232 VDD_B.t79 VDD_B.t9 171.59443552587
Riso8233 VDD_B.t79 VDD_B.t90 1262.8386679426
Riso8234 VDD_B.t79 VDD_B.t91 638.877364666105
Riso8235 VDD_B.t79 VDD_B.t92 150.644179089864
Riso8236 VDD_B.t79 VDD_B.t94 7539.736577732
Riso8237 VDD_B.t79 VDD_B.t95 111.617615744286
Riso8238 VDD_B.t79 VDD_B.t96 16208.2754370405
Riso8239 VDD_B.t79 VDD_B.t97 23266.3792820739
Riso8240 VDD_B.t79 VDD_B.t99 7539.736577732
Riso8241 VDD_B.t8 VDD_B.t80 2474.82559674226
Riso8242 VDD_B.t8 VDD_B.t81 21371.6563227654
Riso8243 VDD_B.t8 VDD_B.t82 3292.65597660018
Riso8244 VDD_B.t8 VDD_B.t83 5730.75439997179
Riso8245 VDD_B.t8 VDD_B.t85 41.7621862458547
Riso8246 VDD_B.t8 VDD_B.t86 4854.46693007678
Riso8247 VDD_B.t8 VDD_B.t87 459.0276408007
Riso8248 VDD_B.t8 VDD_B.t88 4412.44019655296
Riso8249 VDD_B.t8 VDD_B.t89 1972.30772813199
Riso8250 VDD_B.t8 VDD_B.t9 3710.06102689503
Riso8251 VDD_B.t8 VDD_B.t90 583.678004662029
Riso8252 VDD_B.t8 VDD_B.t91 1536.33134575777
Riso8253 VDD_B.t8 VDD_B.t92 3944.59383237589
Riso8254 VDD_B.t8 VDD_B.t94 66.6890568079654
Riso8255 VDD_B.t8 VDD_B.t95 1664.52053066
Riso8256 VDD_B.t8 VDD_B.t96 4419.41401212997
Riso8257 VDD_B.t8 VDD_B.t97 6343.90518659042
Riso8258 VDD_B.t8 VDD_B.t99 66.6890568079654
Riso8259 VDD_B.t80 VDD_B.t81 60565.9346104457
Riso8260 VDD_B.t80 VDD_B.t82 9331.18067976002
Riso8261 VDD_B.t80 VDD_B.t83 442.455901798198
Riso8262 VDD_B.t80 VDD_B.t85 2939.9141081304
Riso8263 VDD_B.t80 VDD_B.t86 183.653937923129
Riso8264 VDD_B.t80 VDD_B.t87 376.618586813059
Riso8265 VDD_B.t80 VDD_B.t88 140.687634426246
Riso8266 VDD_B.t80 VDD_B.t89 57.9296081415201
Riso8267 VDD_B.t80 VDD_B.t9 89.9988743869116
Riso8268 VDD_B.t80 VDD_B.t90 322.09686258248
Riso8269 VDD_B.t80 VDD_B.t91 92.8051382314512
Riso8270 VDD_B.t80 VDD_B.t92 105.04328197021
Riso8271 VDD_B.t80 VDD_B.t94 2994.63381866876
Riso8272 VDD_B.t80 VDD_B.t95 33.299403625693
Riso8273 VDD_B.t80 VDD_B.t96 12524.3423360702
Riso8274 VDD_B.t80 VDD_B.t97 17978.2297124357
Riso8275 VDD_B.t80 VDD_B.t99 2994.63381866876
Riso8276 VDD_B.t81 VDD_B.t82 190.329443575997
Riso8277 VDD_B.t81 VDD_B.t83 64813.4503473415
Riso8278 VDD_B.t81 VDD_B.t85 22233.9255537103
Riso8279 VDD_B.t81 VDD_B.t86 93265.4911691567
Riso8280 VDD_B.t81 VDD_B.t87 10677.5558279448
Riso8281 VDD_B.t81 VDD_B.t88 92137.8234079942
Riso8282 VDD_B.t81 VDD_B.t89 48351.5348346933
Riso8283 VDD_B.t81 VDD_B.t9 84578.3797594588
Riso8284 VDD_B.t81 VDD_B.t90 13590.5891037982
Riso8285 VDD_B.t81 VDD_B.t91 37266.6819090184
Riso8286 VDD_B.t81 VDD_B.t92 87756.2447398619
Riso8287 VDD_B.t81 VDD_B.t94 19688.0829376502
Riso8288 VDD_B.t81 VDD_B.t95 39323.7780580306
Riso8289 VDD_B.t81 VDD_B.t96 124.872564170474
Riso8290 VDD_B.t81 VDD_B.t97 119.951928445017
Riso8291 VDD_B.t81 VDD_B.t99 19688.0829376502
Riso8292 VDD_B.t82 VDD_B.t83 9985.58050098004
Riso8293 VDD_B.t82 VDD_B.t85 3425.50276647134
Riso8294 VDD_B.t82 VDD_B.t86 14369.086432555
Riso8295 VDD_B.t82 VDD_B.t87 1645.05349896135
Riso8296 VDD_B.t82 VDD_B.t88 14195.3506239056
Riso8297 VDD_B.t82 VDD_B.t89 7449.35103516789
Riso8298 VDD_B.t82 VDD_B.t9 13030.6937094759
Riso8299 VDD_B.t82 VDD_B.t90 2093.85429759467
Riso8300 VDD_B.t82 VDD_B.t91 5741.54670384994
Riso8301 VDD_B.t82 VDD_B.t92 13520.2961980489
Riso8302 VDD_B.t82 VDD_B.t94 3033.27374226023
Riso8303 VDD_B.t82 VDD_B.t95 6058.47627763647
Riso8304 VDD_B.t82 VDD_B.t96 38.3452141687395
Riso8305 VDD_B.t82 VDD_B.t97 56.6889780523258
Riso8306 VDD_B.t82 VDD_B.t99 3033.27374226023
Riso8307 VDD_B.t83 VDD_B.t85 7032.07743695652
Riso8308 VDD_B.t83 VDD_B.t86 123.071224444703
Riso8309 VDD_B.t83 VDD_B.t87 1394.59805170296
Riso8310 VDD_B.t83 VDD_B.t88 161.29470938391
Riso8311 VDD_B.t83 VDD_B.t89 591.912234192009
Riso8312 VDD_B.t83 VDD_B.t9 232.910942717714
Riso8313 VDD_B.t83 VDD_B.t90 1365.10596445548
Riso8314 VDD_B.t83 VDD_B.t91 764.972058937407
Riso8315 VDD_B.t83 VDD_B.t92 207.168470363816
Riso8316 VDD_B.t83 VDD_B.t94 7460.47180101343
Riso8317 VDD_B.t83 VDD_B.t95 148.020228051534
Riso8318 VDD_B.t83 VDD_B.t96 13402.6799941759
Riso8319 VDD_B.t83 VDD_B.t97 19239.0509003898
Riso8320 VDD_B.t83 VDD_B.t99 7460.47180101343
Riso8321 VDD_B.t84 VDD_B.t98 158.648
Riso8322 VDD_B.t85 VDD_B.t86 5978.44134154747
Riso8323 VDD_B.t85 VDD_B.t87 439.524059504274
Riso8324 VDD_B.t85 VDD_B.t88 5416.47039084265
Riso8325 VDD_B.t85 VDD_B.t89 2297.84404394583
Riso8326 VDD_B.t85 VDD_B.t9 4518.63342067666
Riso8327 VDD_B.t85 VDD_B.t90 579.769743714541
Riso8328 VDD_B.t85 VDD_B.t91 1743.58032704201
Riso8329 VDD_B.t85 VDD_B.t92 4818.80367108231
Riso8330 VDD_B.t85 VDD_B.t94 43.7991547841106
Riso8331 VDD_B.t85 VDD_B.t95 2012.57586756294
Riso8332 VDD_B.t85 VDD_B.t96 4597.72142377439
Riso8333 VDD_B.t85 VDD_B.t97 6599.85887421368
Riso8334 VDD_B.t85 VDD_B.t99 43.7991547841106
Riso8335 VDD_B.t86 VDD_B.t87 990.906930081042
Riso8336 VDD_B.t86 VDD_B.t88 48.5842721859194
Riso8337 VDD_B.t86 VDD_B.t89 270.670294333646
Riso8338 VDD_B.t86 VDD_B.t9 78.6938083719541
Riso8339 VDD_B.t86 VDD_B.t90 904.51052747062
Riso8340 VDD_B.t86 VDD_B.t91 380.926546696641
Riso8341 VDD_B.t86 VDD_B.t92 67.4329164386075
Riso8342 VDD_B.t86 VDD_B.t94 6372.78174917673
Riso8343 VDD_B.t86 VDD_B.t95 53.5336797721083
Riso8344 VDD_B.t86 VDD_B.t96 19286.2365132691
Riso8345 VDD_B.t86 VDD_B.t97 27684.6784461748
Riso8346 VDD_B.t86 VDD_B.t99 6372.78174917673
Riso8347 VDD_B.t87 VDD_B.t88 859.412735815155
Riso8348 VDD_B.t87 VDD_B.t89 269.971423339958
Riso8349 VDD_B.t87 VDD_B.t9 669.332384385857
Riso8350 VDD_B.t87 VDD_B.t90 43.1256938546101
Riso8351 VDD_B.t87 VDD_B.t91 185.411933196581
Riso8352 VDD_B.t87 VDD_B.t92 730.696095122855
Riso8353 VDD_B.t87 VDD_B.t94 362.600499823255
Riso8354 VDD_B.t87 VDD_B.t95 283.965600933366
Riso8355 VDD_B.t87 VDD_B.t96 2207.99638215469
Riso8356 VDD_B.t87 VDD_B.t97 3169.49705600746
Riso8357 VDD_B.t87 VDD_B.t99 362.600499823255
Riso8358 VDD_B.t88 VDD_B.t89 212.707377609448
Riso8359 VDD_B.t88 VDD_B.t9 57.4591687892165
Riso8360 VDD_B.t88 VDD_B.t90 775.031219689428
Riso8361 VDD_B.t88 VDD_B.t91 306.307547366975
Riso8362 VDD_B.t88 VDD_B.t92 48.8584510272282
Riso8363 VDD_B.t88 VDD_B.t94 5749.29801925029
Riso8364 VDD_B.t88 VDD_B.t95 39.6721558096688
Riso8365 VDD_B.t88 VDD_B.t96 19053.0477220288
Riso8366 VDD_B.t88 VDD_B.t97 27349.9445701125
Riso8367 VDD_B.t88 VDD_B.t99 5749.29801925029
Riso8368 VDD_B.t89 VDD_B.t9 141.554943063187
Riso8369 VDD_B.t89 VDD_B.t90 226.049442604235
Riso8370 VDD_B.t89 VDD_B.t91 57.8232925129455
Riso8371 VDD_B.t89 VDD_B.t92 163.056464873166
Riso8372 VDD_B.t89 VDD_B.t94 2287.31850610897
Riso8373 VDD_B.t89 VDD_B.t95 53.7425555821795
Riso8374 VDD_B.t89 VDD_B.t96 9998.54420870565
Riso8375 VDD_B.t89 VDD_B.t97 14352.5400177186
Riso8376 VDD_B.t89 VDD_B.t99 2287.31850610897
Riso8377 VDD_B.t9 VDD_B.t90 593.070328988428
Riso8378 VDD_B.t9 VDD_B.t91 211.550646063621
Riso8379 VDD_B.t9 VDD_B.t92 40.9496334545207
Riso8380 VDD_B.t9 VDD_B.t94 4747.88630800611
Riso8381 VDD_B.t9 VDD_B.t95 24.1829735187471
Riso8382 VDD_B.t9 VDD_B.t96 17489.8412639192
Riso8383 VDD_B.t9 VDD_B.t97 25106.0195768681
Riso8384 VDD_B.t9 VDD_B.t99 4747.88630800611
Riso8385 VDD_B.t90 VDD_B.t91 151.567174872951
Riso8386 VDD_B.t90 VDD_B.t92 651.256195069261
Riso8387 VDD_B.t90 VDD_B.t94 492.854328892185
Riso8388 VDD_B.t90 VDD_B.t95 248.608109923728
Riso8389 VDD_B.t90 VDD_B.t96 2810.37833527426
Riso8390 VDD_B.t90 VDD_B.t97 4034.19404665259
Riso8391 VDD_B.t90 VDD_B.t99 492.854328892185
Riso8392 VDD_B.t91 VDD_B.t92 240.631817454669
Riso8393 VDD_B.t91 VDD_B.t94 1685.01496537059
Riso8394 VDD_B.t91 VDD_B.t95 82.3890163872586
Riso8395 VDD_B.t91 VDD_B.t96 7706.32344667031
Riso8396 VDD_B.t91 VDD_B.t97 11062.1419827814
Riso8397 VDD_B.t91 VDD_B.t99 1685.01496537059
Riso8398 VDD_B.t92 VDD_B.t94 5082.94964813912
Riso8399 VDD_B.t92 VDD_B.t95 28.6712636600458
Riso8400 VDD_B.t92 VDD_B.t96 18146.9873835716
Riso8401 VDD_B.t92 VDD_B.t97 26049.3285009401
Riso8402 VDD_B.t92 VDD_B.t99 5082.94964813912
Riso8403 VDD_B.t93 VDD_B.t98 158.648
Riso8404 VDD_B.t94 VDD_B.t95 2095.22681430451
Riso8405 VDD_B.t94 VDD_B.t96 4071.27029803227
Riso8406 VDD_B.t94 VDD_B.t97 5844.15777494687
Riso8407 VDD_B.t94 VDD_B.t99 0.823027179970408
Riso8408 VDD_B.t95 VDD_B.t96 8131.70739482781
Riso8409 VDD_B.t95 VDD_B.t97 11672.7648906153
Riso8410 VDD_B.t95 VDD_B.t99 2095.22681430451
Riso8411 VDD_B.t96 VDD_B.t97 19.2667192065866
Riso8412 VDD_B.t96 VDD_B.t99 4071.27029803227
Riso8413 VDD_B.t97 VDD_B.t99 5844.15777494687
Riso8414 DVDD_A DVDD_B 1.79869167509188
Riso8415 DVSS_A DVSS_B 1.48017878422112
Riso8416 DVSS_A DVSS_B.t10 577002.776340439
Riso8417 DVSS_A DVSS_B.t100 2813.10024278784
Riso8418 DVSS_A DVSS_B.t102 1557.41283410712
Riso8419 DVSS_A DVSS_B.t11 592.757412899142
Riso8420 DVSS_A DVSS_B.t112 8741.24952330085
Riso8421 DVSS_A DVSS_B.t114 9192.30787146042
Riso8422 DVSS_A DVSS_B.t118 3421.37638544852
Riso8423 DVSS_A DVSS_B.t120 4309.19526171323
Riso8424 DVSS_A DVSS_B.t124 6060.57339987279
Riso8425 DVSS_A DVSS_B.t132 953.353967930358
Riso8426 DVSS_A DVSS_B.t134 3877.84660781325
Riso8427 DVSS_A DVSS_B.t143 5200.2753442931
Riso8428 DVSS_A DVSS_B.t148 119345.508288761
Riso8429 DVSS_A DVSS_B.t149 1625.72876566819
Riso8430 DVSS_A DVSS_B.t151 3162.20340643658
Riso8431 DVSS_A DVSS_B.t153 3402.82486345639
Riso8432 DVSS_A DVSS_B.t155 8538.80471164583
Riso8433 DVSS_A DVSS_B.t157 1775.83214635747
Riso8434 DVSS_A DVSS_B.t159 1067.40208099874
Riso8435 DVSS_A DVSS_B.t161 2613.47953809074
Riso8436 DVSS_A DVSS_B.t162 219844.021202736
Riso8437 DVSS_A DVSS_B.t163 1775.83214635747
Riso8438 DVSS_A DVSS_B.t165 8741.24952330085
Riso8439 DVSS_A DVSS_B.t167 9305.50796263853
Riso8440 DVSS_A DVSS_B.t169 1310.58169163983
Riso8441 DVSS_A DVSS_B.t173 1555.39057976622
Riso8442 DVSS_A DVSS_B.t177 2200.71432724429
Riso8443 DVSS_A DVSS_B.t20 117575.783403419
Riso8444 DVSS_A DVSS_B.t202 1555.39057976622
Riso8445 DVSS_A DVSS_B.t204 7217.89177873086
Riso8446 DVSS_A DVSS_B.t206 5640.5593678372
Riso8447 DVSS_A DVSS_B.t21 1379.63977960551
Riso8448 DVSS_A DVSS_B.t212 6445.10860791345
Riso8449 DVSS_A DVSS_B.t214 8086.06806337023
Riso8450 DVSS_A DVSS_B.t215 121318.640604576
Riso8451 DVSS_A DVSS_B.t216 1625.72876566819
Riso8452 DVSS_A DVSS_B.t218 3382.74301339673
Riso8453 DVSS_A DVSS_B.t225 9357.35610148283
Riso8454 DVSS_A DVSS_B.t236 6445.10860791345
Riso8455 DVSS_A DVSS_B.t238 953.353967930358
Riso8456 DVSS_A DVSS_B.t240 6060.57339987279
Riso8457 DVSS_A DVSS_B.t250 3162.20340643658
Riso8458 DVSS_A DVSS_B.t252 1187.10387900533
Riso8459 DVSS_A DVSS_B.t256 2407.38200438596
Riso8460 DVSS_A DVSS_B.t258 4752.86813360901
Riso8461 DVSS_A DVSS_B.t259 150028.117238414
Riso8462 DVSS_A DVSS_B.t260 3877.84660781325
Riso8463 DVSS_A DVSS_B.t264 8913.94529264738
Riso8464 DVSS_A DVSS_B.t266 9357.35610148283
Riso8465 DVSS_A DVSS_B.t267 82358.6423588246
Riso8466 DVSS_A DVSS_B.t268 746.738040643967
Riso8467 DVSS_A DVSS_B.t271 846.212521633538
Riso8468 DVSS_A DVSS_B.t273 3293.41087999599
Riso8469 DVSS_A DVSS_B.t275 1557.41283410712
Riso8470 DVSS_A DVSS_B.t277 7040.47642676758
Riso8471 DVSS_A DVSS_B.t279 5640.5593678372
Riso8472 DVSS_A DVSS_B.t281 9397.05657722729
Riso8473 DVSS_A DVSS_B.t283 1672.75547723371
Riso8474 DVSS_A DVSS_B.t285 3421.37638544852
Riso8475 DVSS_A DVSS_B.t287 3382.74301339673
Riso8476 DVSS_A DVSS_B.t288 219844.021202736
Riso8477 DVSS_A DVSS_B.t289 2200.71432724429
Riso8478 DVSS_A DVSS_B.t291 9305.50796263853
Riso8479 DVSS_A DVSS_B.t293 1310.58169163983
Riso8480 DVSS_A DVSS_B.t295 4309.19526171323
Riso8481 DVSS_A DVSS_B.t297 2613.47953809074
Riso8482 DVSS_A DVSS_B.t299 1435.19409988531
Riso8483 DVSS_A DVSS_B.t301 8292.65746808638
Riso8484 DVSS_A DVSS_B.t302 960960.913205857
Riso8485 DVSS_A DVSS_B.t303 8292.65746808638
Riso8486 DVSS_A DVSS_B.t305 2407.38200438596
Riso8487 DVSS_A DVSS_B.t322 1735.18746456551
Riso8488 DVSS_A DVSS_B.t325 828358.228554688
Riso8489 DVSS_A DVSS_B.t326 7217.89177873086
Riso8490 DVSS_A DVSS_B.t329 26.2097992982503
Riso8491 DVSS_A DVSS_B.t331 109.696780045878
Riso8492 DVSS_A DVSS_B.t333 100.511739947352
Riso8493 DVSS_A DVSS_B.t335 23.40391283687
Riso8494 DVSS_A DVSS_B.t337 43.8626229409869
Riso8495 DVSS_A DVSS_B.t339 109.696780045878
Riso8496 DVSS_A DVSS_B.t341 100.511739947352
Riso8497 DVSS_A DVSS_B.t343 41.0653977463688
Riso8498 DVSS_A DVSS_B.t345 172368.563922698
Riso8499 DVSS_A DVSS_B.t346 685.041487281951
Riso8500 DVSS_A DVSS_B.t348 3293.41087999599
Riso8501 DVSS_A DVSS_B.t35 4752.86813360901
Riso8502 DVSS_A DVSS_B.t350 846.212521633538
Riso8503 DVSS_A DVSS_B.t352 746.738040643967
Riso8504 DVSS_A DVSS_B.t355 584986.684342495
Riso8505 DVSS_A DVSS_B.t356 852.804834060904
Riso8506 DVSS_A DVSS_B.t358 8913.94529264738
Riso8507 DVSS_A DVSS_B.t36 88816.247582635
Riso8508 DVSS_A DVSS_B.t360 6777.47004008907
Riso8509 DVSS_A DVSS_B.t364 9397.05657722729
Riso8510 DVSS_A DVSS_B.t366 9084.00240222881
Riso8511 DVSS_A DVSS_B.t37 1379.63977960551
Riso8512 DVSS_A DVSS_B.t509 9084.00240222881
Riso8513 DVSS_A DVSS_B.t515 2998.8987355341
Riso8514 DVSS_A DVSS_B.t525 1499.07378518299
Riso8515 DVSS_A DVSS_B.t529 5200.2753442931
Riso8516 DVSS_A DVSS_B.t531 2998.8987355341
Riso8517 DVSS_A DVSS_B.t59 150028.117238414
Riso8518 DVSS_A DVSS_B.t60 3402.82486345639
Riso8519 DVSS_A DVSS_B.t66 2813.10024278784
Riso8520 DVSS_A DVSS_B.t68 1435.19409988531
Riso8521 DVSS_A DVSS_B.t70 7040.47642676758
Riso8522 DVSS_A DVSS_B.t72 9192.30787146042
Riso8523 DVSS_A DVSS_B.t74 1735.18746456551
Riso8524 DVSS_A DVSS_B.t76 1067.40208099874
Riso8525 DVSS_A DVSS_B.t80 1187.10387900533
Riso8526 DVSS_A DVSS_B.t82 1672.75547723371
Riso8527 DVSS_A DVSS_B.t84 1499.07378518299
Riso8528 DVSS_A DVSS_B.t89 828358.228554688
Riso8529 DVSS_A DVSS_B.t90 8086.06806337023
Riso8530 DVSS_A DVSS_B.t94 6777.47004008907
Riso8531 DVSS_A DVSS_B.t96 8538.80471164583
Riso8532 DVSS_A VSS_A 17.3675014405066
Riso8533 DVSS_A VSS_B 22.9654601095979
Riso8534 DVSS_B DVSS_B.t10 2678150.01933712
Riso8535 DVSS_B DVSS_B.t100 13043.6058929264
Riso8536 DVSS_B DVSS_B.t102 7217.40238507337
Riso8537 DVSS_B DVSS_B.t11 2749.83186285964
Riso8538 DVSS_B DVSS_B.t112 40595.7493713398
Riso8539 DVSS_B DVSS_B.t114 42682.0485240721
Riso8540 DVSS_B DVSS_B.t118 15875.5456698221
Riso8541 DVSS_B DVSS_B.t120 20003.666060659
Riso8542 DVSS_B DVSS_B.t124 28132.6540414021
Riso8543 DVSS_B DVSS_B.t132 4417.41484625725
Riso8544 DVSS_B DVSS_B.t134 18001.8531407513
Riso8545 DVSS_B DVSS_B.t143 24139.2375703744
Riso8546 DVSS_B DVSS_B.t148 553625.37792923
Riso8547 DVSS_B DVSS_B.t149 7541.7583867527
Riso8548 DVSS_B DVSS_B.t151 14665.6490334733
Riso8549 DVSS_B DVSS_B.t153 15792.613984897
Riso8550 DVSS_B DVSS_B.t155 39645.584751164
Riso8551 DVSS_B DVSS_B.t157 8230.77521165718
Riso8552 DVSS_B DVSS_B.t159 4945.91343365601
Riso8553 DVSS_B DVSS_B.t161 12116.9982312661
Riso8554 DVSS_B DVSS_B.t162 1019248.02363762
Riso8555 DVSS_B DVSS_B.t163 8230.77521165718
Riso8556 DVSS_B DVSS_B.t165 40595.7493713398
Riso8557 DVSS_B DVSS_B.t167 43212.54824473
Riso8558 DVSS_B DVSS_B.t169 6072.98837297749
Riso8559 DVSS_B DVSS_B.t173 7201.62567039624
Riso8560 DVSS_B DVSS_B.t177 10202.0692547234
Riso8561 DVSS_B DVSS_B.t20 545442.149031751
Riso8562 DVSS_B DVSS_B.t202 7201.62567039624
Riso8563 DVSS_B DVSS_B.t204 33508.7923444358
Riso8564 DVSS_B DVSS_B.t206 26182.8624430329
Riso8565 DVSS_B DVSS_B.t21 6400.17378502755
Riso8566 DVSS_B DVSS_B.t212 29918.0804919305
Riso8567 DVSS_B DVSS_B.t214 37542.8489177158
Riso8568 DVSS_B DVSS_B.t215 562778.433957149
Riso8569 DVSS_B DVSS_B.t216 7541.7583867527
Riso8570 DVSS_B DVSS_B.t218 15693.3752981411
Riso8571 DVSS_B DVSS_B.t225 43449.8820895777
Riso8572 DVSS_B DVSS_B.t236 29918.0804919305
Riso8573 DVSS_B DVSS_B.t238 4417.41484625725
Riso8574 DVSS_B DVSS_B.t240 28132.6540414021
Riso8575 DVSS_B DVSS_B.t250 14665.6490334733
Riso8576 DVSS_B DVSS_B.t252 5500.66359079463
Riso8577 DVSS_B DVSS_B.t256 11160.7142915026
Riso8578 DVSS_B DVSS_B.t258 22062.7302294534
Riso8579 DVSS_B DVSS_B.t259 697502.927661859
Riso8580 DVSS_B DVSS_B.t260 18001.8531407513
Riso8581 DVSS_B DVSS_B.t264 41388.3414069228
Riso8582 DVSS_B DVSS_B.t266 43449.8820895777
Riso8583 DVSS_B DVSS_B.t267 381657.964820394
Riso8584 DVSS_B DVSS_B.t268 3460.04081518002
Riso8585 DVSS_B DVSS_B.t271 3920.95454452972
Riso8586 DVSS_B DVSS_B.t273 15276.3927958289
Riso8587 DVSS_B DVSS_B.t275 7217.40238507337
Riso8588 DVSS_B DVSS_B.t277 32683.7292232367
Riso8589 DVSS_B DVSS_B.t279 26182.8624430329
Riso8590 DVSS_B DVSS_B.t281 43635.8870827085
Riso8591 DVSS_B DVSS_B.t283 7752.42335342824
Riso8592 DVSS_B DVSS_B.t285 15875.5456698221
Riso8593 DVSS_B DVSS_B.t287 15693.3752981411
Riso8594 DVSS_B DVSS_B.t288 1019248.02363762
Riso8595 DVSS_B DVSS_B.t289 10202.0692547234
Riso8596 DVSS_B DVSS_B.t291 43212.54824473
Riso8597 DVSS_B DVSS_B.t293 6072.98837297749
Riso8598 DVSS_B DVSS_B.t295 20003.666060659
Riso8599 DVSS_B DVSS_B.t297 12116.9982312661
Riso8600 DVSS_B DVSS_B.t299 6650.67512220911
Riso8601 DVSS_B DVSS_B.t301 38514.0312290991
Riso8602 DVSS_B DVSS_B.t302 4463612.3560583
Riso8603 DVSS_B DVSS_B.t303 38514.0312290991
Riso8604 DVSS_B DVSS_B.t305 11160.7142915026
Riso8605 DVSS_B DVSS_B.t322 8034.4031100331
Riso8606 DVSS_B DVSS_B.t325 3846279.3647797
Riso8607 DVSS_B DVSS_B.t326 33508.7923444358
Riso8608 DVSS_B DVSS_B.t329 122.430446564008
Riso8609 DVSS_B DVSS_B.t331 510.873851331844
Riso8610 DVSS_B DVSS_B.t333 468.385407375063
Riso8611 DVSS_B DVSS_B.t335 109.351750925435
Riso8612 DVSS_B DVSS_B.t337 201.771667897228
Riso8613 DVSS_B DVSS_B.t339 510.873851331844
Riso8614 DVSS_B DVSS_B.t341 468.385407375063
Riso8615 DVSS_B DVSS_B.t343 188.991825105421
Riso8616 DVSS_B DVSS_B.t345 794446.882163364
Riso8617 DVSS_B DVSS_B.t346 3165.83027376824
Riso8618 DVSS_B DVSS_B.t348 15276.3927958289
Riso8619 DVSS_B DVSS_B.t35 22062.7302294534
Riso8620 DVSS_B DVSS_B.t350 3920.95454452972
Riso8621 DVSS_B DVSS_B.t352 3460.04081518002
Riso8622 DVSS_B DVSS_B.t355 2704455.75964382
Riso8623 DVSS_B DVSS_B.t356 3945.51236506422
Riso8624 DVSS_B DVSS_B.t358 41388.3414069228
Riso8625 DVSS_B DVSS_B.t36 412024.683554008
Riso8626 DVSS_B DVSS_B.t360 31461.6884193068
Riso8627 DVSS_B DVSS_B.t364 43635.8870827085
Riso8628 DVSS_B DVSS_B.t366 42185.7326621352
Riso8629 DVSS_B DVSS_B.t37 6400.17378502755
Riso8630 DVSS_B DVSS_B.t509 42185.7326621352
Riso8631 DVSS_B DVSS_B.t515 13906.544356547
Riso8632 DVSS_B DVSS_B.t525 6939.29149441341
Riso8633 DVSS_B DVSS_B.t529 24139.2375703744
Riso8634 DVSS_B DVSS_B.t531 13906.544356547
Riso8635 DVSS_B DVSS_B.t59 697502.927661859
Riso8636 DVSS_B DVSS_B.t60 15792.613984897
Riso8637 DVSS_B DVSS_B.t66 13043.6058929264
Riso8638 DVSS_B DVSS_B.t68 6650.67512220911
Riso8639 DVSS_B DVSS_B.t70 32683.7292232367
Riso8640 DVSS_B DVSS_B.t72 42682.0485240721
Riso8641 DVSS_B DVSS_B.t74 8034.4031100331
Riso8642 DVSS_B DVSS_B.t76 4945.91343365601
Riso8643 DVSS_B DVSS_B.t80 5500.66359079463
Riso8644 DVSS_B DVSS_B.t82 7752.42335342824
Riso8645 DVSS_B DVSS_B.t84 6939.29149441341
Riso8646 DVSS_B DVSS_B.t89 3846279.3647797
Riso8647 DVSS_B DVSS_B.t90 37542.8489177158
Riso8648 DVSS_B DVSS_B.t94 31461.6884193068
Riso8649 DVSS_B DVSS_B.t96 39645.584751164
Riso8650 DVSS_B VSS_A 78.4212048403556
Riso8651 DVSS_B VSS_B 107.224154624354
Riso8652 DVSS_B.t10 DVSS_B.t100 369303.815648226
Riso8653 DVSS_B.t10 DVSS_B.t102 198082.916853826
Riso8654 DVSS_B.t10 DVSS_B.t11 25432.236702651
Riso8655 DVSS_B.t10 DVSS_B.t112 1289486.00402662
Riso8656 DVSS_B.t10 DVSS_B.t114 1345736.65194867
Riso8657 DVSS_B.t10 DVSS_B.t118 466231.353085917
Riso8658 DVSS_B.t10 DVSS_B.t120 602535.944755005
Riso8659 DVSS_B.t10 DVSS_B.t124 858697.821663611
Riso8660 DVSS_B.t10 DVSS_B.t132 123444.774832222
Riso8661 DVSS_B.t10 DVSS_B.t134 540879.412141122
Riso8662 DVSS_B.t10 DVSS_B.t143 731560.649265639
Riso8663 DVSS_B.t10 DVSS_B.t148 5188986.53806955
Riso8664 DVSS_B.t10 DVSS_B.t149 70219.93625987
Riso8665 DVSS_B.t10 DVSS_B.t151 420762.690660686
Riso8666 DVSS_B.t10 DVSS_B.t153 467543.745508734
Riso8667 DVSS_B.t10 DVSS_B.t155 1243099.76043233
Riso8668 DVSS_B.t10 DVSS_B.t157 227052.15050408
Riso8669 DVSS_B.t10 DVSS_B.t159 137202.368042778
Riso8670 DVSS_B.t10 DVSS_B.t161 341160.238489079
Riso8671 DVSS_B.t10 DVSS_B.t162 28438522.7920561
Riso8672 DVSS_B.t10 DVSS_B.t163 227052.15050408
Riso8673 DVSS_B.t10 DVSS_B.t165 1289486.00402662
Riso8674 DVSS_B.t10 DVSS_B.t167 1370324.66895131
Riso8675 DVSS_B.t10 DVSS_B.t169 166950.317938087
Riso8676 DVSS_B.t10 DVSS_B.t173 513694.265870975
Riso8677 DVSS_B.t10 DVSS_B.t177 284745.150270824
Riso8678 DVSS_B.t10 DVSS_B.t20 356.859771215075
Riso8679 DVSS_B.t10 DVSS_B.t202 513694.265870975
Riso8680 DVSS_B.t10 DVSS_B.t204 1037798.14358347
Riso8681 DVSS_B.t10 DVSS_B.t206 796261.304702999
Riso8682 DVSS_B.t10 DVSS_B.t21 59560.6530117236
Riso8683 DVSS_B.t10 DVSS_B.t212 916631.217883237
Riso8684 DVSS_B.t10 DVSS_B.t214 1173593.58069559
Riso8685 DVSS_B.t10 DVSS_B.t215 5274775.74933857
Riso8686 DVSS_B.t10 DVSS_B.t216 70219.93625987
Riso8687 DVSS_B.t10 DVSS_B.t218 457189.509706948
Riso8688 DVSS_B.t10 DVSS_B.t225 1373130.72511225
Riso8689 DVSS_B.t10 DVSS_B.t236 916631.217883237
Riso8690 DVSS_B.t10 DVSS_B.t238 123444.774832222
Riso8691 DVSS_B.t10 DVSS_B.t240 858697.821663611
Riso8692 DVSS_B.t10 DVSS_B.t250 420762.690660686
Riso8693 DVSS_B.t10 DVSS_B.t252 151759.784819753
Riso8694 DVSS_B.t10 DVSS_B.t256 312734.221258633
Riso8695 DVSS_B.t10 DVSS_B.t258 666481.514587955
Riso8696 DVSS_B.t10 DVSS_B.t259 21633955.7463381
Riso8697 DVSS_B.t10 DVSS_B.t260 540879.412141122
Riso8698 DVSS_B.t10 DVSS_B.t264 1301498.47152222
Riso8699 DVSS_B.t10 DVSS_B.t266 1373130.72511225
Riso8700 DVSS_B.t10 DVSS_B.t267 10896286.1335758
Riso8701 DVSS_B.t10 DVSS_B.t268 98664.9574216882
Riso8702 DVSS_B.t10 DVSS_B.t271 110583.807161114
Riso8703 DVSS_B.t10 DVSS_B.t273 441566.938771487
Riso8704 DVSS_B.t10 DVSS_B.t275 198082.916853826
Riso8705 DVSS_B.t10 DVSS_B.t277 1008787.94501115
Riso8706 DVSS_B.t10 DVSS_B.t279 796261.304702999
Riso8707 DVSS_B.t10 DVSS_B.t281 1381676.19652396
Riso8708 DVSS_B.t10 DVSS_B.t283 213145.176148565
Riso8709 DVSS_B.t10 DVSS_B.t285 466231.353085917
Riso8710 DVSS_B.t10 DVSS_B.t287 457189.509706948
Riso8711 DVSS_B.t10 DVSS_B.t288 28438522.7920561
Riso8712 DVSS_B.t10 DVSS_B.t289 284745.150270824
Riso8713 DVSS_B.t10 DVSS_B.t291 1370324.66895131
Riso8714 DVSS_B.t10 DVSS_B.t293 166950.317938087
Riso8715 DVSS_B.t10 DVSS_B.t295 602535.944755005
Riso8716 DVSS_B.t10 DVSS_B.t297 341160.238489079
Riso8717 DVSS_B.t10 DVSS_B.t299 182515.633994591
Riso8718 DVSS_B.t10 DVSS_B.t301 1223625.90891248
Riso8719 DVSS_B.t10 DVSS_B.t302 141539667.332282
Riso8720 DVSS_B.t10 DVSS_B.t303 1223625.90891248
Riso8721 DVSS_B.t10 DVSS_B.t305 312734.221258633
Riso8722 DVSS_B.t10 DVSS_B.t322 570475.461987277
Riso8723 DVSS_B.t10 DVSS_B.t325 119584344.320919
Riso8724 DVSS_B.t10 DVSS_B.t326 1037798.14358347
Riso8725 DVSS_B.t10 DVSS_B.t329 75276.0673660709
Riso8726 DVSS_B.t10 DVSS_B.t331 131645.240549778
Riso8727 DVSS_B.t10 DVSS_B.t333 107162.363083937
Riso8728 DVSS_B.t10 DVSS_B.t335 62049.662808775
Riso8729 DVSS_B.t10 DVSS_B.t337 64040.0514513845
Riso8730 DVSS_B.t10 DVSS_B.t339 131645.240549778
Riso8731 DVSS_B.t10 DVSS_B.t341 107162.363083937
Riso8732 DVSS_B.t10 DVSS_B.t343 48366.4181171991
Riso8733 DVSS_B.t10 DVSS_B.t345 77855125.3671369
Riso8734 DVSS_B.t10 DVSS_B.t346 296872.254029249
Riso8735 DVSS_B.t10 DVSS_B.t348 441566.938771487
Riso8736 DVSS_B.t10 DVSS_B.t35 666481.514587955
Riso8737 DVSS_B.t10 DVSS_B.t350 110583.807161114
Riso8738 DVSS_B.t10 DVSS_B.t352 98664.9574216882
Riso8739 DVSS_B.t10 DVSS_B.t355 236212709.859182
Riso8740 DVSS_B.t10 DVSS_B.t356 311323.314048971
Riso8741 DVSS_B.t10 DVSS_B.t358 1301498.47152222
Riso8742 DVSS_B.t10 DVSS_B.t36 3667950.54966435
Riso8743 DVSS_B.t10 DVSS_B.t360 967544.529394009
Riso8744 DVSS_B.t10 DVSS_B.t364 1381676.19652396
Riso8745 DVSS_B.t10 DVSS_B.t366 1339168.61908583
Riso8746 DVSS_B.t10 DVSS_B.t37 59560.6530117236
Riso8747 DVSS_B.t10 DVSS_B.t509 1339168.61908583
Riso8748 DVSS_B.t10 DVSS_B.t515 396225.277024624
Riso8749 DVSS_B.t10 DVSS_B.t525 509330.730892533
Riso8750 DVSS_B.t10 DVSS_B.t529 731560.649265639
Riso8751 DVSS_B.t10 DVSS_B.t531 396225.277024624
Riso8752 DVSS_B.t10 DVSS_B.t59 21633955.7463381
Riso8753 DVSS_B.t10 DVSS_B.t60 467543.745508734
Riso8754 DVSS_B.t10 DVSS_B.t66 369303.815648226
Riso8755 DVSS_B.t10 DVSS_B.t68 182515.633994591
Riso8756 DVSS_B.t10 DVSS_B.t70 1008787.94501115
Riso8757 DVSS_B.t10 DVSS_B.t72 1345736.65194867
Riso8758 DVSS_B.t10 DVSS_B.t74 570475.461987277
Riso8759 DVSS_B.t10 DVSS_B.t76 137202.368042778
Riso8760 DVSS_B.t10 DVSS_B.t80 151759.784819753
Riso8761 DVSS_B.t10 DVSS_B.t82 213145.176148565
Riso8762 DVSS_B.t10 DVSS_B.t84 509330.730892533
Riso8763 DVSS_B.t10 DVSS_B.t89 119584344.320919
Riso8764 DVSS_B.t10 DVSS_B.t90 1173593.58069559
Riso8765 DVSS_B.t10 DVSS_B.t94 967544.529394009
Riso8766 DVSS_B.t10 DVSS_B.t96 1243099.76043233
Riso8767 DVSS_B.t10 VSS_A 261811.280381318
Riso8768 DVSS_B.t10 VSS_B 28909.0249271396
Riso8769 DVSS_B.t100 DVSS_B.t102 112.173590416118
Riso8770 DVSS_B.t100 DVSS_B.t11 355.860509855324
Riso8771 DVSS_B.t100 DVSS_B.t112 559.89400534837
Riso8772 DVSS_B.t100 DVSS_B.t114 522.72276912972
Riso8773 DVSS_B.t100 DVSS_B.t118 76.4050427211984
Riso8774 DVSS_B.t100 DVSS_B.t120 150.756325539281
Riso8775 DVSS_B.t100 DVSS_B.t124 246.624640197016
Riso8776 DVSS_B.t100 DVSS_B.t132 200.873646577457
Riso8777 DVSS_B.t100 DVSS_B.t134 130.970490568235
Riso8778 DVSS_B.t100 DVSS_B.t143 195.811015301425
Riso8779 DVSS_B.t100 DVSS_B.t148 71571.5417122216
Riso8780 DVSS_B.t100 DVSS_B.t149 975.390915890718
Riso8781 DVSS_B.t100 DVSS_B.t151 48.0874934445253
Riso8782 DVSS_B.t100 DVSS_B.t153 87.4069242797085
Riso8783 DVSS_B.t100 DVSS_B.t155 461.872991728401
Riso8784 DVSS_B.t100 DVSS_B.t157 83.3460413099905
Riso8785 DVSS_B.t100 DVSS_B.t159 183.099405969178
Riso8786 DVSS_B.t100 DVSS_B.t161 40.195373193485
Riso8787 DVSS_B.t100 DVSS_B.t162 8098.82253532833
Riso8788 DVSS_B.t100 DVSS_B.t163 83.3460413099905
Riso8789 DVSS_B.t100 DVSS_B.t165 559.89400534837
Riso8790 DVSS_B.t100 DVSS_B.t167 570.047053121932
Riso8791 DVSS_B.t100 DVSS_B.t169 146.294854276344
Riso8792 DVSS_B.t100 DVSS_B.t173 968.233469880474
Riso8793 DVSS_B.t100 DVSS_B.t177 54.1270416819037
Riso8794 DVSS_B.t100 DVSS_B.t20 70647.0877514356
Riso8795 DVSS_B.t100 DVSS_B.t202 968.233469880474
Riso8796 DVSS_B.t100 DVSS_B.t204 345.922641505063
Riso8797 DVSS_B.t100 DVSS_B.t206 220.684588107135
Riso8798 DVSS_B.t100 DVSS_B.t21 827.77919494209
Riso8799 DVSS_B.t100 DVSS_B.t212 273.034318536977
Riso8800 DVSS_B.t100 DVSS_B.t214 426.881819674908
Riso8801 DVSS_B.t100 DVSS_B.t215 72754.8298298054
Riso8802 DVSS_B.t100 DVSS_B.t216 975.390915890718
Riso8803 DVSS_B.t100 DVSS_B.t218 66.0506712423182
Riso8804 DVSS_B.t100 DVSS_B.t225 545.709058089536
Riso8805 DVSS_B.t100 DVSS_B.t236 273.034318536977
Riso8806 DVSS_B.t100 DVSS_B.t238 200.873646577457
Riso8807 DVSS_B.t100 DVSS_B.t240 246.624640197016
Riso8808 DVSS_B.t100 DVSS_B.t250 48.0874934445253
Riso8809 DVSS_B.t100 DVSS_B.t252 164.634914885224
Riso8810 DVSS_B.t100 DVSS_B.t256 46.924530296379
Riso8811 DVSS_B.t100 DVSS_B.t258 172.415494815057
Riso8812 DVSS_B.t100 DVSS_B.t259 15036.8696187872
Riso8813 DVSS_B.t100 DVSS_B.t260 130.970490568235
Riso8814 DVSS_B.t100 DVSS_B.t264 494.290952997161
Riso8815 DVSS_B.t100 DVSS_B.t266 545.709058089536
Riso8816 DVSS_B.t100 DVSS_B.t267 33729.4466371033
Riso8817 DVSS_B.t100 DVSS_B.t268 230.110613906647
Riso8818 DVSS_B.t100 DVSS_B.t271 216.934107735306
Riso8819 DVSS_B.t100 DVSS_B.t273 56.5755788823354
Riso8820 DVSS_B.t100 DVSS_B.t275 112.173590416118
Riso8821 DVSS_B.t100 DVSS_B.t277 323.810839270678
Riso8822 DVSS_B.t100 DVSS_B.t279 220.684588107135
Riso8823 DVSS_B.t100 DVSS_B.t281 561.868239519592
Riso8824 DVSS_B.t100 DVSS_B.t283 97.0267297455866
Riso8825 DVSS_B.t100 DVSS_B.t285 76.4050427211984
Riso8826 DVSS_B.t100 DVSS_B.t287 66.0506712423182
Riso8827 DVSS_B.t100 DVSS_B.t288 8098.82253532833
Riso8828 DVSS_B.t100 DVSS_B.t289 54.1270416819037
Riso8829 DVSS_B.t100 DVSS_B.t291 570.047053121932
Riso8830 DVSS_B.t100 DVSS_B.t293 146.294854276344
Riso8831 DVSS_B.t100 DVSS_B.t295 150.756325539281
Riso8832 DVSS_B.t100 DVSS_B.t297 40.195373193485
Riso8833 DVSS_B.t100 DVSS_B.t299 128.674992451353
Riso8834 DVSS_B.t100 DVSS_B.t301 541.623994642638
Riso8835 DVSS_B.t100 DVSS_B.t302 66106.7095628215
Riso8836 DVSS_B.t100 DVSS_B.t303 541.623994642638
Riso8837 DVSS_B.t100 DVSS_B.t305 46.924530296379
Riso8838 DVSS_B.t100 DVSS_B.t322 1082.63023240449
Riso8839 DVSS_B.t100 DVSS_B.t325 43869.1655051334
Riso8840 DVSS_B.t100 DVSS_B.t326 345.922641505063
Riso8841 DVSS_B.t100 DVSS_B.t329 297.10916962501
Riso8842 DVSS_B.t100 DVSS_B.t331 565.579555330821
Riso8843 DVSS_B.t100 DVSS_B.t333 541.256876162163
Riso8844 DVSS_B.t100 DVSS_B.t335 292.336413429484
Riso8845 DVSS_B.t100 DVSS_B.t337 255.44192530103
Riso8846 DVSS_B.t100 DVSS_B.t339 565.579555330821
Riso8847 DVSS_B.t100 DVSS_B.t341 541.256876162163
Riso8848 DVSS_B.t100 DVSS_B.t343 225.059811807008
Riso8849 DVSS_B.t100 DVSS_B.t345 104062.666200959
Riso8850 DVSS_B.t100 DVSS_B.t346 381.633552762014
Riso8851 DVSS_B.t100 DVSS_B.t348 56.5755788823354
Riso8852 DVSS_B.t100 DVSS_B.t35 172.415494815057
Riso8853 DVSS_B.t100 DVSS_B.t350 216.934107735306
Riso8854 DVSS_B.t100 DVSS_B.t352 230.110613906647
Riso8855 DVSS_B.t100 DVSS_B.t355 333360.455969984
Riso8856 DVSS_B.t100 DVSS_B.t356 506.670559677789
Riso8857 DVSS_B.t100 DVSS_B.t358 494.290952997161
Riso8858 DVSS_B.t100 DVSS_B.t36 53366.5101358037
Riso8859 DVSS_B.t100 DVSS_B.t360 299.105750131553
Riso8860 DVSS_B.t100 DVSS_B.t364 561.868239519592
Riso8861 DVSS_B.t100 DVSS_B.t366 569.475337688933
Riso8862 DVSS_B.t100 DVSS_B.t37 827.77919494209
Riso8863 DVSS_B.t100 DVSS_B.t509 569.475337688933
Riso8864 DVSS_B.t100 DVSS_B.t515 40.6074955465765
Riso8865 DVSS_B.t100 DVSS_B.t525 920.283831422959
Riso8866 DVSS_B.t100 DVSS_B.t529 195.811015301425
Riso8867 DVSS_B.t100 DVSS_B.t531 40.6074955465765
Riso8868 DVSS_B.t100 DVSS_B.t59 15036.8696187872
Riso8869 DVSS_B.t100 DVSS_B.t60 87.4069242797085
Riso8870 DVSS_B.t100 DVSS_B.t66 0.0669634404674486
Riso8871 DVSS_B.t100 DVSS_B.t68 128.674992451353
Riso8872 DVSS_B.t100 DVSS_B.t70 323.810839270678
Riso8873 DVSS_B.t100 DVSS_B.t72 522.72276912972
Riso8874 DVSS_B.t100 DVSS_B.t74 1082.63023240449
Riso8875 DVSS_B.t100 DVSS_B.t76 183.099405969178
Riso8876 DVSS_B.t100 DVSS_B.t80 164.634914885224
Riso8877 DVSS_B.t100 DVSS_B.t82 97.0267297455866
Riso8878 DVSS_B.t100 DVSS_B.t84 920.283831422959
Riso8879 DVSS_B.t100 DVSS_B.t89 43869.1655051334
Riso8880 DVSS_B.t100 DVSS_B.t90 426.881819674908
Riso8881 DVSS_B.t100 DVSS_B.t94 299.105750131553
Riso8882 DVSS_B.t100 DVSS_B.t96 461.872991728401
Riso8883 DVSS_B.t100 VSS_A 1026.55852412479
Riso8884 DVSS_B.t100 VSS_B 157.228841033248
Riso8885 DVSS_B.t101 DVSS_B.t274 66.3487
Riso8886 DVSS_B.t101 DVSS_B.t298 66.3487
Riso8887 DVSS_B.t102 DVSS_B.t11 182.241308849428
Riso8888 DVSS_B.t102 DVSS_B.t112 964.774618085351
Riso8889 DVSS_B.t102 DVSS_B.t114 938.691424580031
Riso8890 DVSS_B.t102 DVSS_B.t118 207.345480322493
Riso8891 DVSS_B.t102 DVSS_B.t120 342.804669472169
Riso8892 DVSS_B.t102 DVSS_B.t124 514.486696016195
Riso8893 DVSS_B.t102 DVSS_B.t132 71.0243998897834
Riso8894 DVSS_B.t102 DVSS_B.t134 304.525612104377
Riso8895 DVSS_B.t102 DVSS_B.t143 426.132133170982
Riso8896 DVSS_B.t102 DVSS_B.t148 36620.1177138528
Riso8897 DVSS_B.t102 DVSS_B.t149 499.285736972116
Riso8898 DVSS_B.t102 DVSS_B.t151 147.473784546657
Riso8899 DVSS_B.t102 DVSS_B.t153 226.599250324412
Riso8900 DVSS_B.t102 DVSS_B.t155 846.859036807886
Riso8901 DVSS_B.t102 DVSS_B.t157 45.1930296028835
Riso8902 DVSS_B.t102 DVSS_B.t159 62.3777961031311
Riso8903 DVSS_B.t102 DVSS_B.t161 96.7923944972666
Riso8904 DVSS_B.t102 DVSS_B.t162 6836.61190771296
Riso8905 DVSS_B.t102 DVSS_B.t163 45.1930296028835
Riso8906 DVSS_B.t102 DVSS_B.t165 964.774618085351
Riso8907 DVSS_B.t102 DVSS_B.t167 996.354394714662
Riso8908 DVSS_B.t102 DVSS_B.t169 46.3695435855487
Riso8909 DVSS_B.t102 DVSS_B.t173 372.541745736499
Riso8910 DVSS_B.t102 DVSS_B.t177 70.7923747934473
Riso8911 DVSS_B.t102 DVSS_B.t20 36200.1342263067
Riso8912 DVSS_B.t102 DVSS_B.t202 372.541745736499
Riso8913 DVSS_B.t102 DVSS_B.t204 668.708267486351
Riso8914 DVSS_B.t102 DVSS_B.t206 470.094852276946
Riso8915 DVSS_B.t102 DVSS_B.t21 423.743903210092
Riso8916 DVSS_B.t102 DVSS_B.t212 558.140652804569
Riso8917 DVSS_B.t102 DVSS_B.t214 791.360055108464
Riso8918 DVSS_B.t102 DVSS_B.t215 37225.5559804971
Riso8919 DVSS_B.t102 DVSS_B.t216 499.285736972116
Riso8920 DVSS_B.t102 DVSS_B.t218 187.160613669425
Riso8921 DVSS_B.t102 DVSS_B.t225 970.549336675552
Riso8922 DVSS_B.t102 DVSS_B.t236 558.140652804569
Riso8923 DVSS_B.t102 DVSS_B.t238 71.0243998897834
Riso8924 DVSS_B.t102 DVSS_B.t240 514.486696016195
Riso8925 DVSS_B.t102 DVSS_B.t250 147.473784546657
Riso8926 DVSS_B.t102 DVSS_B.t252 54.0715647470047
Riso8927 DVSS_B.t102 DVSS_B.t256 83.0088962623749
Riso8928 DVSS_B.t102 DVSS_B.t258 383.487176941639
Riso8929 DVSS_B.t102 DVSS_B.t259 23342.1869750397
Riso8930 DVSS_B.t102 DVSS_B.t260 304.525612104377
Riso8931 DVSS_B.t102 DVSS_B.t264 896.718811409304
Riso8932 DVSS_B.t102 DVSS_B.t266 970.549336675552
Riso8933 DVSS_B.t102 DVSS_B.t267 14162.0080117691
Riso8934 DVSS_B.t102 DVSS_B.t268 87.5341738555542
Riso8935 DVSS_B.t102 DVSS_B.t271 79.5988515013726
Riso8936 DVSS_B.t102 DVSS_B.t273 166.975895614226
Riso8937 DVSS_B.t102 DVSS_B.t275 0.066960101104887
Riso8938 DVSS_B.t102 DVSS_B.t277 637.102543600184
Riso8939 DVSS_B.t102 DVSS_B.t279 470.094852276946
Riso8940 DVSS_B.t102 DVSS_B.t281 990.287931312109
Riso8941 DVSS_B.t102 DVSS_B.t283 38.9922172064633
Riso8942 DVSS_B.t102 DVSS_B.t285 207.345480322493
Riso8943 DVSS_B.t102 DVSS_B.t287 187.160613669425
Riso8944 DVSS_B.t102 DVSS_B.t288 6836.61190771296
Riso8945 DVSS_B.t102 DVSS_B.t289 70.7923747934473
Riso8946 DVSS_B.t102 DVSS_B.t291 996.354394714662
Riso8947 DVSS_B.t102 DVSS_B.t293 46.3695435855487
Riso8948 DVSS_B.t102 DVSS_B.t295 342.804669472169
Riso8949 DVSS_B.t102 DVSS_B.t297 96.7923944972666
Riso8950 DVSS_B.t102 DVSS_B.t299 39.4136326458607
Riso8951 DVSS_B.t102 DVSS_B.t301 927.927259398487
Riso8952 DVSS_B.t102 DVSS_B.t302 111680.887757071
Riso8953 DVSS_B.t102 DVSS_B.t303 927.927259398487
Riso8954 DVSS_B.t102 DVSS_B.t305 83.0088962623749
Riso8955 DVSS_B.t102 DVSS_B.t322 414.173813857573
Riso8956 DVSS_B.t102 DVSS_B.t325 81808.2106978936
Riso8957 DVSS_B.t102 DVSS_B.t326 668.708267486351
Riso8958 DVSS_B.t102 DVSS_B.t329 161.258783367274
Riso8959 DVSS_B.t102 DVSS_B.t331 297.73501043599
Riso8960 DVSS_B.t102 DVSS_B.t333 284.118742144659
Riso8961 DVSS_B.t102 DVSS_B.t335 157.373968703747
Riso8962 DVSS_B.t102 DVSS_B.t337 136.43114210163
Riso8963 DVSS_B.t102 DVSS_B.t339 297.73501043599
Riso8964 DVSS_B.t102 DVSS_B.t341 284.118742144659
Riso8965 DVSS_B.t102 DVSS_B.t343 118.369845701119
Riso8966 DVSS_B.t102 DVSS_B.t345 52938.6052543182
Riso8967 DVSS_B.t102 DVSS_B.t346 199.304738309426
Riso8968 DVSS_B.t102 DVSS_B.t348 166.975895614226
Riso8969 DVSS_B.t102 DVSS_B.t35 383.487176941639
Riso8970 DVSS_B.t102 DVSS_B.t350 79.5988515013726
Riso8971 DVSS_B.t102 DVSS_B.t352 87.5341738555542
Riso8972 DVSS_B.t102 DVSS_B.t355 163011.656287004
Riso8973 DVSS_B.t102 DVSS_B.t356 220.183962218783
Riso8974 DVSS_B.t102 DVSS_B.t358 896.718811409304
Riso8975 DVSS_B.t102 DVSS_B.t36 27345.4276969314
Riso8976 DVSS_B.t102 DVSS_B.t360 599.593838189234
Riso8977 DVSS_B.t102 DVSS_B.t364 990.287931312109
Riso8978 DVSS_B.t102 DVSS_B.t366 987.866371451613
Riso8979 DVSS_B.t102 DVSS_B.t37 423.743903210092
Riso8980 DVSS_B.t102 DVSS_B.t509 987.866371451613
Riso8981 DVSS_B.t102 DVSS_B.t515 129.113764989152
Riso8982 DVSS_B.t102 DVSS_B.t525 366.833217981355
Riso8983 DVSS_B.t102 DVSS_B.t529 426.132133170982
Riso8984 DVSS_B.t102 DVSS_B.t531 129.113764989152
Riso8985 DVSS_B.t102 DVSS_B.t59 23342.1869750397
Riso8986 DVSS_B.t102 DVSS_B.t60 226.599250324412
Riso8987 DVSS_B.t102 DVSS_B.t66 112.173590416118
Riso8988 DVSS_B.t102 DVSS_B.t68 39.4136326458607
Riso8989 DVSS_B.t102 DVSS_B.t70 637.102543600184
Riso8990 DVSS_B.t102 DVSS_B.t72 938.691424580031
Riso8991 DVSS_B.t102 DVSS_B.t74 414.173813857573
Riso8992 DVSS_B.t102 DVSS_B.t76 62.3777961031311
Riso8993 DVSS_B.t102 DVSS_B.t80 54.0715647470047
Riso8994 DVSS_B.t102 DVSS_B.t82 38.9922172064633
Riso8995 DVSS_B.t102 DVSS_B.t84 366.833217981355
Riso8996 DVSS_B.t102 DVSS_B.t89 81808.2106978936
Riso8997 DVSS_B.t102 DVSS_B.t90 791.360055108464
Riso8998 DVSS_B.t102 DVSS_B.t94 599.593838189234
Riso8999 DVSS_B.t102 DVSS_B.t96 846.859036807886
Riso9000 DVSS_B.t102 VSS_A 561.969757266806
Riso9001 DVSS_B.t102 VSS_B 90.3235328205559
Riso9002 DVSS_B.t11 DVSS_B.t112 1439.00266567253
Riso9003 DVSS_B.t11 DVSS_B.t114 1475.38460112842
Riso9004 DVSS_B.t11 DVSS_B.t118 475.399816761629
Riso9005 DVSS_B.t11 DVSS_B.t120 637.781467072537
Riso9006 DVSS_B.t11 DVSS_B.t124 911.211697354089
Riso9007 DVSS_B.t11 DVSS_B.t132 111.691296314853
Riso9008 DVSS_B.t11 DVSS_B.t134 573.106354371302
Riso9009 DVSS_B.t11 DVSS_B.t143 774.236408667729
Riso9010 DVSS_B.t11 DVSS_B.t148 1716.96764784831
Riso9011 DVSS_B.t11 DVSS_B.t149 23.145581808933
Riso9012 DVSS_B.t11 DVSS_B.t151 412.791221171373
Riso9013 DVSS_B.t11 DVSS_B.t153 484.268780562072
Riso9014 DVSS_B.t11 DVSS_B.t155 1354.66583131314
Riso9015 DVSS_B.t11 DVSS_B.t157 211.427063538163
Riso9016 DVSS_B.t11 DVSS_B.t159 124.400741876502
Riso9017 DVSS_B.t11 DVSS_B.t161 326.48448810707
Riso9018 DVSS_B.t11 DVSS_B.t162 27051.2917152781
Riso9019 DVSS_B.t11 DVSS_B.t163 211.427063538163
Riso9020 DVSS_B.t11 DVSS_B.t165 1439.00266567253
Riso9021 DVSS_B.t11 DVSS_B.t167 1518.42962198887
Riso9022 DVSS_B.t11 DVSS_B.t169 152.268145802403
Riso9023 DVSS_B.t11 DVSS_B.t173 468.116966333727
Riso9024 DVSS_B.t11 DVSS_B.t177 269.67958213877
Riso9025 DVSS_B.t11 DVSS_B.t20 1699.71614040473
Riso9026 DVSS_B.t11 DVSS_B.t202 468.116966333727
Riso9027 DVSS_B.t11 DVSS_B.t204 1116.47150194934
Riso9028 DVSS_B.t11 DVSS_B.t206 843.524570746272
Riso9029 DVSS_B.t11 DVSS_B.t21 19.6189355513037
Riso9030 DVSS_B.t11 DVSS_B.t212 975.057134077737
Riso9031 DVSS_B.t11 DVSS_B.t214 1275.7214055338
Riso9032 DVSS_B.t11 DVSS_B.t215 1745.35417365689
Riso9033 DVSS_B.t11 DVSS_B.t216 23.145581808933
Riso9034 DVSS_B.t11 DVSS_B.t218 459.514319997494
Riso9035 DVSS_B.t11 DVSS_B.t225 1510.57306987271
Riso9036 DVSS_B.t11 DVSS_B.t236 975.057134077737
Riso9037 DVSS_B.t11 DVSS_B.t238 111.691296314853
Riso9038 DVSS_B.t11 DVSS_B.t240 911.211697354089
Riso9039 DVSS_B.t11 DVSS_B.t250 412.791221171373
Riso9040 DVSS_B.t11 DVSS_B.t252 137.963569875017
Riso9041 DVSS_B.t11 DVSS_B.t256 297.578657195639
Riso9042 DVSS_B.t11 DVSS_B.t258 705.179066064563
Riso9043 DVSS_B.t11 DVSS_B.t259 25914.1701141827
Riso9044 DVSS_B.t11 DVSS_B.t260 573.106354371302
Riso9045 DVSS_B.t11 DVSS_B.t264 1422.36719256255
Riso9046 DVSS_B.t11 DVSS_B.t266 1510.57306987271
Riso9047 DVSS_B.t11 DVSS_B.t267 9896.6227542412
Riso9048 DVSS_B.t11 DVSS_B.t268 89.0113648375141
Riso9049 DVSS_B.t11 DVSS_B.t271 99.8899409403253
Riso9050 DVSS_B.t11 DVSS_B.t273 438.124540092542
Riso9051 DVSS_B.t11 DVSS_B.t275 182.241308849428
Riso9052 DVSS_B.t11 DVSS_B.t277 1080.55953036303
Riso9053 DVSS_B.t11 DVSS_B.t279 843.524570746272
Riso9054 DVSS_B.t11 DVSS_B.t281 1525.43015971491
Riso9055 DVSS_B.t11 DVSS_B.t283 197.197855534785
Riso9056 DVSS_B.t11 DVSS_B.t285 475.399816761629
Riso9057 DVSS_B.t11 DVSS_B.t287 459.514319997494
Riso9058 DVSS_B.t11 DVSS_B.t288 27051.2917152781
Riso9059 DVSS_B.t11 DVSS_B.t289 269.67958213877
Riso9060 DVSS_B.t11 DVSS_B.t291 1518.42962198887
Riso9061 DVSS_B.t11 DVSS_B.t293 152.268145802403
Riso9062 DVSS_B.t11 DVSS_B.t295 637.781467072537
Riso9063 DVSS_B.t11 DVSS_B.t297 326.48448810707
Riso9064 DVSS_B.t11 DVSS_B.t299 167.124793547054
Riso9065 DVSS_B.t11 DVSS_B.t301 1369.92225006029
Riso9066 DVSS_B.t11 DVSS_B.t302 159859.209903544
Riso9067 DVSS_B.t11 DVSS_B.t303 1369.92225006029
Riso9068 DVSS_B.t11 DVSS_B.t305 297.578657195639
Riso9069 DVSS_B.t11 DVSS_B.t322 519.96914752187
Riso9070 DVSS_B.t11 DVSS_B.t325 130417.67661762
Riso9071 DVSS_B.t11 DVSS_B.t326 1116.47150194934
Riso9072 DVSS_B.t11 DVSS_B.t329 72.9832284845657
Riso9073 DVSS_B.t11 DVSS_B.t331 126.806027788738
Riso9074 DVSS_B.t11 DVSS_B.t333 102.918922928151
Riso9075 DVSS_B.t11 DVSS_B.t335 60.0881853190897
Riso9076 DVSS_B.t11 DVSS_B.t337 60.645330899112
Riso9077 DVSS_B.t11 DVSS_B.t339 126.806027788738
Riso9078 DVSS_B.t11 DVSS_B.t341 102.918922928151
Riso9079 DVSS_B.t11 DVSS_B.t343 45.3734875422525
Riso9080 DVSS_B.t11 DVSS_B.t345 70174.6141505575
Riso9081 DVSS_B.t11 DVSS_B.t346 270.04832101314
Riso9082 DVSS_B.t11 DVSS_B.t348 438.124540092542
Riso9083 DVSS_B.t11 DVSS_B.t35 705.179066064563
Riso9084 DVSS_B.t11 DVSS_B.t350 99.8899409403253
Riso9085 DVSS_B.t11 DVSS_B.t352 89.0113648375141
Riso9086 DVSS_B.t11 DVSS_B.t355 211568.685698257
Riso9087 DVSS_B.t11 DVSS_B.t356 282.328611382725
Riso9088 DVSS_B.t11 DVSS_B.t358 1422.36719256255
Riso9089 DVSS_B.t11 DVSS_B.t36 1283.95835584964
Riso9090 DVSS_B.t11 DVSS_B.t360 1032.45665756896
Riso9091 DVSS_B.t11 DVSS_B.t364 1525.43015971491
Riso9092 DVSS_B.t11 DVSS_B.t366 1489.27388343188
Riso9093 DVSS_B.t11 DVSS_B.t37 19.6189355513037
Riso9094 DVSS_B.t11 DVSS_B.t509 1489.27388343188
Riso9095 DVSS_B.t11 DVSS_B.t515 384.958703506134
Riso9096 DVSS_B.t11 DVSS_B.t525 463.525426927687
Riso9097 DVSS_B.t11 DVSS_B.t529 774.236408667729
Riso9098 DVSS_B.t11 DVSS_B.t531 384.958703506134
Riso9099 DVSS_B.t11 DVSS_B.t59 25914.1701141827
Riso9100 DVSS_B.t11 DVSS_B.t60 484.268780562072
Riso9101 DVSS_B.t11 DVSS_B.t66 355.860509855324
Riso9102 DVSS_B.t11 DVSS_B.t68 167.124793547054
Riso9103 DVSS_B.t11 DVSS_B.t70 1080.55953036303
Riso9104 DVSS_B.t11 DVSS_B.t72 1475.38460112842
Riso9105 DVSS_B.t11 DVSS_B.t74 519.96914752187
Riso9106 DVSS_B.t11 DVSS_B.t76 124.400741876502
Riso9107 DVSS_B.t11 DVSS_B.t80 137.963569875017
Riso9108 DVSS_B.t11 DVSS_B.t82 197.197855534785
Riso9109 DVSS_B.t11 DVSS_B.t84 463.525426927687
Riso9110 DVSS_B.t11 DVSS_B.t89 130417.67661762
Riso9111 DVSS_B.t11 DVSS_B.t90 1275.7214055338
Riso9112 DVSS_B.t11 DVSS_B.t94 1032.45665756896
Riso9113 DVSS_B.t11 DVSS_B.t96 1354.66583131314
Riso9114 DVSS_B.t11 VSS_A 256.963588112304
Riso9115 DVSS_B.t11 VSS_B 30.9704507762154
Riso9116 DVSS_B.t111 DVSS_B.t164 66.3487
Riso9117 DVSS_B.t111 DVSS_B.t300 66.3487
Riso9118 DVSS_B.t112 DVSS_B.t114 51.9743475156552
Riso9119 DVSS_B.t112 DVSS_B.t118 349.650379585254
Riso9120 DVSS_B.t112 DVSS_B.t120 237.772304343155
Riso9121 DVSS_B.t112 DVSS_B.t124 171.045004423548
Riso9122 DVSS_B.t112 DVSS_B.t132 1232.61419372744
Riso9123 DVSS_B.t112 DVSS_B.t134 249.996583362437
Riso9124 DVSS_B.t112 DVSS_B.t143 206.219303014057
Riso9125 DVSS_B.t112 DVSS_B.t148 289638.733760529
Riso9126 DVSS_B.t112 DVSS_B.t149 3949.07158768492
Riso9127 DVSS_B.t112 DVSS_B.t151 472.993773132697
Riso9128 DVSS_B.t112 DVSS_B.t153 312.62790815385
Riso9129 DVSS_B.t112 DVSS_B.t155 67.3816326394865
Riso9130 DVSS_B.t112 DVSS_B.t157 821.05872182601
Riso9131 DVSS_B.t112 DVSS_B.t159 1200.33032032532
Riso9132 DVSS_B.t112 DVSS_B.t161 601.860166295639
Riso9133 DVSS_B.t112 DVSS_B.t162 82460.5726766347
Riso9134 DVSS_B.t112 DVSS_B.t163 821.05872182601
Riso9135 DVSS_B.t112 DVSS_B.t165 0.066905629800953
Riso9136 DVSS_B.t112 DVSS_B.t167 33.0365885539555
Riso9137 DVSS_B.t112 DVSS_B.t169 1097.9088162146
Riso9138 DVSS_B.t112 DVSS_B.t173 4711.49183365018
Riso9139 DVSS_B.t112 DVSS_B.t177 675.160027347944
Riso9140 DVSS_B.t112 DVSS_B.t20 285041.936615725
Riso9141 DVSS_B.t112 DVSS_B.t202 4711.49183365018
Riso9142 DVSS_B.t112 DVSS_B.t204 106.878699912654
Riso9143 DVSS_B.t112 DVSS_B.t206 188.721252122947
Riso9144 DVSS_B.t112 DVSS_B.t21 3351.65029404371
Riso9145 DVSS_B.t112 DVSS_B.t212 153.710185553332
Riso9146 DVSS_B.t112 DVSS_B.t214 75.4076890896578
Riso9147 DVSS_B.t112 DVSS_B.t215 294427.314023741
Riso9148 DVSS_B.t112 DVSS_B.t216 3949.07158768492
Riso9149 DVSS_B.t112 DVSS_B.t218 388.962476066754
Riso9150 DVSS_B.t112 DVSS_B.t225 45.0145537094426
Riso9151 DVSS_B.t112 DVSS_B.t236 153.710185553332
Riso9152 DVSS_B.t112 DVSS_B.t238 1232.61419372744
Riso9153 DVSS_B.t112 DVSS_B.t240 171.045004423548
Riso9154 DVSS_B.t112 DVSS_B.t250 472.993773132697
Riso9155 DVSS_B.t112 DVSS_B.t252 1154.41816228409
Riso9156 DVSS_B.t112 DVSS_B.t256 640.888703578106
Riso9157 DVSS_B.t112 DVSS_B.t258 222.853240234206
Riso9158 DVSS_B.t112 DVSS_B.t259 17466.9831258118
Riso9159 DVSS_B.t112 DVSS_B.t260 249.996583362437
Riso9160 DVSS_B.t112 DVSS_B.t264 59.4841705656115
Riso9161 DVSS_B.t112 DVSS_B.t266 45.0145537094426
Riso9162 DVSS_B.t112 DVSS_B.t267 156043.689694447
Riso9163 DVSS_B.t112 DVSS_B.t268 1245.85472827431
Riso9164 DVSS_B.t112 DVSS_B.t271 1248.49975426886
Riso9165 DVSS_B.t112 DVSS_B.t273 430.2400162077
Riso9166 DVSS_B.t112 DVSS_B.t275 964.774618085351
Riso9167 DVSS_B.t112 DVSS_B.t277 121.42682277223
Riso9168 DVSS_B.t112 DVSS_B.t279 188.721252122947
Riso9169 DVSS_B.t112 DVSS_B.t281 38.6914833270304
Riso9170 DVSS_B.t112 DVSS_B.t283 893.222204612647
Riso9171 DVSS_B.t112 DVSS_B.t285 349.650379585254
Riso9172 DVSS_B.t112 DVSS_B.t287 388.962476066754
Riso9173 DVSS_B.t112 DVSS_B.t288 82460.5726766347
Riso9174 DVSS_B.t112 DVSS_B.t289 675.160027347944
Riso9175 DVSS_B.t112 DVSS_B.t291 33.0365885539555
Riso9176 DVSS_B.t112 DVSS_B.t293 1097.9088162146
Riso9177 DVSS_B.t112 DVSS_B.t295 237.772304343155
Riso9178 DVSS_B.t112 DVSS_B.t297 601.860166295639
Riso9179 DVSS_B.t112 DVSS_B.t299 1033.78611700937
Riso9180 DVSS_B.t112 DVSS_B.t301 24.979218186684
Riso9181 DVSS_B.t112 DVSS_B.t302 3772.03724425347
Riso9182 DVSS_B.t112 DVSS_B.t303 24.979218186684
Riso9183 DVSS_B.t112 DVSS_B.t305 640.888703578106
Riso9184 DVSS_B.t112 DVSS_B.t322 5301.68074521247
Riso9185 DVSS_B.t112 DVSS_B.t325 10534.5098164946
Riso9186 DVSS_B.t112 DVSS_B.t326 106.878699912654
Riso9187 DVSS_B.t112 DVSS_B.t329 1014.37648073561
Riso9188 DVSS_B.t112 DVSS_B.t331 1965.21744785168
Riso9189 DVSS_B.t112 DVSS_B.t333 1864.9189976479
Riso9190 DVSS_B.t112 DVSS_B.t335 988.339710175633
Riso9191 DVSS_B.t112 DVSS_B.t337 907.476921633463
Riso9192 DVSS_B.t112 DVSS_B.t339 1965.21744785168
Riso9193 DVSS_B.t112 DVSS_B.t341 1864.9189976479
Riso9194 DVSS_B.t112 DVSS_B.t343 809.936571701867
Riso9195 DVSS_B.t112 DVSS_B.t345 399436.327558874
Riso9196 DVSS_B.t112 DVSS_B.t346 1440.37759036216
Riso9197 DVSS_B.t112 DVSS_B.t348 430.2400162077
Riso9198 DVSS_B.t112 DVSS_B.t35 222.853240234206
Riso9199 DVSS_B.t112 DVSS_B.t350 1248.49975426886
Riso9200 DVSS_B.t112 DVSS_B.t352 1245.85472827431
Riso9201 DVSS_B.t112 DVSS_B.t355 1314367.02586471
Riso9202 DVSS_B.t112 DVSS_B.t356 2189.74688276068
Riso9203 DVSS_B.t112 DVSS_B.t358 59.4841705656115
Riso9204 DVSS_B.t112 DVSS_B.t36 215319.468695624
Riso9205 DVSS_B.t112 DVSS_B.t360 137.08798428344
Riso9206 DVSS_B.t112 DVSS_B.t364 38.6914833270304
Riso9207 DVSS_B.t112 DVSS_B.t366 28.0433554249434
Riso9208 DVSS_B.t112 DVSS_B.t37 3351.65029404371
Riso9209 DVSS_B.t112 DVSS_B.t509 28.0433554249434
Riso9210 DVSS_B.t112 DVSS_B.t515 516.527354415745
Riso9211 DVSS_B.t112 DVSS_B.t525 4313.55419720386
Riso9212 DVSS_B.t112 DVSS_B.t529 206.219303014057
Riso9213 DVSS_B.t112 DVSS_B.t531 516.527354415745
Riso9214 DVSS_B.t112 DVSS_B.t59 17466.9831258118
Riso9215 DVSS_B.t112 DVSS_B.t60 312.62790815385
Riso9216 DVSS_B.t112 DVSS_B.t66 559.89400534837
Riso9217 DVSS_B.t112 DVSS_B.t68 1033.78611700937
Riso9218 DVSS_B.t112 DVSS_B.t70 121.42682277223
Riso9219 DVSS_B.t112 DVSS_B.t72 51.9743475156552
Riso9220 DVSS_B.t112 DVSS_B.t74 5301.68074521247
Riso9221 DVSS_B.t112 DVSS_B.t76 1200.33032032532
Riso9222 DVSS_B.t112 DVSS_B.t80 1154.41816228409
Riso9223 DVSS_B.t112 DVSS_B.t82 893.222204612647
Riso9224 DVSS_B.t112 DVSS_B.t84 4313.55419720386
Riso9225 DVSS_B.t112 DVSS_B.t89 10534.5098164946
Riso9226 DVSS_B.t112 DVSS_B.t90 75.4076890896578
Riso9227 DVSS_B.t112 DVSS_B.t94 137.08798428344
Riso9228 DVSS_B.t112 DVSS_B.t96 67.3816326394865
Riso9229 DVSS_B.t112 VSS_A 3441.39175307995
Riso9230 DVSS_B.t112 VSS_B 442.03676853049
Riso9231 DVSS_B.t113 DVSS_B.t263 66.3487
Riso9232 DVSS_B.t113 DVSS_B.t71 66.3487
Riso9233 DVSS_B.t114 DVSS_B.t118 316.508671000859
Riso9234 DVSS_B.t114 DVSS_B.t120 197.86702700989
Riso9235 DVSS_B.t114 DVSS_B.t124 128.748619763153
Riso9236 DVSS_B.t114 DVSS_B.t132 1225.65473018169
Riso9237 DVSS_B.t114 DVSS_B.t134 213.680598999414
Riso9238 DVSS_B.t114 DVSS_B.t143 162.998624157148
Riso9239 DVSS_B.t114 DVSS_B.t148 296892.198590336
Riso9240 DVSS_B.t114 DVSS_B.t149 4048.19146128993
Riso9241 DVSS_B.t114 DVSS_B.t151 436.134544023013
Riso9242 DVSS_B.t114 DVSS_B.t153 281.256204015835
Riso9243 DVSS_B.t114 DVSS_B.t155 41.9770570005495
Riso9244 DVSS_B.t114 DVSS_B.t157 792.958506136697
Riso9245 DVSS_B.t114 DVSS_B.t159 1187.98941370998
Riso9246 DVSS_B.t114 DVSS_B.t161 565.453961567905
Riso9247 DVSS_B.t114 DVSS_B.t162 79771.9891130797
Riso9248 DVSS_B.t114 DVSS_B.t163 792.958506136697
Riso9249 DVSS_B.t114 DVSS_B.t165 51.9743475156552
Riso9250 DVSS_B.t114 DVSS_B.t167 44.8438994372296
Riso9251 DVSS_B.t114 DVSS_B.t169 1076.97387545588
Riso9252 DVSS_B.t114 DVSS_B.t173 4779.56298821661
Riso9253 DVSS_B.t114 DVSS_B.t177 642.438944358431
Riso9254 DVSS_B.t114 DVSS_B.t20 292328.518538128
Riso9255 DVSS_B.t114 DVSS_B.t202 4779.56298821661
Riso9256 DVSS_B.t114 DVSS_B.t204 73.3838775697343
Riso9257 DVSS_B.t114 DVSS_B.t206 145.524585147351
Riso9258 DVSS_B.t114 DVSS_B.t21 3435.7886399363
Riso9259 DVSS_B.t114 DVSS_B.t212 112.998715877139
Riso9260 DVSS_B.t114 DVSS_B.t214 48.1911828276996
Riso9261 DVSS_B.t114 DVSS_B.t215 301800.699963798
Riso9262 DVSS_B.t114 DVSS_B.t216 4048.19146128993
Riso9263 DVSS_B.t114 DVSS_B.t218 354.265870681961
Riso9264 DVSS_B.t114 DVSS_B.t225 35.4891836806249
Riso9265 DVSS_B.t114 DVSS_B.t236 112.998715877139
Riso9266 DVSS_B.t114 DVSS_B.t238 1225.65473018169
Riso9267 DVSS_B.t114 DVSS_B.t240 128.748619763153
Riso9268 DVSS_B.t114 DVSS_B.t250 436.134544023013
Riso9269 DVSS_B.t114 DVSS_B.t252 1137.36767733672
Riso9270 DVSS_B.t114 DVSS_B.t256 605.957150482338
Riso9271 DVSS_B.t114 DVSS_B.t258 180.675893217245
Riso9272 DVSS_B.t114 DVSS_B.t259 19088.8153689374
Riso9273 DVSS_B.t114 DVSS_B.t260 213.680598999414
Riso9274 DVSS_B.t114 DVSS_B.t264 36.1320071891723
Riso9275 DVSS_B.t114 DVSS_B.t266 35.4891836806249
Riso9276 DVSS_B.t114 DVSS_B.t267 158597.655187022
Riso9277 DVSS_B.t114 DVSS_B.t268 1250.52965467099
Riso9278 DVSS_B.t114 DVSS_B.t271 1247.33184652899
Riso9279 DVSS_B.t114 DVSS_B.t273 394.276591577843
Riso9280 DVSS_B.t114 DVSS_B.t275 938.691424580031
Riso9281 DVSS_B.t114 DVSS_B.t277 85.2576162047381
Riso9282 DVSS_B.t114 DVSS_B.t279 145.524585147351
Riso9283 DVSS_B.t114 DVSS_B.t281 40.2636662390059
Riso9284 DVSS_B.t114 DVSS_B.t283 865.784496571427
Riso9285 DVSS_B.t114 DVSS_B.t285 316.508671000859
Riso9286 DVSS_B.t114 DVSS_B.t287 354.265870681961
Riso9287 DVSS_B.t114 DVSS_B.t288 79771.9891130797
Riso9288 DVSS_B.t114 DVSS_B.t289 642.438944358431
Riso9289 DVSS_B.t114 DVSS_B.t291 44.8438994372296
Riso9290 DVSS_B.t114 DVSS_B.t293 1076.97387545588
Riso9291 DVSS_B.t114 DVSS_B.t295 197.86702700989
Riso9292 DVSS_B.t114 DVSS_B.t297 565.453961567905
Riso9293 DVSS_B.t114 DVSS_B.t299 1009.8470573387
Riso9294 DVSS_B.t114 DVSS_B.t301 53.7932548062042
Riso9295 DVSS_B.t114 DVSS_B.t302 7739.83175149707
Riso9296 DVSS_B.t114 DVSS_B.t303 53.7932548062042
Riso9297 DVSS_B.t114 DVSS_B.t305 605.957150482338
Riso9298 DVSS_B.t114 DVSS_B.t322 5377.69868342895
Riso9299 DVSS_B.t114 DVSS_B.t325 7129.89260432608
Riso9300 DVSS_B.t114 DVSS_B.t326 73.3838775697343
Riso9301 DVSS_B.t114 DVSS_B.t329 1051.93261835044
Riso9302 DVSS_B.t114 DVSS_B.t331 2039.2389962905
Riso9303 DVSS_B.t114 DVSS_B.t333 1941.06037736855
Riso9304 DVSS_B.t114 DVSS_B.t335 1028.70942898013
Riso9305 DVSS_B.t114 DVSS_B.t337 936.628432101152
Riso9306 DVSS_B.t114 DVSS_B.t339 2039.2389962905
Riso9307 DVSS_B.t114 DVSS_B.t341 1941.06037736855
Riso9308 DVSS_B.t114 DVSS_B.t343 836.551855464142
Riso9309 DVSS_B.t114 DVSS_B.t345 406663.166748468
Riso9310 DVSS_B.t114 DVSS_B.t346 1466.76078112146
Riso9311 DVSS_B.t114 DVSS_B.t348 394.276591577843
Riso9312 DVSS_B.t114 DVSS_B.t35 180.675893217245
Riso9313 DVSS_B.t114 DVSS_B.t350 1247.33184652899
Riso9314 DVSS_B.t114 DVSS_B.t352 1250.52965467099
Riso9315 DVSS_B.t114 DVSS_B.t355 1337663.79231823
Riso9316 DVSS_B.t114 DVSS_B.t356 2225.60414243765
Riso9317 DVSS_B.t114 DVSS_B.t358 36.1320071891723
Riso9318 DVSS_B.t114 DVSS_B.t36 220823.72174262
Riso9319 DVSS_B.t114 DVSS_B.t360 98.470055889031
Riso9320 DVSS_B.t114 DVSS_B.t364 40.2636662390059
Riso9321 DVSS_B.t114 DVSS_B.t366 48.8758658800868
Riso9322 DVSS_B.t114 DVSS_B.t37 3435.7886399363
Riso9323 DVSS_B.t114 DVSS_B.t509 48.8758658800868
Riso9324 DVSS_B.t114 DVSS_B.t515 479.234244484414
Riso9325 DVSS_B.t114 DVSS_B.t525 4378.60467983072
Riso9326 DVSS_B.t114 DVSS_B.t529 162.998624157148
Riso9327 DVSS_B.t114 DVSS_B.t531 479.234244484414
Riso9328 DVSS_B.t114 DVSS_B.t59 19088.8153689374
Riso9329 DVSS_B.t114 DVSS_B.t60 281.256204015835
Riso9330 DVSS_B.t114 DVSS_B.t66 522.72276912972
Riso9331 DVSS_B.t114 DVSS_B.t68 1009.8470573387
Riso9332 DVSS_B.t114 DVSS_B.t70 85.2576162047381
Riso9333 DVSS_B.t114 DVSS_B.t72 0.0669493576761241
Riso9334 DVSS_B.t114 DVSS_B.t74 5377.69868342895
Riso9335 DVSS_B.t114 DVSS_B.t76 1187.98941370998
Riso9336 DVSS_B.t114 DVSS_B.t80 1137.36767733672
Riso9337 DVSS_B.t114 DVSS_B.t82 865.784496571427
Riso9338 DVSS_B.t114 DVSS_B.t84 4378.60467983072
Riso9339 DVSS_B.t114 DVSS_B.t89 7129.89260432608
Riso9340 DVSS_B.t114 DVSS_B.t90 48.1911828276996
Riso9341 DVSS_B.t114 DVSS_B.t94 98.470055889031
Riso9342 DVSS_B.t114 DVSS_B.t96 41.9770570005495
Riso9343 DVSS_B.t114 VSS_A 3576.05625954142
Riso9344 DVSS_B.t114 VSS_B 470.496062172397
Riso9345 DVSS_B.t117 DVSS_B.t217 66.3487
Riso9346 DVSS_B.t117 DVSS_B.t284 66.3487
Riso9347 DVSS_B.t118 DVSS_B.t120 74.283680451705
Riso9348 DVSS_B.t118 DVSS_B.t124 130.814238197969
Riso9349 DVSS_B.t118 DVSS_B.t132 327.290710701564
Riso9350 DVSS_B.t118 DVSS_B.t134 63.3736811975
Riso9351 DVSS_B.t118 DVSS_B.t143 100.11488522429
Riso9352 DVSS_B.t118 DVSS_B.t148 95677.1190041166
Riso9353 DVSS_B.t118 DVSS_B.t149 1303.70511255102
Riso9354 DVSS_B.t118 DVSS_B.t151 56.1385988359652
Riso9355 DVSS_B.t118 DVSS_B.t153 39.5043755607894
Riso9356 DVSS_B.t118 DVSS_B.t155 274.556206497031
Riso9357 DVSS_B.t118 DVSS_B.t157 161.451292988835
Riso9358 DVSS_B.t118 DVSS_B.t159 306.085629818805
Riso9359 DVSS_B.t118 DVSS_B.t161 87.9890919899137
Riso9360 DVSS_B.t118 DVSS_B.t162 15905.9367405996
Riso9361 DVSS_B.t118 DVSS_B.t163 161.451292988835
Riso9362 DVSS_B.t118 DVSS_B.t165 349.650379585254
Riso9363 DVSS_B.t118 DVSS_B.t167 352.625416284088
Riso9364 DVSS_B.t118 DVSS_B.t169 257.378732740072
Riso9365 DVSS_B.t118 DVSS_B.t173 1461.53357567074
Riso9366 DVSS_B.t118 DVSS_B.t177 112.759210419962
Riso9367 DVSS_B.t118 DVSS_B.t20 94304.6622532973
Riso9368 DVSS_B.t118 DVSS_B.t202 1461.53357567074
Riso9369 DVSS_B.t118 DVSS_B.t204 196.111484467771
Riso9370 DVSS_B.t118 DVSS_B.t206 114.937243831437
Riso9371 DVSS_B.t118 DVSS_B.t21 1106.39558484302
Riso9372 DVSS_B.t118 DVSS_B.t212 147.428864999296
Riso9373 DVSS_B.t118 DVSS_B.t214 251.176031268153
Riso9374 DVSS_B.t118 DVSS_B.t215 97258.9432227065
Riso9375 DVSS_B.t118 DVSS_B.t216 1303.70511255102
Riso9376 DVSS_B.t118 DVSS_B.t218 40.1585431710517
Riso9377 DVSS_B.t118 DVSS_B.t225 333.092877667317
Riso9378 DVSS_B.t118 DVSS_B.t236 147.428864999296
Riso9379 DVSS_B.t118 DVSS_B.t238 327.290710701564
Riso9380 DVSS_B.t118 DVSS_B.t240 130.814238197969
Riso9381 DVSS_B.t118 DVSS_B.t250 56.1385988359652
Riso9382 DVSS_B.t118 DVSS_B.t252 282.375294543756
Riso9383 DVSS_B.t118 DVSS_B.t256 100.245580682412
Riso9384 DVSS_B.t118 DVSS_B.t258 86.5347879318451
Riso9385 DVSS_B.t118 DVSS_B.t259 9247.19366571672
Riso9386 DVSS_B.t118 DVSS_B.t260 63.3736811975
Riso9387 DVSS_B.t118 DVSS_B.t264 296.655670972611
Riso9388 DVSS_B.t118 DVSS_B.t266 333.092877667317
Riso9389 DVSS_B.t118 DVSS_B.t267 48978.470842794
Riso9390 DVSS_B.t118 DVSS_B.t268 356.734886748779
Riso9391 DVSS_B.t118 DVSS_B.t271 344.631031888299
Riso9392 DVSS_B.t118 DVSS_B.t273 47.617886767889
Riso9393 DVSS_B.t118 DVSS_B.t275 207.345480322493
Riso9394 DVSS_B.t118 DVSS_B.t277 180.807142718108
Riso9395 DVSS_B.t118 DVSS_B.t279 114.937243831437
Riso9396 DVSS_B.t118 DVSS_B.t281 345.416223989459
Riso9397 DVSS_B.t118 DVSS_B.t283 183.66472013091
Riso9398 DVSS_B.t118 DVSS_B.t285 0.0669618665349777
Riso9399 DVSS_B.t118 DVSS_B.t287 40.1585431710517
Riso9400 DVSS_B.t118 DVSS_B.t288 15905.9367405996
Riso9401 DVSS_B.t118 DVSS_B.t289 112.759210419962
Riso9402 DVSS_B.t118 DVSS_B.t291 352.625416284088
Riso9403 DVSS_B.t118 DVSS_B.t293 257.378732740072
Riso9404 DVSS_B.t118 DVSS_B.t295 74.283680451705
Riso9405 DVSS_B.t118 DVSS_B.t297 87.9890919899137
Riso9406 DVSS_B.t118 DVSS_B.t299 232.107194161184
Riso9407 DVSS_B.t118 DVSS_B.t301 339.370178822237
Riso9408 DVSS_B.t118 DVSS_B.t302 41693.539873366
Riso9409 DVSS_B.t118 DVSS_B.t303 339.370178822237
Riso9410 DVSS_B.t118 DVSS_B.t305 100.245580682412
Riso9411 DVSS_B.t118 DVSS_B.t322 1638.88913622679
Riso9412 DVSS_B.t118 DVSS_B.t325 25572.0291075968
Riso9413 DVSS_B.t118 DVSS_B.t326 196.111484467771
Riso9414 DVSS_B.t118 DVSS_B.t329 376.983636577133
Riso9415 DVSS_B.t118 DVSS_B.t331 723.652506594616
Riso9416 DVSS_B.t118 DVSS_B.t333 688.672581517741
Riso9417 DVSS_B.t118 DVSS_B.t335 368.814412996328
Riso9418 DVSS_B.t118 DVSS_B.t337 329.563549775364
Riso9419 DVSS_B.t118 DVSS_B.t339 723.652506594616
Riso9420 DVSS_B.t118 DVSS_B.t341 688.672581517741
Riso9421 DVSS_B.t118 DVSS_B.t343 291.530005651084
Riso9422 DVSS_B.t118 DVSS_B.t345 140153.875672794
Riso9423 DVSS_B.t118 DVSS_B.t346 509.580619882658
Riso9424 DVSS_B.t118 DVSS_B.t348 47.617886767889
Riso9425 DVSS_B.t118 DVSS_B.t35 86.5347879318451
Riso9426 DVSS_B.t118 DVSS_B.t350 344.631031888299
Riso9427 DVSS_B.t118 DVSS_B.t352 356.734886748779
Riso9428 DVSS_B.t118 DVSS_B.t355 455116.42299845
Riso9429 DVSS_B.t118 DVSS_B.t356 723.698976530425
Riso9430 DVSS_B.t118 DVSS_B.t358 296.655670972611
Riso9431 DVSS_B.t118 DVSS_B.t36 71237.3414697744
Riso9432 DVSS_B.t118 DVSS_B.t360 164.30830648759
Riso9433 DVSS_B.t118 DVSS_B.t364 345.416223989459
Riso9434 DVSS_B.t118 DVSS_B.t366 354.120238141409
Riso9435 DVSS_B.t118 DVSS_B.t37 1106.39558484302
Riso9436 DVSS_B.t118 DVSS_B.t509 354.120238141409
Riso9437 DVSS_B.t118 DVSS_B.t515 65.7461239818154
Riso9438 DVSS_B.t118 DVSS_B.t525 1365.64394268229
Riso9439 DVSS_B.t118 DVSS_B.t529 100.11488522429
Riso9440 DVSS_B.t118 DVSS_B.t531 65.7461239818154
Riso9441 DVSS_B.t118 DVSS_B.t59 9247.19366571672
Riso9442 DVSS_B.t118 DVSS_B.t60 39.5043755607894
Riso9443 DVSS_B.t118 DVSS_B.t66 76.4050427211984
Riso9444 DVSS_B.t118 DVSS_B.t68 232.107194161184
Riso9445 DVSS_B.t118 DVSS_B.t70 180.807142718108
Riso9446 DVSS_B.t118 DVSS_B.t72 316.508671000859
Riso9447 DVSS_B.t118 DVSS_B.t74 1638.88913622679
Riso9448 DVSS_B.t118 DVSS_B.t76 306.085629818805
Riso9449 DVSS_B.t118 DVSS_B.t80 282.375294543756
Riso9450 DVSS_B.t118 DVSS_B.t82 183.66472013091
Riso9451 DVSS_B.t118 DVSS_B.t84 1365.64394268229
Riso9452 DVSS_B.t118 DVSS_B.t89 25572.0291075968
Riso9453 DVSS_B.t118 DVSS_B.t90 251.176031268153
Riso9454 DVSS_B.t118 DVSS_B.t94 164.30830648759
Riso9455 DVSS_B.t118 DVSS_B.t96 274.556206497031
Riso9456 DVSS_B.t118 VSS_A 1292.37936228406
Riso9457 DVSS_B.t118 VSS_B 182.418485779323
Riso9458 DVSS_B.t119 DVSS_B.t133 66.3487
Riso9459 DVSS_B.t119 DVSS_B.t294 66.3487
Riso9460 DVSS_B.t120 DVSS_B.t124 64.67705992303
Riso9461 DVSS_B.t120 DVSS_B.t132 493.10314461379
Riso9462 DVSS_B.t120 DVSS_B.t134 39.3363380188871
Riso9463 DVSS_B.t120 DVSS_B.t143 47.1978177563535
Riso9464 DVSS_B.t120 DVSS_B.t148 128400.265577586
Riso9465 DVSS_B.t120 DVSS_B.t149 1749.59464889799
Riso9466 DVSS_B.t120 DVSS_B.t151 116.099282644295
Riso9467 DVSS_B.t120 DVSS_B.t153 63.2576685975986
Riso9468 DVSS_B.t120 DVSS_B.t155 164.877233742514
Riso9469 DVSS_B.t120 DVSS_B.t157 277.214909619886
Riso9470 DVSS_B.t120 DVSS_B.t159 469.542715318073
Riso9471 DVSS_B.t120 DVSS_B.t161 169.425334649602
Riso9472 DVSS_B.t120 DVSS_B.t162 27567.1410655379
Riso9473 DVSS_B.t120 DVSS_B.t163 277.214909619886
Riso9474 DVSS_B.t120 DVSS_B.t165 237.772304343155
Riso9475 DVSS_B.t120 DVSS_B.t167 232.847406108514
Riso9476 DVSS_B.t120 DVSS_B.t169 409.761129884918
Riso9477 DVSS_B.t120 DVSS_B.t173 2076.95142132434
Riso9478 DVSS_B.t120 DVSS_B.t177 206.666984905013
Riso9479 DVSS_B.t120 DVSS_B.t20 126446.039955791
Riso9480 DVSS_B.t120 DVSS_B.t202 2076.95142132434
Riso9481 DVSS_B.t120 DVSS_B.t204 107.585042718235
Riso9482 DVSS_B.t120 DVSS_B.t206 55.4607577805091
Riso9483 DVSS_B.t120 DVSS_B.t21 1484.80768019199
Riso9484 DVSS_B.t120 DVSS_B.t212 74.7572036679649
Riso9485 DVSS_B.t120 DVSS_B.t214 147.785663010534
Riso9486 DVSS_B.t120 DVSS_B.t215 130523.099666635
Riso9487 DVSS_B.t120 DVSS_B.t216 1749.59464889799
Riso9488 DVSS_B.t120 DVSS_B.t218 86.7502214305712
Riso9489 DVSS_B.t120 DVSS_B.t225 212.287023272873
Riso9490 DVSS_B.t120 DVSS_B.t236 74.7572036679649
Riso9491 DVSS_B.t120 DVSS_B.t238 493.10314461379
Riso9492 DVSS_B.t120 DVSS_B.t240 64.67705992303
Riso9493 DVSS_B.t120 DVSS_B.t250 116.099282644295
Riso9494 DVSS_B.t120 DVSS_B.t252 441.231325333567
Riso9495 DVSS_B.t120 DVSS_B.t256 188.315236746854
Riso9496 DVSS_B.t120 DVSS_B.t258 39.9043964026663
Riso9497 DVSS_B.t120 DVSS_B.t259 9135.45904244295
Riso9498 DVSS_B.t120 DVSS_B.t260 39.3363380188871
Riso9499 DVSS_B.t120 DVSS_B.t264 181.799616718609
Riso9500 DVSS_B.t120 DVSS_B.t266 212.287023272873
Riso9501 DVSS_B.t120 DVSS_B.t267 68367.2578632711
Riso9502 DVSS_B.t120 DVSS_B.t268 519.551757694373
Riso9503 DVSS_B.t120 DVSS_B.t271 510.273436099135
Riso9504 DVSS_B.t120 DVSS_B.t273 100.695385436343
Riso9505 DVSS_B.t120 DVSS_B.t275 342.804669472169
Riso9506 DVSS_B.t120 DVSS_B.t277 96.6110501893887
Riso9507 DVSS_B.t120 DVSS_B.t279 55.4607577805091
Riso9508 DVSS_B.t120 DVSS_B.t281 224.216722212325
Riso9509 DVSS_B.t120 DVSS_B.t283 309.454282783292
Riso9510 DVSS_B.t120 DVSS_B.t285 74.283680451705
Riso9511 DVSS_B.t120 DVSS_B.t287 86.7502214305712
Riso9512 DVSS_B.t120 DVSS_B.t288 27567.1410655379
Riso9513 DVSS_B.t120 DVSS_B.t289 206.666984905013
Riso9514 DVSS_B.t120 DVSS_B.t291 232.847406108514
Riso9515 DVSS_B.t120 DVSS_B.t293 409.761129884918
Riso9516 DVSS_B.t120 DVSS_B.t295 0.0669612727454081
Riso9517 DVSS_B.t120 DVSS_B.t297 169.425334649602
Riso9518 DVSS_B.t120 DVSS_B.t299 376.555061545389
Riso9519 DVSS_B.t120 DVSS_B.t301 233.532250022744
Riso9520 DVSS_B.t120 DVSS_B.t302 29534.5074437748
Riso9521 DVSS_B.t120 DVSS_B.t303 233.532250022744
Riso9522 DVSS_B.t120 DVSS_B.t305 188.315236746854
Riso9523 DVSS_B.t120 DVSS_B.t322 2332.77776600604
Riso9524 DVSS_B.t120 DVSS_B.t325 14858.2611385278
Riso9525 DVSS_B.t120 DVSS_B.t326 107.585042718235
Riso9526 DVSS_B.t120 DVSS_B.t329 487.424103370478
Riso9527 DVSS_B.t120 DVSS_B.t331 939.063421208639
Riso9528 DVSS_B.t120 DVSS_B.t333 890.595216659188
Riso9529 DVSS_B.t120 DVSS_B.t335 474.995481913038
Riso9530 DVSS_B.t120 DVSS_B.t337 430.588918233514
Riso9531 DVSS_B.t120 DVSS_B.t339 939.063421208639
Riso9532 DVSS_B.t120 DVSS_B.t341 890.595216659188
Riso9533 DVSS_B.t120 DVSS_B.t343 381.729088867037
Riso9534 DVSS_B.t120 DVSS_B.t345 187682.634698276
Riso9535 DVSS_B.t120 DVSS_B.t346 679.601125124323
Riso9536 DVSS_B.t120 DVSS_B.t348 100.695385436343
Riso9537 DVSS_B.t120 DVSS_B.t35 39.9043964026663
Riso9538 DVSS_B.t120 DVSS_B.t350 510.273436099135
Riso9539 DVSS_B.t120 DVSS_B.t352 519.551757694373
Riso9540 DVSS_B.t120 DVSS_B.t355 613462.256832329
Riso9541 DVSS_B.t120 DVSS_B.t356 997.963784786457
Riso9542 DVSS_B.t120 DVSS_B.t358 181.799616718609
Riso9543 DVSS_B.t120 DVSS_B.t36 95516.8017211842
Riso9544 DVSS_B.t120 DVSS_B.t360 85.5095664056503
Riso9545 DVSS_B.t120 DVSS_B.t364 224.216722212325
Riso9546 DVSS_B.t120 DVSS_B.t366 237.508573743323
Riso9547 DVSS_B.t120 DVSS_B.t37 1484.80768019199
Riso9548 DVSS_B.t120 DVSS_B.t509 237.508573743323
Riso9549 DVSS_B.t120 DVSS_B.t515 132.85873689152
Riso9550 DVSS_B.t120 DVSS_B.t525 1922.20837192178
Riso9551 DVSS_B.t120 DVSS_B.t529 47.1978177563535
Riso9552 DVSS_B.t120 DVSS_B.t531 132.85873689152
Riso9553 DVSS_B.t120 DVSS_B.t59 9135.45904244295
Riso9554 DVSS_B.t120 DVSS_B.t60 63.2576685975986
Riso9555 DVSS_B.t120 DVSS_B.t66 150.756325539281
Riso9556 DVSS_B.t120 DVSS_B.t68 376.555061545389
Riso9557 DVSS_B.t120 DVSS_B.t70 96.6110501893887
Riso9558 DVSS_B.t120 DVSS_B.t72 197.86702700989
Riso9559 DVSS_B.t120 DVSS_B.t74 2332.77776600604
Riso9560 DVSS_B.t120 DVSS_B.t76 469.542715318073
Riso9561 DVSS_B.t120 DVSS_B.t80 441.231325333567
Riso9562 DVSS_B.t120 DVSS_B.t82 309.454282783292
Riso9563 DVSS_B.t120 DVSS_B.t84 1922.20837192178
Riso9564 DVSS_B.t120 DVSS_B.t89 14858.2611385278
Riso9565 DVSS_B.t120 DVSS_B.t90 147.785663010534
Riso9566 DVSS_B.t120 DVSS_B.t94 85.5095664056503
Riso9567 DVSS_B.t120 DVSS_B.t96 164.877233742514
Riso9568 DVSS_B.t120 VSS_A 1663.06517684658
Riso9569 DVSS_B.t120 VSS_B 223.719834316282
Riso9570 DVSS_B.t123 DVSS_B.t211 66.3487
Riso9571 DVSS_B.t123 DVSS_B.t239 66.3487
Riso9572 DVSS_B.t124 DVSS_B.t132 716.27522470411
Riso9573 DVSS_B.t124 DVSS_B.t134 74.33215506546
Riso9574 DVSS_B.t124 DVSS_B.t143 47.5093959312749
Riso9575 DVSS_B.t124 DVSS_B.t148 183389.148798789
Riso9576 DVSS_B.t124 DVSS_B.t149 2499.61044774272
Riso9577 DVSS_B.t124 DVSS_B.t151 195.523461033595
Riso9578 DVSS_B.t124 DVSS_B.t153 113.042834835847
Riso9579 DVSS_B.t124 DVSS_B.t155 102.698565104169
Riso9580 DVSS_B.t124 DVSS_B.t157 422.935267274999
Riso9581 DVSS_B.t124 DVSS_B.t159 685.77623796367
Riso9582 DVSS_B.t124 DVSS_B.t161 273.352113567922
Riso9583 DVSS_B.t124 DVSS_B.t162 42348.0482739152
Riso9584 DVSS_B.t124 DVSS_B.t163 422.935267274999
Riso9585 DVSS_B.t124 DVSS_B.t165 171.045004423548
Riso9586 DVSS_B.t124 DVSS_B.t167 161.511668520082
Riso9587 DVSS_B.t124 DVSS_B.t169 606.04407936099
Riso9588 DVSS_B.t124 DVSS_B.t173 2955.42519812732
Riso9589 DVSS_B.t124 DVSS_B.t177 325.036895980636
Riso9590 DVSS_B.t124 DVSS_B.t20 180643.257548106
Riso9591 DVSS_B.t124 DVSS_B.t202 2955.42519812732
Riso9592 DVSS_B.t124 DVSS_B.t204 61.3908745452568
Riso9593 DVSS_B.t124 DVSS_B.t206 40.2423027109723
Riso9594 DVSS_B.t124 DVSS_B.t21 2121.38144986007
Riso9595 DVSS_B.t124 DVSS_B.t212 39.9338310088635
Riso9596 DVSS_B.t124 DVSS_B.t214 90.1243198683169
Riso9597 DVSS_B.t124 DVSS_B.t215 186421.110881427
Riso9598 DVSS_B.t124 DVSS_B.t216 2499.61044774272
Riso9599 DVSS_B.t124 DVSS_B.t218 150.515575426522
Riso9600 DVSS_B.t124 DVSS_B.t225 141.192432322004
Riso9601 DVSS_B.t124 DVSS_B.t236 39.9338310088635
Riso9602 DVSS_B.t124 DVSS_B.t238 716.27522470411
Riso9603 DVSS_B.t124 DVSS_B.t240 0.0669625697691413
Riso9604 DVSS_B.t124 DVSS_B.t250 195.523461033595
Riso9605 DVSS_B.t124 DVSS_B.t252 648.31907335736
Riso9606 DVSS_B.t124 DVSS_B.t256 299.848929253968
Riso9607 DVSS_B.t124 DVSS_B.t258 55.6778213378557
Riso9608 DVSS_B.t124 DVSS_B.t259 13265.8862892806
Riso9609 DVSS_B.t124 DVSS_B.t260 74.33215506546
Riso9610 DVSS_B.t124 DVSS_B.t264 115.723047616393
Riso9611 DVSS_B.t124 DVSS_B.t266 141.192432322004
Riso9612 DVSS_B.t124 DVSS_B.t267 97548.6252991728
Riso9613 DVSS_B.t124 DVSS_B.t268 747.897509793716
Riso9614 DVSS_B.t124 DVSS_B.t271 737.638163560689
Riso9615 DVSS_B.t124 DVSS_B.t273 172.122662093952
Riso9616 DVSS_B.t124 DVSS_B.t275 514.486696016195
Riso9617 DVSS_B.t124 DVSS_B.t277 53.8795951513506
Riso9618 DVSS_B.t124 DVSS_B.t279 40.2423027109723
Riso9619 DVSS_B.t124 DVSS_B.t281 152.362126855649
Riso9620 DVSS_B.t124 DVSS_B.t283 468.16527481512
Riso9621 DVSS_B.t124 DVSS_B.t285 130.814238197969
Riso9622 DVSS_B.t124 DVSS_B.t287 150.515575426522
Riso9623 DVSS_B.t124 DVSS_B.t288 42348.0482739152
Riso9624 DVSS_B.t124 DVSS_B.t289 325.036895980636
Riso9625 DVSS_B.t124 DVSS_B.t291 161.511668520082
Riso9626 DVSS_B.t124 DVSS_B.t293 606.04407936099
Riso9627 DVSS_B.t124 DVSS_B.t295 64.67705992303
Riso9628 DVSS_B.t124 DVSS_B.t297 273.352113567922
Riso9629 DVSS_B.t124 DVSS_B.t299 560.886312213448
Riso9630 DVSS_B.t124 DVSS_B.t301 170.536125876715
Riso9631 DVSS_B.t124 DVSS_B.t302 22390.6054943606
Riso9632 DVSS_B.t124 DVSS_B.t303 170.536125876715
Riso9633 DVSS_B.t124 DVSS_B.t305 299.848929253968
Riso9634 DVSS_B.t124 DVSS_B.t322 3322.00078260901
Riso9635 DVSS_B.t124 DVSS_B.t325 8934.28213825394
Riso9636 DVSS_B.t124 DVSS_B.t326 61.3908745452568
Riso9637 DVSS_B.t124 DVSS_B.t329 682.154872893259
Riso9638 DVSS_B.t124 DVSS_B.t331 1318.5024447117
Riso9639 DVSS_B.t124 DVSS_B.t333 1254.95143329596
Riso9640 DVSS_B.t124 DVSS_B.t335 667.453950844456
Riso9641 DVSS_B.t124 DVSS_B.t337 602.673543104529
Riso9642 DVSS_B.t124 DVSS_B.t339 1318.5024447117
Riso9643 DVSS_B.t124 DVSS_B.t341 1254.95143329596
Riso9644 DVSS_B.t124 DVSS_B.t343 536.242445209177
Riso9645 DVSS_B.t124 DVSS_B.t345 260008.538978984
Riso9646 DVSS_B.t124 DVSS_B.t346 939.820977566687
Riso9647 DVSS_B.t124 DVSS_B.t348 172.122662093952
Riso9648 DVSS_B.t124 DVSS_B.t35 55.6778213378557
Riso9649 DVSS_B.t124 DVSS_B.t350 737.638163560689
Riso9650 DVSS_B.t124 DVSS_B.t352 747.897509793716
Riso9651 DVSS_B.t124 DVSS_B.t355 852299.50857903
Riso9652 DVSS_B.t124 DVSS_B.t356 1400.54115277239
Riso9653 DVSS_B.t124 DVSS_B.t358 115.723047616393
Riso9654 DVSS_B.t124 DVSS_B.t36 136457.149781234
Riso9655 DVSS_B.t124 DVSS_B.t360 46.645703209474
Riso9656 DVSS_B.t124 DVSS_B.t364 152.362126855649
Riso9657 DVSS_B.t124 DVSS_B.t366 167.929152553776
Riso9658 DVSS_B.t124 DVSS_B.t37 2121.38144986007
Riso9659 DVSS_B.t124 DVSS_B.t509 167.929152553776
Riso9660 DVSS_B.t124 DVSS_B.t515 220.486720560366
Riso9661 DVSS_B.t124 DVSS_B.t525 2723.0323177363
Riso9662 DVSS_B.t124 DVSS_B.t529 47.5093959312749
Riso9663 DVSS_B.t124 DVSS_B.t531 220.486720560366
Riso9664 DVSS_B.t124 DVSS_B.t59 13265.8862892806
Riso9665 DVSS_B.t124 DVSS_B.t60 113.042834835847
Riso9666 DVSS_B.t124 DVSS_B.t66 246.624640197016
Riso9667 DVSS_B.t124 DVSS_B.t68 560.886312213448
Riso9668 DVSS_B.t124 DVSS_B.t70 53.8795951513506
Riso9669 DVSS_B.t124 DVSS_B.t72 128.748619763153
Riso9670 DVSS_B.t124 DVSS_B.t74 3322.00078260901
Riso9671 DVSS_B.t124 DVSS_B.t76 685.77623796367
Riso9672 DVSS_B.t124 DVSS_B.t80 648.31907335736
Riso9673 DVSS_B.t124 DVSS_B.t82 468.16527481512
Riso9674 DVSS_B.t124 DVSS_B.t84 2723.0323177363
Riso9675 DVSS_B.t124 DVSS_B.t89 8934.28213825394
Riso9676 DVSS_B.t124 DVSS_B.t90 90.1243198683169
Riso9677 DVSS_B.t124 DVSS_B.t94 46.645703209474
Riso9678 DVSS_B.t124 DVSS_B.t96 102.698565104169
Riso9679 DVSS_B.t124 VSS_A 2327.11910676975
Riso9680 DVSS_B.t124 VSS_B 315.511714871761
Riso9681 DVSS_B.t131 DVSS_B.t237 66.3487
Riso9682 DVSS_B.t131 DVSS_B.t75 66.3487
Riso9683 DVSS_B.t132 DVSS_B.t134 441.666986304882
Riso9684 DVSS_B.t132 DVSS_B.t143 602.999913131121
Riso9685 DVSS_B.t132 DVSS_B.t148 22411.2584642445
Riso9686 DVSS_B.t132 DVSS_B.t149 305.899848295005
Riso9687 DVSS_B.t132 DVSS_B.t151 251.74064281669
Riso9688 DVSS_B.t132 DVSS_B.t153 347.828006380335
Riso9689 DVSS_B.t132 DVSS_B.t155 1116.17945814663
Riso9690 DVSS_B.t132 DVSS_B.t157 92.343219038709
Riso9691 DVSS_B.t132 DVSS_B.t159 37.6360792307161
Riso9692 DVSS_B.t132 DVSS_B.t161 177.330345729179
Riso9693 DVSS_B.t132 DVSS_B.t162 13280.217618926
Riso9694 DVSS_B.t132 DVSS_B.t163 92.343219038709
Riso9695 DVSS_B.t132 DVSS_B.t165 1232.61419372744
Riso9696 DVSS_B.t132 DVSS_B.t167 1283.27393248009
Riso9697 DVSS_B.t132 DVSS_B.t169 52.4523658602611
Riso9698 DVSS_B.t132 DVSS_B.t173 171.310401408015
Riso9699 DVSS_B.t132 DVSS_B.t177 135.465253635219
Riso9700 DVSS_B.t132 DVSS_B.t20 22188.2168858471
Riso9701 DVSS_B.t132 DVSS_B.t202 171.310401408015
Riso9702 DVSS_B.t132 DVSS_B.t204 901.799708800677
Riso9703 DVSS_B.t132 DVSS_B.t206 659.809944290633
Riso9704 DVSS_B.t132 DVSS_B.t21 259.647724191737
Riso9705 DVSS_B.t132 DVSS_B.t212 770.790757756116
Riso9706 DVSS_B.t132 DVSS_B.t214 1047.88026180653
Riso9707 DVSS_B.t132 DVSS_B.t215 22781.7824910632
Riso9708 DVSS_B.t132 DVSS_B.t216 305.899848295005
Riso9709 DVSS_B.t132 DVSS_B.t218 303.522917586147
Riso9710 DVSS_B.t132 DVSS_B.t225 1261.34547800515
Riso9711 DVSS_B.t132 DVSS_B.t236 770.790757756116
Riso9712 DVSS_B.t132 DVSS_B.t238 0.0669531051936496
Riso9713 DVSS_B.t132 DVSS_B.t240 716.27522470411
Riso9714 DVSS_B.t132 DVSS_B.t250 251.74064281669
Riso9715 DVSS_B.t132 DVSS_B.t252 44.5668318689253
Riso9716 DVSS_B.t132 DVSS_B.t256 155.47808943041
Riso9717 DVSS_B.t132 DVSS_B.t258 547.111623432985
Riso9718 DVSS_B.t132 DVSS_B.t259 27342.2633718909
Riso9719 DVSS_B.t132 DVSS_B.t260 441.666986304882
Riso9720 DVSS_B.t132 DVSS_B.t264 1176.36938262871
Riso9721 DVSS_B.t132 DVSS_B.t266 1261.34547800515
Riso9722 DVSS_B.t132 DVSS_B.t267 7011.62794483948
Riso9723 DVSS_B.t132 DVSS_B.t268 40.6910082497086
Riso9724 DVSS_B.t132 DVSS_B.t271 36.2081064728562
Riso9725 DVSS_B.t132 DVSS_B.t273 277.945008730063
Riso9726 DVSS_B.t132 DVSS_B.t275 71.0243998897834
Riso9727 DVSS_B.t132 DVSS_B.t277 865.890602077562
Riso9728 DVSS_B.t132 DVSS_B.t279 659.809944290633
Riso9729 DVSS_B.t132 DVSS_B.t281 1281.11449088449
Riso9730 DVSS_B.t132 DVSS_B.t283 81.4756957685454
Riso9731 DVSS_B.t132 DVSS_B.t285 327.290710701564
Riso9732 DVSS_B.t132 DVSS_B.t287 303.522917586147
Riso9733 DVSS_B.t132 DVSS_B.t288 13280.217618926
Riso9734 DVSS_B.t132 DVSS_B.t289 135.465253635219
Riso9735 DVSS_B.t132 DVSS_B.t291 1283.27393248009
Riso9736 DVSS_B.t132 DVSS_B.t293 52.4523658602611
Riso9737 DVSS_B.t132 DVSS_B.t295 493.10314461379
Riso9738 DVSS_B.t132 DVSS_B.t297 177.330345729179
Riso9739 DVSS_B.t132 DVSS_B.t299 61.293985764678
Riso9740 DVSS_B.t132 DVSS_B.t301 1181.38943748577
Riso9741 DVSS_B.t132 DVSS_B.t302 140884.735487341
Riso9742 DVSS_B.t132 DVSS_B.t303 1181.38943748577
Riso9743 DVSS_B.t132 DVSS_B.t305 155.47808943041
Riso9744 DVSS_B.t132 DVSS_B.t322 189.764863487279
Riso9745 DVSS_B.t132 DVSS_B.t325 108345.301787446
Riso9746 DVSS_B.t132 DVSS_B.t326 901.799708800677
Riso9747 DVSS_B.t132 DVSS_B.t329 99.0805268761054
Riso9748 DVSS_B.t132 DVSS_B.t331 176.925825280798
Riso9749 DVSS_B.t132 DVSS_B.t333 168.358611818707
Riso9750 DVSS_B.t132 DVSS_B.t335 95.6536446825186
Riso9751 DVSS_B.t132 DVSS_B.t337 83.142110443058
Riso9752 DVSS_B.t132 DVSS_B.t339 176.925825280798
Riso9753 DVSS_B.t132 DVSS_B.t341 168.358611818707
Riso9754 DVSS_B.t132 DVSS_B.t343 71.1899529479837
Riso9755 DVSS_B.t132 DVSS_B.t345 30605.7189530108
Riso9756 DVSS_B.t132 DVSS_B.t346 118.548917898901
Riso9757 DVSS_B.t132 DVSS_B.t348 277.945008730063
Riso9758 DVSS_B.t132 DVSS_B.t35 547.111623432985
Riso9759 DVSS_B.t132 DVSS_B.t350 36.2081064728562
Riso9760 DVSS_B.t132 DVSS_B.t352 40.6910082497086
Riso9761 DVSS_B.t132 DVSS_B.t355 90538.9695347866
Riso9762 DVSS_B.t132 DVSS_B.t356 110.320005130579
Riso9763 DVSS_B.t132 DVSS_B.t358 1176.36938262871
Riso9764 DVSS_B.t132 DVSS_B.t36 16760.8848293949
Riso9765 DVSS_B.t132 DVSS_B.t360 821.41042056164
Riso9766 DVSS_B.t132 DVSS_B.t364 1281.11449088449
Riso9767 DVSS_B.t132 DVSS_B.t366 1267.02317681228
Riso9768 DVSS_B.t132 DVSS_B.t37 259.647724191737
Riso9769 DVSS_B.t132 DVSS_B.t509 1267.02317681228
Riso9770 DVSS_B.t132 DVSS_B.t515 225.827843192229
Riso9771 DVSS_B.t132 DVSS_B.t525 172.630597085251
Riso9772 DVSS_B.t132 DVSS_B.t529 602.999913131121
Riso9773 DVSS_B.t132 DVSS_B.t531 225.827843192229
Riso9774 DVSS_B.t132 DVSS_B.t59 27342.2633718909
Riso9775 DVSS_B.t132 DVSS_B.t60 347.828006380335
Riso9776 DVSS_B.t132 DVSS_B.t66 200.873646577457
Riso9777 DVSS_B.t132 DVSS_B.t68 61.293985764678
Riso9778 DVSS_B.t132 DVSS_B.t70 865.890602077562
Riso9779 DVSS_B.t132 DVSS_B.t72 1225.65473018169
Riso9780 DVSS_B.t132 DVSS_B.t74 189.764863487279
Riso9781 DVSS_B.t132 DVSS_B.t76 37.6360792307161
Riso9782 DVSS_B.t132 DVSS_B.t80 44.5668318689253
Riso9783 DVSS_B.t132 DVSS_B.t82 81.4756957685454
Riso9784 DVSS_B.t132 DVSS_B.t84 172.630597085251
Riso9785 DVSS_B.t132 DVSS_B.t89 108345.301787446
Riso9786 DVSS_B.t132 DVSS_B.t90 1047.88026180653
Riso9787 DVSS_B.t132 DVSS_B.t94 821.41042056164
Riso9788 DVSS_B.t132 DVSS_B.t96 1116.17945814663
Riso9789 DVSS_B.t132 VSS_A 347.068330764454
Riso9790 DVSS_B.t132 VSS_B 55.9349162746284
Riso9791 DVSS_B.t133 DVSS_B.t259 66.3487
Riso9792 DVSS_B.t134 DVSS_B.t143 54.8323913091115
Riso9793 DVSS_B.t134 DVSS_B.t148 115391.112746867
Riso9794 DVSS_B.t134 DVSS_B.t149 1572.21050854826
Riso9795 DVSS_B.t134 DVSS_B.t151 100.13086294793
Riso9796 DVSS_B.t134 DVSS_B.t153 53.7797988369364
Riso9797 DVSS_B.t134 DVSS_B.t155 180.14837815302
Riso9798 DVSS_B.t134 DVSS_B.t157 245.186423879089
Riso9799 DVSS_B.t134 DVSS_B.t159 420.022180714473
Riso9800 DVSS_B.t134 DVSS_B.t161 147.70733470254
Riso9801 DVSS_B.t134 DVSS_B.t162 24330.4508558166
Riso9802 DVSS_B.t134 DVSS_B.t163 245.186423879089
Riso9803 DVSS_B.t134 DVSS_B.t165 249.996583362437
Riso9804 DVSS_B.t134 DVSS_B.t167 247.218186126518
Riso9805 DVSS_B.t134 DVSS_B.t169 365.395880187529
Riso9806 DVSS_B.t134 DVSS_B.t173 1867.81662389783
Riso9807 DVSS_B.t134 DVSS_B.t177 181.350375513102
Riso9808 DVSS_B.t134 DVSS_B.t20 113622.822277908
Riso9809 DVSS_B.t134 DVSS_B.t202 1867.81662389783
Riso9810 DVSS_B.t134 DVSS_B.t204 120.490989435447
Riso9811 DVSS_B.t134 DVSS_B.t206 64.0976883711976
Riso9812 DVSS_B.t134 DVSS_B.t21 1334.25846881591
Riso9813 DVSS_B.t134 DVSS_B.t212 85.4045105546178
Riso9814 DVSS_B.t134 DVSS_B.t214 162.399697753047
Riso9815 DVSS_B.t134 DVSS_B.t215 117298.867272222
Riso9816 DVSS_B.t134 DVSS_B.t216 1572.21050854826
Riso9817 DVSS_B.t134 DVSS_B.t218 74.2739785645732
Riso9818 DVSS_B.t134 DVSS_B.t225 227.919609065341
Riso9819 DVSS_B.t134 DVSS_B.t236 85.4045105546178
Riso9820 DVSS_B.t134 DVSS_B.t238 441.666986304882
Riso9821 DVSS_B.t134 DVSS_B.t240 74.33215506546
Riso9822 DVSS_B.t134 DVSS_B.t250 100.13086294793
Riso9823 DVSS_B.t134 DVSS_B.t252 394.112820536507
Riso9824 DVSS_B.t134 DVSS_B.t256 164.72813396529
Riso9825 DVSS_B.t134 DVSS_B.t258 46.5828304440546
Riso9826 DVSS_B.t134 DVSS_B.t259 8099.49376769584
Riso9827 DVSS_B.t134 DVSS_B.t260 0.0669592262767567
Riso9828 DVSS_B.t134 DVSS_B.t264 197.484595998464
Riso9829 DVSS_B.t134 DVSS_B.t266 227.919609065341
Riso9830 DVSS_B.t134 DVSS_B.t267 61456.3722238013
Riso9831 DVSS_B.t134 DVSS_B.t268 466.281427698003
Riso9832 DVSS_B.t134 DVSS_B.t271 457.545651349372
Riso9833 DVSS_B.t134 DVSS_B.t273 86.5276290482057
Riso9834 DVSS_B.t134 DVSS_B.t275 304.525612104377
Riso9835 DVSS_B.t134 DVSS_B.t277 108.945647554175
Riso9836 DVSS_B.t134 DVSS_B.t279 64.0976883711976
Riso9837 DVSS_B.t134 DVSS_B.t281 239.358913603908
Riso9838 DVSS_B.t134 DVSS_B.t283 274.316364113753
Riso9839 DVSS_B.t134 DVSS_B.t285 63.3736811975
Riso9840 DVSS_B.t134 DVSS_B.t287 74.2739785645732
Riso9841 DVSS_B.t134 DVSS_B.t288 24330.4508558166
Riso9842 DVSS_B.t134 DVSS_B.t289 181.350375513102
Riso9843 DVSS_B.t134 DVSS_B.t291 247.218186126518
Riso9844 DVSS_B.t134 DVSS_B.t293 365.395880187529
Riso9845 DVSS_B.t134 DVSS_B.t295 39.3363380188871
Riso9846 DVSS_B.t134 DVSS_B.t297 147.70733470254
Riso9847 DVSS_B.t134 DVSS_B.t299 335.17142526444
Riso9848 DVSS_B.t134 DVSS_B.t301 244.536646397758
Riso9849 DVSS_B.t134 DVSS_B.t302 30603.702423867
Riso9850 DVSS_B.t134 DVSS_B.t303 244.536646397758
Riso9851 DVSS_B.t134 DVSS_B.t305 164.72813396529
Riso9852 DVSS_B.t134 DVSS_B.t322 2097.42989764622
Riso9853 DVSS_B.t134 DVSS_B.t325 16374.3886373088
Riso9854 DVSS_B.t134 DVSS_B.t326 120.490989435447
Riso9855 DVSS_B.t134 DVSS_B.t329 439.820902147983
Riso9856 DVSS_B.t134 DVSS_B.t331 846.537721515256
Riso9857 DVSS_B.t134 DVSS_B.t333 801.862597018927
Riso9858 DVSS_B.t134 DVSS_B.t335 427.995612653555
Riso9859 DVSS_B.t134 DVSS_B.t337 388.704732276006
Riso9860 DVSS_B.t134 DVSS_B.t339 846.537721515256
Riso9861 DVSS_B.t134 DVSS_B.t341 801.862597018927
Riso9862 DVSS_B.t134 DVSS_B.t343 344.24075721018
Riso9863 DVSS_B.t134 DVSS_B.t345 170086.44874765
Riso9864 DVSS_B.t134 DVSS_B.t346 616.205302988533
Riso9865 DVSS_B.t134 DVSS_B.t348 86.5276290482057
Riso9866 DVSS_B.t134 DVSS_B.t35 46.5828304440546
Riso9867 DVSS_B.t134 DVSS_B.t350 457.545651349372
Riso9868 DVSS_B.t134 DVSS_B.t352 466.281427698003
Riso9869 DVSS_B.t134 DVSS_B.t355 555484.471992351
Riso9870 DVSS_B.t134 DVSS_B.t356 901.0188186106
Riso9871 DVSS_B.t134 DVSS_B.t358 197.484595998464
Riso9872 DVSS_B.t134 DVSS_B.t36 85830.1975318064
Riso9873 DVSS_B.t134 DVSS_B.t360 97.070356338543
Riso9874 DVSS_B.t134 DVSS_B.t364 239.358913603908
Riso9875 DVSS_B.t134 DVSS_B.t366 250.881994515347
Riso9876 DVSS_B.t134 DVSS_B.t37 1334.25846881591
Riso9877 DVSS_B.t134 DVSS_B.t509 250.881994515347
Riso9878 DVSS_B.t134 DVSS_B.t515 115.005629985564
Riso9879 DVSS_B.t134 DVSS_B.t525 1730.84245231961
Riso9880 DVSS_B.t134 DVSS_B.t529 54.8323913091115
Riso9881 DVSS_B.t134 DVSS_B.t531 115.005629985564
Riso9882 DVSS_B.t134 DVSS_B.t59 8099.49376769584
Riso9883 DVSS_B.t134 DVSS_B.t60 53.7797988369364
Riso9884 DVSS_B.t134 DVSS_B.t66 130.970490568235
Riso9885 DVSS_B.t134 DVSS_B.t68 335.17142526444
Riso9886 DVSS_B.t134 DVSS_B.t70 108.945647554175
Riso9887 DVSS_B.t134 DVSS_B.t72 213.680598999414
Riso9888 DVSS_B.t134 DVSS_B.t74 2097.42989764622
Riso9889 DVSS_B.t134 DVSS_B.t76 420.022180714473
Riso9890 DVSS_B.t134 DVSS_B.t80 394.112820536507
Riso9891 DVSS_B.t134 DVSS_B.t82 274.316364113753
Riso9892 DVSS_B.t134 DVSS_B.t84 1730.84245231961
Riso9893 DVSS_B.t134 DVSS_B.t89 16374.3886373088
Riso9894 DVSS_B.t134 DVSS_B.t90 162.399697753047
Riso9895 DVSS_B.t134 DVSS_B.t94 97.070356338543
Riso9896 DVSS_B.t134 DVSS_B.t96 180.14837815302
Riso9897 DVSS_B.t134 VSS_A 1500.40905814864
Riso9898 DVSS_B.t134 VSS_B 200.928239272637
Riso9899 DVSS_B.t142 DVSS_B.t278 66.3487
Riso9900 DVSS_B.t142 DVSS_B.t528 66.3487
Riso9901 DVSS_B.t143 DVSS_B.t148 155843.541063446
Riso9902 DVSS_B.t143 DVSS_B.t149 2123.86448774016
Riso9903 DVSS_B.t143 DVSS_B.t151 153.021161738706
Riso9904 DVSS_B.t143 DVSS_B.t153 85.8747825455195
Riso9905 DVSS_B.t143 DVSS_B.t155 132.803861239618
Riso9906 DVSS_B.t143 DVSS_B.t157 347.522660033029
Riso9907 DVSS_B.t143 DVSS_B.t159 575.716826559036
Riso9908 DVSS_B.t143 DVSS_B.t161 218.521217781216
Riso9909 DVSS_B.t143 DVSS_B.t162 34690.5328322013
Riso9910 DVSS_B.t143 DVSS_B.t163 347.522660033029
Riso9911 DVSS_B.t143 DVSS_B.t165 206.219303014057
Riso9912 DVSS_B.t143 DVSS_B.t167 198.204652562234
Riso9913 DVSS_B.t143 DVSS_B.t169 505.583934969606
Riso9914 DVSS_B.t143 DVSS_B.t173 2515.92973021671
Riso9915 DVSS_B.t143 DVSS_B.t177 263.131400120466
Riso9916 DVSS_B.t143 DVSS_B.t20 153497.18132599
Riso9917 DVSS_B.t143 DVSS_B.t202 2515.92973021671
Riso9918 DVSS_B.t143 DVSS_B.t204 82.7595259617916
Riso9919 DVSS_B.t143 DVSS_B.t206 40.337814292832
Riso9920 DVSS_B.t143 DVSS_B.t21 1802.46419310098
Riso9921 DVSS_B.t143 DVSS_B.t212 55.5007434259351
Riso9922 DVSS_B.t143 DVSS_B.t214 117.741717576346
Riso9923 DVSS_B.t143 DVSS_B.t215 158420.093222739
Riso9924 DVSS_B.t143 DVSS_B.t216 2123.86448774016
Riso9925 DVSS_B.t143 DVSS_B.t218 116.056780885282
Riso9926 DVSS_B.t143 DVSS_B.t225 176.854954431604
Riso9927 DVSS_B.t143 DVSS_B.t236 55.5007434259351
Riso9928 DVSS_B.t143 DVSS_B.t238 602.999913131121
Riso9929 DVSS_B.t143 DVSS_B.t240 47.5093959312749
Riso9930 DVSS_B.t143 DVSS_B.t250 153.021161738706
Riso9931 DVSS_B.t143 DVSS_B.t252 542.621503006612
Riso9932 DVSS_B.t143 DVSS_B.t256 241.267463887378
Riso9933 DVSS_B.t143 DVSS_B.t258 40.2286339578654
Riso9934 DVSS_B.t143 DVSS_B.t259 11270.3326320032
Riso9935 DVSS_B.t143 DVSS_B.t260 54.8323913091115
Riso9936 DVSS_B.t143 DVSS_B.t264 148.080806092254
Riso9937 DVSS_B.t143 DVSS_B.t266 176.854954431604
Riso9938 DVSS_B.t143 DVSS_B.t267 82922.7293864509
Riso9939 DVSS_B.t143 DVSS_B.t268 632.628943934657
Riso9940 DVSS_B.t143 DVSS_B.t271 622.553521818353
Riso9941 DVSS_B.t143 DVSS_B.t273 133.712532345989
Riso9942 DVSS_B.t143 DVSS_B.t275 426.132133170982
Riso9943 DVSS_B.t143 DVSS_B.t277 73.4089355661665
Riso9944 DVSS_B.t143 DVSS_B.t279 40.337814292832
Riso9945 DVSS_B.t143 DVSS_B.t281 188.859226814104
Riso9946 DVSS_B.t143 DVSS_B.t283 386.259520063712
Riso9947 DVSS_B.t143 DVSS_B.t285 100.11488522429
Riso9948 DVSS_B.t143 DVSS_B.t287 116.056780885282
Riso9949 DVSS_B.t143 DVSS_B.t288 34690.5328322013
Riso9950 DVSS_B.t143 DVSS_B.t289 263.131400120466
Riso9951 DVSS_B.t143 DVSS_B.t291 198.204652562234
Riso9952 DVSS_B.t143 DVSS_B.t293 505.583934969606
Riso9953 DVSS_B.t143 DVSS_B.t295 47.1978177563535
Riso9954 DVSS_B.t143 DVSS_B.t297 218.521217781216
Riso9955 DVSS_B.t143 DVSS_B.t299 466.282970277239
Riso9956 DVSS_B.t143 DVSS_B.t301 204.120878245618
Riso9957 DVSS_B.t143 DVSS_B.t302 26325.9978738146
Riso9958 DVSS_B.t143 DVSS_B.t303 204.120878245618
Riso9959 DVSS_B.t143 DVSS_B.t305 241.267463887378
Riso9960 DVSS_B.t143 DVSS_B.t322 2826.97511231578
Riso9961 DVSS_B.t143 DVSS_B.t325 11758.9011704138
Riso9962 DVSS_B.t143 DVSS_B.t326 82.7595259617916
Riso9963 DVSS_B.t143 DVSS_B.t329 585.996542926376
Riso9964 DVSS_B.t143 DVSS_B.t331 1130.9762013601
Riso9965 DVSS_B.t143 DVSS_B.t333 1074.87622321504
Riso9966 DVSS_B.t143 DVSS_B.t335 572.437222670577
Riso9967 DVSS_B.t143 DVSS_B.t337 517.490240229678
Riso9968 DVSS_B.t143 DVSS_B.t339 1130.9762013601
Riso9969 DVSS_B.t143 DVSS_B.t341 1074.87622321504
Riso9970 DVSS_B.t143 DVSS_B.t343 459.672806371962
Riso9971 DVSS_B.t143 DVSS_B.t345 224124.249721254
Riso9972 DVSS_B.t143 DVSS_B.t346 810.781444524079
Riso9973 DVSS_B.t143 DVSS_B.t348 133.712532345989
Riso9974 DVSS_B.t143 DVSS_B.t35 40.2286339578654
Riso9975 DVSS_B.t143 DVSS_B.t350 622.553521818353
Riso9976 DVSS_B.t143 DVSS_B.t352 632.628943934657
Riso9977 DVSS_B.t143 DVSS_B.t355 733700.115426526
Riso9978 DVSS_B.t143 DVSS_B.t356 1200.01731867696
Riso9979 DVSS_B.t143 DVSS_B.t358 148.080806092254
Riso9980 DVSS_B.t143 DVSS_B.t36 115951.119059176
Riso9981 DVSS_B.t143 DVSS_B.t360 64.2054738006034
Riso9982 DVSS_B.t143 DVSS_B.t364 188.859226814104
Riso9983 DVSS_B.t143 DVSS_B.t366 204.167731426459
Riso9984 DVSS_B.t143 DVSS_B.t37 1802.46419310098
Riso9985 DVSS_B.t143 DVSS_B.t509 204.167731426459
Riso9986 DVSS_B.t143 DVSS_B.t515 173.820139206805
Riso9987 DVSS_B.t143 DVSS_B.t525 2322.96078799772
Riso9988 DVSS_B.t143 DVSS_B.t529 0.0669631068894586
Riso9989 DVSS_B.t143 DVSS_B.t531 173.820139206805
Riso9990 DVSS_B.t143 DVSS_B.t59 11270.3326320032
Riso9991 DVSS_B.t143 DVSS_B.t60 85.8747825455195
Riso9992 DVSS_B.t143 DVSS_B.t66 195.811015301425
Riso9993 DVSS_B.t143 DVSS_B.t68 466.282970277239
Riso9994 DVSS_B.t143 DVSS_B.t70 73.4089355661665
Riso9995 DVSS_B.t143 DVSS_B.t72 162.998624157148
Riso9996 DVSS_B.t143 DVSS_B.t74 2826.97511231578
Riso9997 DVSS_B.t143 DVSS_B.t76 575.716826559036
Riso9998 DVSS_B.t143 DVSS_B.t80 542.621503006612
Riso9999 DVSS_B.t143 DVSS_B.t82 386.259520063712
Riso10000 DVSS_B.t143 DVSS_B.t84 2322.96078799772
Riso10001 DVSS_B.t143 DVSS_B.t89 11758.9011704138
Riso10002 DVSS_B.t143 DVSS_B.t90 117.741717576346
Riso10003 DVSS_B.t143 DVSS_B.t94 64.2054738006034
Riso10004 DVSS_B.t143 DVSS_B.t96 132.803861239618
Riso10005 DVSS_B.t143 VSS_A 1999.57002005633
Riso10006 DVSS_B.t143 VSS_B 270.663399697794
Riso10007 DVSS_B.t148 DVSS_B.t149 1174.23981678842
Riso10008 DVSS_B.t148 DVSS_B.t151 83037.6972579962
Riso10009 DVSS_B.t148 DVSS_B.t153 97482.9719900428
Riso10010 DVSS_B.t148 DVSS_B.t155 272604.907509399
Riso10011 DVSS_B.t148 DVSS_B.t157 42499.750063691
Riso10012 DVSS_B.t148 DVSS_B.t159 24970.611170041
Riso10013 DVSS_B.t148 DVSS_B.t161 65658.3727091231
Riso10014 DVSS_B.t148 DVSS_B.t162 5439923.46347654
Riso10015 DVSS_B.t148 DVSS_B.t163 42499.750063691
Riso10016 DVSS_B.t148 DVSS_B.t165 289638.733760529
Riso10017 DVSS_B.t148 DVSS_B.t167 305583.828619389
Riso10018 DVSS_B.t148 DVSS_B.t169 30582.9798285262
Riso10019 DVSS_B.t148 DVSS_B.t173 83132.2048232654
Riso10020 DVSS_B.t148 DVSS_B.t177 54227.0398810863
Riso10021 DVSS_B.t148 DVSS_B.t20 116817.355549289
Riso10022 DVSS_B.t148 DVSS_B.t202 83132.2048232654
Riso10023 DVSS_B.t148 DVSS_B.t204 224682.431160334
Riso10024 DVSS_B.t148 DVSS_B.t206 169777.313582884
Riso10025 DVSS_B.t148 DVSS_B.t21 1819.65582334241
Riso10026 DVSS_B.t148 DVSS_B.t212 196229.250222051
Riso10027 DVSS_B.t148 DVSS_B.t214 256726.520877424
Riso10028 DVSS_B.t148 DVSS_B.t215 8828.75544426523
Riso10029 DVSS_B.t148 DVSS_B.t216 1174.23981678842
Riso10030 DVSS_B.t148 DVSS_B.t218 92462.9171360485
Riso10031 DVSS_B.t148 DVSS_B.t225 303977.932426062
Riso10032 DVSS_B.t148 DVSS_B.t236 196229.250222051
Riso10033 DVSS_B.t148 DVSS_B.t238 22411.2584642445
Riso10034 DVSS_B.t148 DVSS_B.t240 183389.148798789
Riso10035 DVSS_B.t148 DVSS_B.t250 83037.6972579962
Riso10036 DVSS_B.t148 DVSS_B.t252 27702.0208290516
Riso10037 DVSS_B.t148 DVSS_B.t256 59841.0469807134
Riso10038 DVSS_B.t148 DVSS_B.t258 141955.56042273
Riso10039 DVSS_B.t148 DVSS_B.t259 5230929.33417427
Riso10040 DVSS_B.t148 DVSS_B.t260 115391.112746867
Riso10041 DVSS_B.t148 DVSS_B.t264 286223.853679133
Riso10042 DVSS_B.t148 DVSS_B.t266 303977.932426062
Riso10043 DVSS_B.t148 DVSS_B.t267 1984314.5008779
Riso10044 DVSS_B.t148 DVSS_B.t268 17844.8935460768
Riso10045 DVSS_B.t148 DVSS_B.t271 20035.0186889203
Riso10046 DVSS_B.t148 DVSS_B.t273 88145.1419383402
Riso10047 DVSS_B.t148 DVSS_B.t275 36620.1177138528
Riso10048 DVSS_B.t148 DVSS_B.t277 217453.029185659
Riso10049 DVSS_B.t148 DVSS_B.t279 169777.313582884
Riso10050 DVSS_B.t148 DVSS_B.t281 306977.707737007
Riso10051 DVSS_B.t148 DVSS_B.t283 39632.991189138
Riso10052 DVSS_B.t148 DVSS_B.t285 95677.1190041166
Riso10053 DVSS_B.t148 DVSS_B.t287 92462.9171360485
Riso10054 DVSS_B.t148 DVSS_B.t288 5439923.46347654
Riso10055 DVSS_B.t148 DVSS_B.t289 54227.0398810863
Riso10056 DVSS_B.t148 DVSS_B.t291 305583.828619389
Riso10057 DVSS_B.t148 DVSS_B.t293 30582.9798285262
Riso10058 DVSS_B.t148 DVSS_B.t295 128400.265577586
Riso10059 DVSS_B.t148 DVSS_B.t297 65658.3727091231
Riso10060 DVSS_B.t148 DVSS_B.t299 33575.285463532
Riso10061 DVSS_B.t148 DVSS_B.t301 275756.755002043
Riso10062 DVSS_B.t148 DVSS_B.t302 32188584.3935358
Riso10063 DVSS_B.t148 DVSS_B.t303 275756.755002043
Riso10064 DVSS_B.t148 DVSS_B.t305 59841.0469807134
Riso10065 DVSS_B.t148 DVSS_B.t322 93254.6932252343
Riso10066 DVSS_B.t148 DVSS_B.t325 26252271.0280576
Riso10067 DVSS_B.t148 DVSS_B.t326 224682.431160334
Riso10068 DVSS_B.t148 DVSS_B.t329 14618.7274931936
Riso10069 DVSS_B.t148 DVSS_B.t331 25443.1756815379
Riso10070 DVSS_B.t148 DVSS_B.t333 20729.5231749466
Riso10071 DVSS_B.t148 DVSS_B.t335 12088.3604063469
Riso10072 DVSS_B.t148 DVSS_B.t337 12148.8740121452
Riso10073 DVSS_B.t148 DVSS_B.t339 25443.1756815379
Riso10074 DVSS_B.t148 DVSS_B.t341 20729.5231749466
Riso10075 DVSS_B.t148 DVSS_B.t343 9122.76734196089
Riso10076 DVSS_B.t148 DVSS_B.t345 8092890.11974852
Riso10077 DVSS_B.t148 DVSS_B.t346 36302.2367532191
Riso10078 DVSS_B.t148 DVSS_B.t348 88145.1419383402
Riso10079 DVSS_B.t148 DVSS_B.t35 141955.56042273
Riso10080 DVSS_B.t148 DVSS_B.t350 20035.0186889203
Riso10081 DVSS_B.t148 DVSS_B.t352 17844.8935460768
Riso10082 DVSS_B.t148 DVSS_B.t355 22509742.9021322
Riso10083 DVSS_B.t148 DVSS_B.t356 40880.061388004
Riso10084 DVSS_B.t148 DVSS_B.t358 286223.853679133
Riso10085 DVSS_B.t148 DVSS_B.t36 355.448445822161
Riso10086 DVSS_B.t148 DVSS_B.t360 207774.740066817
Riso10087 DVSS_B.t148 DVSS_B.t364 306977.707737007
Riso10088 DVSS_B.t148 DVSS_B.t366 299735.070265904
Riso10089 DVSS_B.t148 DVSS_B.t37 1819.65582334241
Riso10090 DVSS_B.t148 DVSS_B.t509 299735.070265904
Riso10091 DVSS_B.t148 DVSS_B.t515 77430.666929944
Riso10092 DVSS_B.t148 DVSS_B.t525 77508.4474495604
Riso10093 DVSS_B.t148 DVSS_B.t529 155843.541063446
Riso10094 DVSS_B.t148 DVSS_B.t531 77430.666929944
Riso10095 DVSS_B.t148 DVSS_B.t59 5230929.33417427
Riso10096 DVSS_B.t148 DVSS_B.t60 97482.9719900428
Riso10097 DVSS_B.t148 DVSS_B.t66 71571.5417122216
Riso10098 DVSS_B.t148 DVSS_B.t68 33575.285463532
Riso10099 DVSS_B.t148 DVSS_B.t70 217453.029185659
Riso10100 DVSS_B.t148 DVSS_B.t72 296892.198590336
Riso10101 DVSS_B.t148 DVSS_B.t74 93254.6932252343
Riso10102 DVSS_B.t148 DVSS_B.t76 24970.611170041
Riso10103 DVSS_B.t148 DVSS_B.t80 27702.0208290516
Riso10104 DVSS_B.t148 DVSS_B.t82 39632.991189138
Riso10105 DVSS_B.t148 DVSS_B.t84 77508.4474495604
Riso10106 DVSS_B.t148 DVSS_B.t89 26252271.0280576
Riso10107 DVSS_B.t148 DVSS_B.t90 256726.520877424
Riso10108 DVSS_B.t148 DVSS_B.t94 207774.740066817
Riso10109 DVSS_B.t148 DVSS_B.t96 272604.907509399
Riso10110 DVSS_B.t148 VSS_A 51464.861188336
Riso10111 DVSS_B.t148 VSS_B 6256.05216099669
Riso10112 DVSS_B.t149 DVSS_B.t151 1131.61180128419
Riso10113 DVSS_B.t149 DVSS_B.t153 1328.22611317325
Riso10114 DVSS_B.t149 DVSS_B.t155 3716.7915678926
Riso10115 DVSS_B.t149 DVSS_B.t157 579.323695766906
Riso10116 DVSS_B.t149 DVSS_B.t159 340.731975831849
Riso10117 DVSS_B.t149 DVSS_B.t161 894.81960891215
Riso10118 DVSS_B.t149 DVSS_B.t162 74137.7196807307
Riso10119 DVSS_B.t149 DVSS_B.t163 579.323695766906
Riso10120 DVSS_B.t149 DVSS_B.t165 3949.07158768492
Riso10121 DVSS_B.t149 DVSS_B.t167 4166.71824272996
Riso10122 DVSS_B.t149 DVSS_B.t169 417.114931228516
Riso10123 DVSS_B.t149 DVSS_B.t173 1257.5905883367
Riso10124 DVSS_B.t149 DVSS_B.t177 739.061574108129
Riso10125 DVSS_B.t149 DVSS_B.t20 2019.407801609
Riso10126 DVSS_B.t149 DVSS_B.t202 1257.5905883367
Riso10127 DVSS_B.t149 DVSS_B.t204 3062.96717577838
Riso10128 DVSS_B.t149 DVSS_B.t206 2313.92458841985
Riso10129 DVSS_B.t149 DVSS_B.t21 24.5195627375037
Riso10130 DVSS_B.t149 DVSS_B.t212 2674.78097178792
Riso10131 DVSS_B.t149 DVSS_B.t214 3500.13836749136
Riso10132 DVSS_B.t149 DVSS_B.t215 1193.65345507479
Riso10133 DVSS_B.t149 DVSS_B.t216 0.7198038715213
Riso10134 DVSS_B.t149 DVSS_B.t218 1259.97226690772
Riso10135 DVSS_B.t149 DVSS_B.t225 4144.86599049757
Riso10136 DVSS_B.t149 DVSS_B.t236 2674.78097178792
Riso10137 DVSS_B.t149 DVSS_B.t238 305.899848295005
Riso10138 DVSS_B.t149 DVSS_B.t240 2499.61044774272
Riso10139 DVSS_B.t149 DVSS_B.t250 1131.61180128419
Riso10140 DVSS_B.t149 DVSS_B.t252 377.905408751209
Riso10141 DVSS_B.t149 DVSS_B.t256 815.55433493059
Riso10142 DVSS_B.t149 DVSS_B.t258 1934.44962983755
Riso10143 DVSS_B.t149 DVSS_B.t259 71189.8857666033
Riso10144 DVSS_B.t149 DVSS_B.t260 1572.21050854826
Riso10145 DVSS_B.t149 DVSS_B.t264 3902.62273900003
Riso10146 DVSS_B.t149 DVSS_B.t266 4144.86599049757
Riso10147 DVSS_B.t149 DVSS_B.t267 27102.4989264301
Riso10148 DVSS_B.t149 DVSS_B.t268 243.747490641345
Riso10149 DVSS_B.t149 DVSS_B.t271 273.558402987551
Riso10150 DVSS_B.t149 DVSS_B.t273 1201.18090126108
Riso10151 DVSS_B.t149 DVSS_B.t275 499.285736972116
Riso10152 DVSS_B.t149 DVSS_B.t277 2964.33901136751
Riso10153 DVSS_B.t149 DVSS_B.t279 2313.92458841985
Riso10154 DVSS_B.t149 DVSS_B.t281 4185.77398365015
Riso10155 DVSS_B.t149 DVSS_B.t283 540.297757716894
Riso10156 DVSS_B.t149 DVSS_B.t285 1303.70511255102
Riso10157 DVSS_B.t149 DVSS_B.t287 1259.97226690772
Riso10158 DVSS_B.t149 DVSS_B.t288 74137.7196807307
Riso10159 DVSS_B.t149 DVSS_B.t289 739.061574108129
Riso10160 DVSS_B.t149 DVSS_B.t291 4166.71824272996
Riso10161 DVSS_B.t149 DVSS_B.t293 417.114931228516
Riso10162 DVSS_B.t149 DVSS_B.t295 1749.59464889799
Riso10163 DVSS_B.t149 DVSS_B.t297 894.81960891215
Riso10164 DVSS_B.t149 DVSS_B.t299 457.84162694637
Riso10165 DVSS_B.t149 DVSS_B.t301 3759.63852788941
Riso10166 DVSS_B.t149 DVSS_B.t302 438772.442517721
Riso10167 DVSS_B.t149 DVSS_B.t303 3759.63852788941
Riso10168 DVSS_B.t149 DVSS_B.t305 815.55433493059
Riso10169 DVSS_B.t149 DVSS_B.t322 1399.17721668151
Riso10170 DVSS_B.t149 DVSS_B.t325 357844.645595919
Riso10171 DVSS_B.t149 DVSS_B.t326 3062.96717577838
Riso10172 DVSS_B.t149 DVSS_B.t329 199.928236778347
Riso10173 DVSS_B.t149 DVSS_B.t331 347.442597128555
Riso10174 DVSS_B.t149 DVSS_B.t333 282.149290746011
Riso10175 DVSS_B.t149 DVSS_B.t335 164.710331421615
Riso10176 DVSS_B.t149 DVSS_B.t337 166.105709087362
Riso10177 DVSS_B.t149 DVSS_B.t339 347.442597128555
Riso10178 DVSS_B.t149 DVSS_B.t341 282.149290746011
Riso10179 DVSS_B.t149 DVSS_B.t343 124.336765763888
Riso10180 DVSS_B.t149 DVSS_B.t345 172957.749592578
Riso10181 DVSS_B.t149 DVSS_B.t346 688.647477431631
Riso10182 DVSS_B.t149 DVSS_B.t348 1201.18090126108
Riso10183 DVSS_B.t149 DVSS_B.t35 1934.44962983755
Riso10184 DVSS_B.t149 DVSS_B.t350 273.558402987551
Riso10185 DVSS_B.t149 DVSS_B.t352 243.747490641345
Riso10186 DVSS_B.t149 DVSS_B.t355 511329.938048711
Riso10187 DVSS_B.t149 DVSS_B.t356 730.879516389674
Riso10188 DVSS_B.t149 DVSS_B.t358 3902.62273900003
Riso10189 DVSS_B.t149 DVSS_B.t36 1525.45207938451
Riso10190 DVSS_B.t149 DVSS_B.t360 2832.29656107666
Riso10191 DVSS_B.t149 DVSS_B.t364 4185.77398365015
Riso10192 DVSS_B.t149 DVSS_B.t366 4086.87057991939
Riso10193 DVSS_B.t149 DVSS_B.t37 24.5195627375037
Riso10194 DVSS_B.t149 DVSS_B.t509 4086.87057991939
Riso10195 DVSS_B.t149 DVSS_B.t515 1055.22265795635
Riso10196 DVSS_B.t149 DVSS_B.t525 1232.5095552274
Riso10197 DVSS_B.t149 DVSS_B.t529 2123.86448774016
Riso10198 DVSS_B.t149 DVSS_B.t531 1055.22265795635
Riso10199 DVSS_B.t149 DVSS_B.t59 71189.8857666033
Riso10200 DVSS_B.t149 DVSS_B.t60 1328.22611317325
Riso10201 DVSS_B.t149 DVSS_B.t66 975.390915890718
Riso10202 DVSS_B.t149 DVSS_B.t68 457.84162694637
Riso10203 DVSS_B.t149 DVSS_B.t70 2964.33901136751
Riso10204 DVSS_B.t149 DVSS_B.t72 4048.19146128993
Riso10205 DVSS_B.t149 DVSS_B.t74 1399.17721668151
Riso10206 DVSS_B.t149 DVSS_B.t76 340.731975831849
Riso10207 DVSS_B.t149 DVSS_B.t80 377.905408751209
Riso10208 DVSS_B.t149 DVSS_B.t82 540.297757716894
Riso10209 DVSS_B.t149 DVSS_B.t84 1232.5095552274
Riso10210 DVSS_B.t149 DVSS_B.t89 357844.645595919
Riso10211 DVSS_B.t149 DVSS_B.t90 3500.13836749136
Riso10212 DVSS_B.t149 DVSS_B.t94 2832.29656107666
Riso10213 DVSS_B.t149 DVSS_B.t96 3716.7915678926
Riso10214 DVSS_B.t149 VSS_A 703.968886632642
Riso10215 DVSS_B.t149 VSS_B 85.0104598329013
Riso10216 DVSS_B.t150 DVSS_B.t249 66.3487
Riso10217 DVSS_B.t150 DVSS_B.t347 66.3487
Riso10218 DVSS_B.t151 DVSS_B.t153 64.9165199594325
Riso10219 DVSS_B.t151 DVSS_B.t155 382.64962631451
Riso10220 DVSS_B.t151 DVSS_B.t157 111.533655489254
Riso10221 DVSS_B.t151 DVSS_B.t159 231.704403987765
Riso10222 DVSS_B.t151 DVSS_B.t161 56.2174109034491
Riso10223 DVSS_B.t151 DVSS_B.t162 10903.6832094396
Riso10224 DVSS_B.t151 DVSS_B.t163 111.533655489254
Riso10225 DVSS_B.t151 DVSS_B.t165 472.993773132697
Riso10226 DVSS_B.t151 DVSS_B.t167 479.661992024892
Riso10227 DVSS_B.t151 DVSS_B.t169 188.755979333325
Riso10228 DVSS_B.t151 DVSS_B.t173 1181.07341951412
Riso10229 DVSS_B.t151 DVSS_B.t177 74.3817418629053
Riso10230 DVSS_B.t151 DVSS_B.t20 81929.1409717417
Riso10231 DVSS_B.t151 DVSS_B.t202 1181.07341951412
Riso10232 DVSS_B.t151 DVSS_B.t204 281.425793249431
Riso10233 DVSS_B.t151 DVSS_B.t206 173.715177751818
Riso10234 DVSS_B.t151 DVSS_B.t21 960.35609311862
Riso10235 DVSS_B.t151 DVSS_B.t212 217.967918143908
Riso10236 DVSS_B.t151 DVSS_B.t214 352.291731781694
Riso10237 DVSS_B.t151 DVSS_B.t215 84410.5546553117
Riso10238 DVSS_B.t151 DVSS_B.t216 1131.61180128419
Riso10239 DVSS_B.t151 DVSS_B.t218 48.0502522241637
Riso10240 DVSS_B.t151 DVSS_B.t225 456.741889505727
Riso10241 DVSS_B.t151 DVSS_B.t236 217.967918143908
Riso10242 DVSS_B.t151 DVSS_B.t238 251.74064281669
Riso10243 DVSS_B.t151 DVSS_B.t240 195.523461033595
Riso10244 DVSS_B.t151 DVSS_B.t250 0.0669644729967823
Riso10245 DVSS_B.t151 DVSS_B.t252 210.377405142835
Riso10246 DVSS_B.t151 DVSS_B.t256 65.063609472613
Riso10247 DVSS_B.t151 DVSS_B.t258 133.755482870674
Riso10248 DVSS_B.t151 DVSS_B.t259 12783.9267833552
Riso10249 DVSS_B.t151 DVSS_B.t260 100.13086294793
Riso10250 DVSS_B.t151 DVSS_B.t264 411.008229675483
Riso10251 DVSS_B.t151 DVSS_B.t266 456.741889505727
Riso10252 DVSS_B.t151 DVSS_B.t267 40490.5137345776
Riso10253 DVSS_B.t151 DVSS_B.t268 283.038332471676
Riso10254 DVSS_B.t151 DVSS_B.t271 269.288762490318
Riso10255 DVSS_B.t151 DVSS_B.t273 40.7811341923897
Riso10256 DVSS_B.t151 DVSS_B.t275 147.473784546657
Riso10257 DVSS_B.t151 DVSS_B.t277 261.886581705179
Riso10258 DVSS_B.t151 DVSS_B.t279 173.715177751818
Riso10259 DVSS_B.t151 DVSS_B.t281 471.598657962362
Riso10260 DVSS_B.t151 DVSS_B.t283 128.714943374255
Riso10261 DVSS_B.t151 DVSS_B.t285 56.1385988359652
Riso10262 DVSS_B.t151 DVSS_B.t287 48.0502522241637
Riso10263 DVSS_B.t151 DVSS_B.t288 10903.6832094396
Riso10264 DVSS_B.t151 DVSS_B.t289 74.3817418629053
Riso10265 DVSS_B.t151 DVSS_B.t291 479.661992024892
Riso10266 DVSS_B.t151 DVSS_B.t293 188.755979333325
Riso10267 DVSS_B.t151 DVSS_B.t295 116.099282644295
Riso10268 DVSS_B.t151 DVSS_B.t297 56.2174109034491
Riso10269 DVSS_B.t151 DVSS_B.t299 167.606173922606
Riso10270 DVSS_B.t151 DVSS_B.t301 458.232207163574
Riso10271 DVSS_B.t151 DVSS_B.t302 56105.2209865995
Riso10272 DVSS_B.t151 DVSS_B.t303 458.232207163574
Riso10273 DVSS_B.t151 DVSS_B.t305 65.063609472613
Riso10274 DVSS_B.t151 DVSS_B.t322 1322.24686845801
Riso10275 DVSS_B.t151 DVSS_B.t325 36088.0784306968
Riso10276 DVSS_B.t151 DVSS_B.t326 281.425793249431
Riso10277 DVSS_B.t151 DVSS_B.t329 338.095462056786
Riso10278 DVSS_B.t151 DVSS_B.t331 646.378918610669
Riso10279 DVSS_B.t151 DVSS_B.t333 617.978144417203
Riso10280 DVSS_B.t151 DVSS_B.t335 332.437294346508
Riso10281 DVSS_B.t151 DVSS_B.t337 292.260828597205
Riso10282 DVSS_B.t151 DVSS_B.t339 646.378918610669
Riso10283 DVSS_B.t151 DVSS_B.t341 617.978144417203
Riso10284 DVSS_B.t151 DVSS_B.t343 258.097882306523
Riso10285 DVSS_B.t151 DVSS_B.t345 120643.0346043
Riso10286 DVSS_B.t151 DVSS_B.t346 440.682581281736
Riso10287 DVSS_B.t151 DVSS_B.t348 40.7811341923897
Riso10288 DVSS_B.t151 DVSS_B.t35 133.755482870674
Riso10289 DVSS_B.t151 DVSS_B.t350 269.288762490318
Riso10290 DVSS_B.t151 DVSS_B.t352 283.038332471676
Riso10291 DVSS_B.t151 DVSS_B.t355 388889.89363102
Riso10292 DVSS_B.t151 DVSS_B.t356 603.242968524624
Riso10293 DVSS_B.t151 DVSS_B.t358 411.008229675483
Riso10294 DVSS_B.t151 DVSS_B.t36 61888.9252373647
Riso10295 DVSS_B.t151 DVSS_B.t360 240.379778812707
Riso10296 DVSS_B.t151 DVSS_B.t364 471.598657962362
Riso10297 DVSS_B.t151 DVSS_B.t366 480.217027940053
Riso10298 DVSS_B.t151 DVSS_B.t37 960.35609311862
Riso10299 DVSS_B.t151 DVSS_B.t509 480.217027940053
Riso10300 DVSS_B.t151 DVSS_B.t515 40.7942809461268
Riso10301 DVSS_B.t151 DVSS_B.t525 1114.29562103681
Riso10302 DVSS_B.t151 DVSS_B.t529 153.021161738706
Riso10303 DVSS_B.t151 DVSS_B.t531 40.7942809461268
Riso10304 DVSS_B.t151 DVSS_B.t59 12783.9267833552
Riso10305 DVSS_B.t151 DVSS_B.t60 64.9165199594325
Riso10306 DVSS_B.t151 DVSS_B.t66 48.0874934445253
Riso10307 DVSS_B.t151 DVSS_B.t68 167.606173922606
Riso10308 DVSS_B.t151 DVSS_B.t70 261.886581705179
Riso10309 DVSS_B.t151 DVSS_B.t72 436.134544023013
Riso10310 DVSS_B.t151 DVSS_B.t74 1322.24686845801
Riso10311 DVSS_B.t151 DVSS_B.t76 231.704403987765
Riso10312 DVSS_B.t151 DVSS_B.t80 210.377405142835
Riso10313 DVSS_B.t151 DVSS_B.t82 128.714943374255
Riso10314 DVSS_B.t151 DVSS_B.t84 1114.29562103681
Riso10315 DVSS_B.t151 DVSS_B.t89 36088.0784306968
Riso10316 DVSS_B.t151 DVSS_B.t90 352.291731781694
Riso10317 DVSS_B.t151 DVSS_B.t94 240.379778812707
Riso10318 DVSS_B.t151 DVSS_B.t96 382.64962631451
Riso10319 DVSS_B.t151 VSS_A 1165.1114871259
Riso10320 DVSS_B.t151 VSS_B 174.106920759966
Riso10321 DVSS_B.t152 DVSS_B.t284 66.3487
Riso10322 DVSS_B.t152 DVSS_B.t59 66.3487
Riso10323 DVSS_B.t153 DVSS_B.t155 243.007752228815
Riso10324 DVSS_B.t153 DVSS_B.t157 178.279357304186
Riso10325 DVSS_B.t153 DVSS_B.t159 327.163102595158
Riso10326 DVSS_B.t153 DVSS_B.t161 100.073932320985
Riso10327 DVSS_B.t153 DVSS_B.t162 17596.6421664006
Riso10328 DVSS_B.t153 DVSS_B.t163 178.279357304186
Riso10329 DVSS_B.t153 DVSS_B.t165 312.62790815385
Riso10330 DVSS_B.t153 DVSS_B.t167 314.732131921202
Riso10331 DVSS_B.t153 DVSS_B.t169 278.233698099827
Riso10332 DVSS_B.t153 DVSS_B.t173 1524.27135243234
Riso10333 DVSS_B.t153 DVSS_B.t177 126.672952128409
Riso10334 DVSS_B.t153 DVSS_B.t20 96042.5977667053
Riso10335 DVSS_B.t153 DVSS_B.t202 1524.27135243234
Riso10336 DVSS_B.t153 DVSS_B.t204 171.823249801803
Riso10337 DVSS_B.t153 DVSS_B.t206 98.9549925743394
Riso10338 DVSS_B.t153 DVSS_B.t21 1127.19949677682
Riso10339 DVSS_B.t153 DVSS_B.t212 127.867970069098
Riso10340 DVSS_B.t153 DVSS_B.t214 221.81785222355
Riso10341 DVSS_B.t153 DVSS_B.t215 99094.6522705427
Riso10342 DVSS_B.t153 DVSS_B.t216 1328.22611317325
Riso10343 DVSS_B.t153 DVSS_B.t218 46.8793194804254
Riso10344 DVSS_B.t153 DVSS_B.t225 296.495015805917
Riso10345 DVSS_B.t153 DVSS_B.t236 127.867970069098
Riso10346 DVSS_B.t153 DVSS_B.t238 347.828006380335
Riso10347 DVSS_B.t153 DVSS_B.t240 113.042834835847
Riso10348 DVSS_B.t153 DVSS_B.t250 64.9165199594325
Riso10349 DVSS_B.t153 DVSS_B.t252 303.545622349064
Riso10350 DVSS_B.t153 DVSS_B.t256 113.322506210338
Riso10351 DVSS_B.t153 DVSS_B.t258 73.9548992981842
Riso10352 DVSS_B.t153 DVSS_B.t259 8151.72033113199
Riso10353 DVSS_B.t153 DVSS_B.t260 53.7797988369364
Riso10354 DVSS_B.t153 DVSS_B.t264 263.114464325832
Riso10355 DVSS_B.t153 DVSS_B.t266 296.495015805917
Riso10356 DVSS_B.t153 DVSS_B.t267 50702.6789070936
Riso10357 DVSS_B.t153 DVSS_B.t268 374.8815524328
Riso10358 DVSS_B.t153 DVSS_B.t271 364.177203165801
Riso10359 DVSS_B.t153 DVSS_B.t273 55.3336109699856
Riso10360 DVSS_B.t153 DVSS_B.t275 226.599250324412
Riso10361 DVSS_B.t153 DVSS_B.t277 157.913156982994
Riso10362 DVSS_B.t153 DVSS_B.t279 98.9549925743394
Riso10363 DVSS_B.t153 DVSS_B.t281 307.916852757511
Riso10364 DVSS_B.t153 DVSS_B.t283 201.774937638429
Riso10365 DVSS_B.t153 DVSS_B.t285 39.5043755607894
Riso10366 DVSS_B.t153 DVSS_B.t287 46.8793194804254
Riso10367 DVSS_B.t153 DVSS_B.t288 17596.6421664006
Riso10368 DVSS_B.t153 DVSS_B.t289 126.672952128409
Riso10369 DVSS_B.t153 DVSS_B.t291 314.732131921202
Riso10370 DVSS_B.t153 DVSS_B.t293 278.233698099827
Riso10371 DVSS_B.t153 DVSS_B.t295 63.2576685975986
Riso10372 DVSS_B.t153 DVSS_B.t297 100.073932320985
Riso10373 DVSS_B.t153 DVSS_B.t299 252.299690161954
Riso10374 DVSS_B.t153 DVSS_B.t301 303.603284738556
Riso10375 DVSS_B.t153 DVSS_B.t302 37330.8492652752
Riso10376 DVSS_B.t153 DVSS_B.t303 303.603284738556
Riso10377 DVSS_B.t153 DVSS_B.t305 113.322506210338
Riso10378 DVSS_B.t153 DVSS_B.t322 1710.02631543506
Riso10379 DVSS_B.t153 DVSS_B.t325 22530.3477113651
Riso10380 DVSS_B.t153 DVSS_B.t326 171.823249801803
Riso10381 DVSS_B.t153 DVSS_B.t329 379.779685271877
Riso10382 DVSS_B.t153 DVSS_B.t331 729.519583979635
Riso10383 DVSS_B.t153 DVSS_B.t333 692.591708146091
Riso10384 DVSS_B.t153 DVSS_B.t335 370.528945137889
Riso10385 DVSS_B.t153 DVSS_B.t337 333.511707239
Riso10386 DVSS_B.t153 DVSS_B.t339 729.519583979635
Riso10387 DVSS_B.t153 DVSS_B.t341 692.591708146091
Riso10388 DVSS_B.t153 DVSS_B.t343 295.026897322454
Riso10389 DVSS_B.t153 DVSS_B.t345 143681.866893432
Riso10390 DVSS_B.t153 DVSS_B.t346 521.778231201172
Riso10391 DVSS_B.t153 DVSS_B.t348 55.3336109699856
Riso10392 DVSS_B.t153 DVSS_B.t35 73.9548992981842
Riso10393 DVSS_B.t153 DVSS_B.t350 364.177203165801
Riso10394 DVSS_B.t153 DVSS_B.t352 374.8815524328
Riso10395 DVSS_B.t153 DVSS_B.t355 467472.55361771
Riso10396 DVSS_B.t153 DVSS_B.t356 748.299945616457
Riso10397 DVSS_B.t153 DVSS_B.t358 263.114464325832
Riso10398 DVSS_B.t153 DVSS_B.t36 72550.1705777198
Riso10399 DVSS_B.t153 DVSS_B.t360 143.016453240048
Riso10400 DVSS_B.t153 DVSS_B.t364 307.916852757511
Riso10401 DVSS_B.t153 DVSS_B.t366 316.381914288853
Riso10402 DVSS_B.t153 DVSS_B.t37 1127.19949677682
Riso10403 DVSS_B.t153 DVSS_B.t509 316.381914288853
Riso10404 DVSS_B.t153 DVSS_B.t515 75.6306133041057
Riso10405 DVSS_B.t153 DVSS_B.t525 1420.40222543595
Riso10406 DVSS_B.t153 DVSS_B.t529 85.8747825455195
Riso10407 DVSS_B.t153 DVSS_B.t531 75.6306133041057
Riso10408 DVSS_B.t153 DVSS_B.t59 8151.72033113199
Riso10409 DVSS_B.t153 DVSS_B.t60 0.0669595938190592
Riso10410 DVSS_B.t153 DVSS_B.t66 87.4069242797085
Riso10411 DVSS_B.t153 DVSS_B.t68 252.299690161954
Riso10412 DVSS_B.t153 DVSS_B.t70 157.913156982994
Riso10413 DVSS_B.t153 DVSS_B.t72 281.256204015835
Riso10414 DVSS_B.t153 DVSS_B.t74 1710.02631543506
Riso10415 DVSS_B.t153 DVSS_B.t76 327.163102595158
Riso10416 DVSS_B.t153 DVSS_B.t80 303.545622349064
Riso10417 DVSS_B.t153 DVSS_B.t82 201.774937638429
Riso10418 DVSS_B.t153 DVSS_B.t84 1420.40222543595
Riso10419 DVSS_B.t153 DVSS_B.t89 22530.3477113651
Riso10420 DVSS_B.t153 DVSS_B.t90 221.81785222355
Riso10421 DVSS_B.t153 DVSS_B.t94 143.016453240048
Riso10422 DVSS_B.t153 DVSS_B.t96 243.007752228815
Riso10423 DVSS_B.t153 VSS_A 1299.31854053936
Riso10424 DVSS_B.t153 VSS_B 179.155604952756
Riso10425 DVSS_B.t154 DVSS_B.t357 66.3487
Riso10426 DVSS_B.t154 DVSS_B.t95 66.3487
Riso10427 DVSS_B.t155 DVSS_B.t157 712.739786382861
Riso10428 DVSS_B.t155 DVSS_B.t159 1079.84577104399
Riso10429 DVSS_B.t155 DVSS_B.t161 501.320341360051
Riso10430 DVSS_B.t155 DVSS_B.t162 71691.1467683795
Riso10431 DVSS_B.t155 DVSS_B.t163 712.739786382861
Riso10432 DVSS_B.t155 DVSS_B.t165 67.3816326394865
Riso10433 DVSS_B.t155 DVSS_B.t167 59.2903242208422
Riso10434 DVSS_B.t155 DVSS_B.t169 975.247973283235
Riso10435 DVSS_B.t155 DVSS_B.t173 4394.55328284415
Riso10436 DVSS_B.t155 DVSS_B.t177 573.231930994408
Riso10437 DVSS_B.t155 DVSS_B.t20 268436.821470259
Riso10438 DVSS_B.t155 DVSS_B.t202 4394.55328284415
Riso10439 DVSS_B.t155 DVSS_B.t204 56.3160214267571
Riso10440 DVSS_B.t155 DVSS_B.t206 117.298463198008
Riso10441 DVSS_B.t155 DVSS_B.t21 3154.49876083327
Riso10442 DVSS_B.t155 DVSS_B.t212 89.2266897151904
Riso10443 DVSS_B.t155 DVSS_B.t214 35.9750167198669
Riso10444 DVSS_B.t155 DVSS_B.t215 277111.868518398
Riso10445 DVSS_B.t155 DVSS_B.t216 3716.7915678926
Riso10446 DVSS_B.t155 DVSS_B.t218 308.50546699101
Riso10447 DVSS_B.t155 DVSS_B.t225 47.8963494175188
Riso10448 DVSS_B.t155 DVSS_B.t236 89.2266897151904
Riso10449 DVSS_B.t155 DVSS_B.t238 1116.17945814663
Riso10450 DVSS_B.t155 DVSS_B.t240 102.698565104169
Riso10451 DVSS_B.t155 DVSS_B.t250 382.64962631451
Riso10452 DVSS_B.t155 DVSS_B.t252 1031.88028186083
Riso10453 DVSS_B.t155 DVSS_B.t256 538.986454456892
Riso10454 DVSS_B.t155 DVSS_B.t258 148.846166999463
Riso10455 DVSS_B.t155 DVSS_B.t259 17936.7292764332
Riso10456 DVSS_B.t155 DVSS_B.t260 180.14837815302
Riso10457 DVSS_B.t155 DVSS_B.t264 36.3018354734837
Riso10458 DVSS_B.t155 DVSS_B.t266 47.8963494175188
Riso10459 DVSS_B.t155 DVSS_B.t267 145619.002563196
Riso10460 DVSS_B.t155 DVSS_B.t268 1142.9792332114
Riso10461 DVSS_B.t155 DVSS_B.t271 1138.02219923121
Riso10462 DVSS_B.t155 DVSS_B.t273 344.651394398038
Riso10463 DVSS_B.t155 DVSS_B.t275 846.859036807886
Riso10464 DVSS_B.t155 DVSS_B.t277 66.0321050096979
Riso10465 DVSS_B.t155 DVSS_B.t279 117.298463198008
Riso10466 DVSS_B.t155 DVSS_B.t281 53.7888658786224
Riso10467 DVSS_B.t155 DVSS_B.t283 779.639221331199
Riso10468 DVSS_B.t155 DVSS_B.t285 274.556206497031
Riso10469 DVSS_B.t155 DVSS_B.t287 308.50546699101
Riso10470 DVSS_B.t155 DVSS_B.t288 71691.1467683795
Riso10471 DVSS_B.t155 DVSS_B.t289 573.231930994408
Riso10472 DVSS_B.t155 DVSS_B.t291 59.2903242208422
Riso10473 DVSS_B.t155 DVSS_B.t293 975.247973283235
Riso10474 DVSS_B.t155 DVSS_B.t295 164.877233742514
Riso10475 DVSS_B.t155 DVSS_B.t297 501.320341360051
Riso10476 DVSS_B.t155 DVSS_B.t299 912.750378633478
Riso10477 DVSS_B.t155 DVSS_B.t301 69.1584453820539
Riso10478 DVSS_B.t155 DVSS_B.t302 9743.56876149187
Riso10479 DVSS_B.t155 DVSS_B.t303 69.1584453820539
Riso10480 DVSS_B.t155 DVSS_B.t305 538.986454456892
Riso10481 DVSS_B.t155 DVSS_B.t322 4943.88692178841
Riso10482 DVSS_B.t155 DVSS_B.t325 5433.92135345516
Riso10483 DVSS_B.t155 DVSS_B.t326 56.3160214267571
Riso10484 DVSS_B.t155 DVSS_B.t329 974.01362481009
Riso10485 DVSS_B.t155 DVSS_B.t331 1887.50974676565
Riso10486 DVSS_B.t155 DVSS_B.t333 1796.85673821514
Riso10487 DVSS_B.t155 DVSS_B.t335 952.761622049252
Riso10488 DVSS_B.t155 DVSS_B.t337 866.020260406811
Riso10489 DVSS_B.t155 DVSS_B.t339 1887.50974676565
Riso10490 DVSS_B.t155 DVSS_B.t341 1796.85673821514
Riso10491 DVSS_B.t155 DVSS_B.t343 773.066374963921
Riso10492 DVSS_B.t155 DVSS_B.t345 375474.207016845
Riso10493 DVSS_B.t155 DVSS_B.t346 1354.62750122548
Riso10494 DVSS_B.t155 DVSS_B.t348 344.651394398038
Riso10495 DVSS_B.t155 DVSS_B.t35 148.846166999463
Riso10496 DVSS_B.t155 DVSS_B.t350 1138.02219923121
Riso10497 DVSS_B.t155 DVSS_B.t352 1142.9792332114
Riso10498 DVSS_B.t155 DVSS_B.t355 1234541.34812686
Riso10499 DVSS_B.t155 DVSS_B.t356 2050.85512421553
Riso10500 DVSS_B.t155 DVSS_B.t358 36.3018354734837
Riso10501 DVSS_B.t155 DVSS_B.t36 202776.035216319
Riso10502 DVSS_B.t155 DVSS_B.t360 76.9941948892923
Riso10503 DVSS_B.t155 DVSS_B.t364 53.7888658786224
Riso10504 DVSS_B.t155 DVSS_B.t366 63.9687559536165
Riso10505 DVSS_B.t155 DVSS_B.t37 3154.49876083327
Riso10506 DVSS_B.t155 DVSS_B.t509 63.9687559536165
Riso10507 DVSS_B.t155 DVSS_B.t515 421.974451465561
Riso10508 DVSS_B.t155 DVSS_B.t525 4028.8150682937
Riso10509 DVSS_B.t155 DVSS_B.t529 132.803861239618
Riso10510 DVSS_B.t155 DVSS_B.t531 421.974451465561
Riso10511 DVSS_B.t155 DVSS_B.t59 17936.7292764332
Riso10512 DVSS_B.t155 DVSS_B.t60 243.007752228815
Riso10513 DVSS_B.t155 DVSS_B.t66 461.872991728401
Riso10514 DVSS_B.t155 DVSS_B.t68 912.750378633478
Riso10515 DVSS_B.t155 DVSS_B.t70 66.0321050096979
Riso10516 DVSS_B.t155 DVSS_B.t72 41.9770570005495
Riso10517 DVSS_B.t155 DVSS_B.t74 4943.88692178841
Riso10518 DVSS_B.t155 DVSS_B.t76 1079.84577104399
Riso10519 DVSS_B.t155 DVSS_B.t80 1031.88028186083
Riso10520 DVSS_B.t155 DVSS_B.t82 779.639221331199
Riso10521 DVSS_B.t155 DVSS_B.t84 4028.8150682937
Riso10522 DVSS_B.t155 DVSS_B.t89 5433.92135345516
Riso10523 DVSS_B.t155 DVSS_B.t90 35.9750167198669
Riso10524 DVSS_B.t155 DVSS_B.t94 76.9941948892923
Riso10525 DVSS_B.t155 DVSS_B.t96 0.0669505116269896
Riso10526 DVSS_B.t155 VSS_A 3313.25269949298
Riso10527 DVSS_B.t155 VSS_B 438.421699100751
Riso10528 DVSS_B.t156 DVSS_B.t162 66.3487
Riso10529 DVSS_B.t156 DVSS_B.t81 66.3487
Riso10530 DVSS_B.t157 DVSS_B.t159 81.8911724869594
Riso10531 DVSS_B.t157 DVSS_B.t161 71.3200989987613
Riso10532 DVSS_B.t157 DVSS_B.t162 4929.08458510493
Riso10533 DVSS_B.t157 DVSS_B.t163 0.0669551025982485
Riso10534 DVSS_B.t157 DVSS_B.t165 821.05872182601
Riso10535 DVSS_B.t157 DVSS_B.t167 845.756866887152
Riso10536 DVSS_B.t157 DVSS_B.t169 61.9974472219196
Riso10537 DVSS_B.t157 DVSS_B.t173 474.767117194336
Riso10538 DVSS_B.t157 DVSS_B.t177 51.3537434843255
Riso10539 DVSS_B.t157 DVSS_B.t20 41991.8840541086
Riso10540 DVSS_B.t157 DVSS_B.t202 474.767117194336
Riso10541 DVSS_B.t157 DVSS_B.t204 557.485954050173
Riso10542 DVSS_B.t157 DVSS_B.t206 384.931604244092
Riso10543 DVSS_B.t157 DVSS_B.t21 491.661267426074
Riso10544 DVSS_B.t157 DVSS_B.t212 460.555343198971
Riso10545 DVSS_B.t157 DVSS_B.t214 664.731980596939
Riso10546 DVSS_B.t157 DVSS_B.t215 43202.3959484596
Riso10547 DVSS_B.t157 DVSS_B.t216 579.323695766906
Riso10548 DVSS_B.t157 DVSS_B.t218 144.27707938407
Riso10549 DVSS_B.t157 DVSS_B.t225 821.285965472145
Riso10550 DVSS_B.t157 DVSS_B.t236 460.555343198971
Riso10551 DVSS_B.t157 DVSS_B.t238 92.343219038709
Riso10552 DVSS_B.t157 DVSS_B.t240 422.935267274999
Riso10553 DVSS_B.t157 DVSS_B.t250 111.533655489254
Riso10554 DVSS_B.t157 DVSS_B.t252 71.6539647462688
Riso10555 DVSS_B.t157 DVSS_B.t256 60.6770563199413
Riso10556 DVSS_B.t157 DVSS_B.t258 311.442835995061
Riso10557 DVSS_B.t157 DVSS_B.t259 20253.2352385158
Riso10558 DVSS_B.t157 DVSS_B.t260 245.186423879089
Riso10559 DVSS_B.t157 DVSS_B.t264 756.129593837453
Riso10560 DVSS_B.t157 DVSS_B.t266 821.285965472145
Riso10561 DVSS_B.t157 DVSS_B.t267 17559.393457777
Riso10562 DVSS_B.t157 DVSS_B.t268 111.598709116481
Riso10563 DVSS_B.t157 DVSS_B.t271 102.476923084952
Riso10564 DVSS_B.t157 DVSS_B.t273 127.472546662925
Riso10565 DVSS_B.t157 DVSS_B.t275 45.1930296028835
Riso10566 DVSS_B.t157 DVSS_B.t277 529.426758340874
Riso10567 DVSS_B.t157 DVSS_B.t279 384.931604244092
Riso10568 DVSS_B.t157 DVSS_B.t281 839.348019014978
Riso10569 DVSS_B.t157 DVSS_B.t283 38.1774208156255
Riso10570 DVSS_B.t157 DVSS_B.t285 161.451292988835
Riso10571 DVSS_B.t157 DVSS_B.t287 144.27707938407
Riso10572 DVSS_B.t157 DVSS_B.t288 4929.08458510493
Riso10573 DVSS_B.t157 DVSS_B.t289 51.3537434843255
Riso10574 DVSS_B.t157 DVSS_B.t291 845.756866887152
Riso10575 DVSS_B.t157 DVSS_B.t293 61.9974472219196
Riso10576 DVSS_B.t157 DVSS_B.t295 277.214909619886
Riso10577 DVSS_B.t157 DVSS_B.t297 71.3200989987613
Riso10578 DVSS_B.t157 DVSS_B.t299 53.1416086115977
Riso10579 DVSS_B.t157 DVSS_B.t301 790.528085348893
Riso10580 DVSS_B.t157 DVSS_B.t302 95386.6655189855
Riso10581 DVSS_B.t157 DVSS_B.t303 790.528085348893
Riso10582 DVSS_B.t157 DVSS_B.t305 60.6770563199413
Riso10583 DVSS_B.t157 DVSS_B.t322 528.66345423479
Riso10584 DVSS_B.t157 DVSS_B.t325 68652.5090812305
Riso10585 DVSS_B.t157 DVSS_B.t326 557.485954050173
Riso10586 DVSS_B.t157 DVSS_B.t329 184.662937462476
Riso10587 DVSS_B.t157 DVSS_B.t331 344.519765849641
Riso10588 DVSS_B.t157 DVSS_B.t333 329.057954922643
Riso10589 DVSS_B.t157 DVSS_B.t335 180.744914189729
Riso10590 DVSS_B.t157 DVSS_B.t337 156.939705570187
Riso10591 DVSS_B.t157 DVSS_B.t339 344.519765849641
Riso10592 DVSS_B.t157 DVSS_B.t341 329.057954922643
Riso10593 DVSS_B.t157 DVSS_B.t343 136.820184567762
Riso10594 DVSS_B.t157 DVSS_B.t345 61923.0274468314
Riso10595 DVSS_B.t157 DVSS_B.t346 231.059680892629
Riso10596 DVSS_B.t157 DVSS_B.t348 127.472546662925
Riso10597 DVSS_B.t157 DVSS_B.t35 311.442835995061
Riso10598 DVSS_B.t157 DVSS_B.t350 102.476923084952
Riso10599 DVSS_B.t157 DVSS_B.t352 111.598709116481
Riso10600 DVSS_B.t157 DVSS_B.t355 193201.779276518
Riso10601 DVSS_B.t157 DVSS_B.t356 270.861953512135
Riso10602 DVSS_B.t157 DVSS_B.t358 756.129593837453
Riso10603 DVSS_B.t157 DVSS_B.t36 31720.490926387
Riso10604 DVSS_B.t157 DVSS_B.t360 496.550881867929
Riso10605 DVSS_B.t157 DVSS_B.t364 839.348019014978
Riso10606 DVSS_B.t157 DVSS_B.t366 839.694281613022
Riso10607 DVSS_B.t157 DVSS_B.t37 491.661267426074
Riso10608 DVSS_B.t157 DVSS_B.t509 839.694281613022
Riso10609 DVSS_B.t157 DVSS_B.t515 96.7700046662516
Riso10610 DVSS_B.t157 DVSS_B.t525 462.865390698092
Riso10611 DVSS_B.t157 DVSS_B.t529 347.522660033029
Riso10612 DVSS_B.t157 DVSS_B.t531 96.7700046662516
Riso10613 DVSS_B.t157 DVSS_B.t59 20253.2352385158
Riso10614 DVSS_B.t157 DVSS_B.t60 178.279357304186
Riso10615 DVSS_B.t157 DVSS_B.t66 83.3460413099905
Riso10616 DVSS_B.t157 DVSS_B.t68 53.1416086115977
Riso10617 DVSS_B.t157 DVSS_B.t70 529.426758340874
Riso10618 DVSS_B.t157 DVSS_B.t72 792.958506136697
Riso10619 DVSS_B.t157 DVSS_B.t74 528.66345423479
Riso10620 DVSS_B.t157 DVSS_B.t76 81.8911724869594
Riso10621 DVSS_B.t157 DVSS_B.t80 71.6539647462688
Riso10622 DVSS_B.t157 DVSS_B.t82 38.1774208156255
Riso10623 DVSS_B.t157 DVSS_B.t84 462.865390698092
Riso10624 DVSS_B.t157 DVSS_B.t89 68652.5090812305
Riso10625 DVSS_B.t157 DVSS_B.t90 664.731980596939
Riso10626 DVSS_B.t157 DVSS_B.t94 496.550881867929
Riso10627 DVSS_B.t157 DVSS_B.t96 712.739786382861
Riso10628 DVSS_B.t157 VSS_A 641.923716120421
Riso10629 DVSS_B.t157 VSS_B 101.969150412222
Riso10630 DVSS_B.t158 DVSS_B.t251 66.3487
Riso10631 DVSS_B.t158 DVSS_B.t75 66.3487
Riso10632 DVSS_B.t159 DVSS_B.t161 160.891370359028
Riso10633 DVSS_B.t159 DVSS_B.t162 11909.8739342248
Riso10634 DVSS_B.t159 DVSS_B.t163 81.8911724869594
Riso10635 DVSS_B.t159 DVSS_B.t165 1200.33032032532
Riso10636 DVSS_B.t159 DVSS_B.t167 1247.43798014778
Riso10637 DVSS_B.t159 DVSS_B.t169 45.6492696871384
Riso10638 DVSS_B.t159 DVSS_B.t173 202.98064324748
Riso10639 DVSS_B.t159 DVSS_B.t177 121.817346279206
Riso10640 DVSS_B.t159 DVSS_B.t20 24713.1945018133
Riso10641 DVSS_B.t159 DVSS_B.t202 202.98064324748
Riso10642 DVSS_B.t159 DVSS_B.t204 868.557821068668
Riso10643 DVSS_B.t159 DVSS_B.t206 630.823983892936
Riso10644 DVSS_B.t159 DVSS_B.t21 289.204087648065
Riso10645 DVSS_B.t159 DVSS_B.t212 739.040062311947
Riso10646 DVSS_B.t159 DVSS_B.t214 1012.86316632585
Riso10647 DVSS_B.t159 DVSS_B.t215 25383.4488256153
Riso10648 DVSS_B.t159 DVSS_B.t216 340.731975831849
Riso10649 DVSS_B.t159 DVSS_B.t218 282.293306706015
Riso10650 DVSS_B.t159 DVSS_B.t225 1223.76750438314
Riso10651 DVSS_B.t159 DVSS_B.t236 739.040062311947
Riso10652 DVSS_B.t159 DVSS_B.t238 37.6360792307161
Riso10653 DVSS_B.t159 DVSS_B.t240 685.77623796367
Riso10654 DVSS_B.t159 DVSS_B.t250 231.704403987765
Riso10655 DVSS_B.t159 DVSS_B.t252 38.6229456499396
Riso10656 DVSS_B.t159 DVSS_B.t256 140.429693489005
Riso10657 DVSS_B.t159 DVSS_B.t258 521.655961169071
Riso10658 DVSS_B.t159 DVSS_B.t259 27192.7006750482
Riso10659 DVSS_B.t159 DVSS_B.t260 420.022180714473
Riso10660 DVSS_B.t159 DVSS_B.t264 1139.1324347422
Riso10661 DVSS_B.t159 DVSS_B.t266 1223.76750438314
Riso10662 DVSS_B.t159 DVSS_B.t267 8186.90117207112
Riso10663 DVSS_B.t159 DVSS_B.t268 48.0639797405734
Riso10664 DVSS_B.t159 DVSS_B.t271 42.9365947198253
Riso10665 DVSS_B.t159 DVSS_B.t273 257.134515417272
Riso10666 DVSS_B.t159 DVSS_B.t275 62.3777961031311
Riso10667 DVSS_B.t159 DVSS_B.t277 832.707678112477
Riso10668 DVSS_B.t159 DVSS_B.t279 630.823983892936
Riso10669 DVSS_B.t159 DVSS_B.t281 1244.15260662965
Riso10670 DVSS_B.t159 DVSS_B.t283 71.9013531347615
Riso10671 DVSS_B.t159 DVSS_B.t285 306.085629818805
Riso10672 DVSS_B.t159 DVSS_B.t287 282.293306706015
Riso10673 DVSS_B.t159 DVSS_B.t288 11909.8739342248
Riso10674 DVSS_B.t159 DVSS_B.t289 121.817346279206
Riso10675 DVSS_B.t159 DVSS_B.t291 1247.43798014778
Riso10676 DVSS_B.t159 DVSS_B.t293 45.6492696871384
Riso10677 DVSS_B.t159 DVSS_B.t295 469.542715318073
Riso10678 DVSS_B.t159 DVSS_B.t297 160.891370359028
Riso10679 DVSS_B.t159 DVSS_B.t299 53.5821726253219
Riso10680 DVSS_B.t159 DVSS_B.t301 1151.35933039464
Riso10681 DVSS_B.t159 DVSS_B.t302 137597.01643694
Riso10682 DVSS_B.t159 DVSS_B.t303 1151.35933039464
Riso10683 DVSS_B.t159 DVSS_B.t305 140.429693489005
Riso10684 DVSS_B.t159 DVSS_B.t322 224.993310592486
Riso10685 DVSS_B.t159 DVSS_B.t325 104748.098993351
Riso10686 DVSS_B.t159 DVSS_B.t326 868.557821068668
Riso10687 DVSS_B.t159 DVSS_B.t329 110.715044463576
Riso10688 DVSS_B.t159 DVSS_B.t331 199.156659968529
Riso10689 DVSS_B.t159 DVSS_B.t333 189.603377089522
Riso10690 DVSS_B.t159 DVSS_B.t335 107.138271501293
Riso10691 DVSS_B.t159 DVSS_B.t337 93.0301161431313
Riso10692 DVSS_B.t159 DVSS_B.t339 199.156659968529
Riso10693 DVSS_B.t159 DVSS_B.t341 189.603377089522
Riso10694 DVSS_B.t159 DVSS_B.t343 79.8672011417352
Riso10695 DVSS_B.t159 DVSS_B.t345 34660.4568005506
Riso10696 DVSS_B.t159 DVSS_B.t346 133.423296634586
Riso10697 DVSS_B.t159 DVSS_B.t348 257.134515417272
Riso10698 DVSS_B.t159 DVSS_B.t35 521.655961169071
Riso10699 DVSS_B.t159 DVSS_B.t350 42.9365947198253
Riso10700 DVSS_B.t159 DVSS_B.t352 48.0639797405734
Riso10701 DVSS_B.t159 DVSS_B.t355 103411.918844565
Riso10702 DVSS_B.t159 DVSS_B.t356 128.642635717905
Riso10703 DVSS_B.t159 DVSS_B.t358 1139.1324347422
Riso10704 DVSS_B.t159 DVSS_B.t36 18668.2422000092
Riso10705 DVSS_B.t159 DVSS_B.t360 788.742456687896
Riso10706 DVSS_B.t159 DVSS_B.t364 1244.15260662965
Riso10707 DVSS_B.t159 DVSS_B.t366 1232.77234796941
Riso10708 DVSS_B.t159 DVSS_B.t37 289.204087648065
Riso10709 DVSS_B.t159 DVSS_B.t509 1232.77234796941
Riso10710 DVSS_B.t159 DVSS_B.t515 206.831086302933
Riso10711 DVSS_B.t159 DVSS_B.t525 203.688251496711
Riso10712 DVSS_B.t159 DVSS_B.t529 575.716826559036
Riso10713 DVSS_B.t159 DVSS_B.t531 206.831086302933
Riso10714 DVSS_B.t159 DVSS_B.t59 27192.7006750482
Riso10715 DVSS_B.t159 DVSS_B.t60 327.163102595158
Riso10716 DVSS_B.t159 DVSS_B.t66 183.099405969178
Riso10717 DVSS_B.t159 DVSS_B.t68 53.5821726253219
Riso10718 DVSS_B.t159 DVSS_B.t70 832.707678112477
Riso10719 DVSS_B.t159 DVSS_B.t72 1187.98941370998
Riso10720 DVSS_B.t159 DVSS_B.t74 224.993310592486
Riso10721 DVSS_B.t159 DVSS_B.t76 0.0669569090682653
Riso10722 DVSS_B.t159 DVSS_B.t80 38.6229456499396
Riso10723 DVSS_B.t159 DVSS_B.t82 71.9013531347615
Riso10724 DVSS_B.t159 DVSS_B.t84 203.688251496711
Riso10725 DVSS_B.t159 DVSS_B.t89 104748.098993351
Riso10726 DVSS_B.t159 DVSS_B.t90 1012.86316632585
Riso10727 DVSS_B.t159 DVSS_B.t94 788.742456687896
Riso10728 DVSS_B.t159 DVSS_B.t96 1079.84577104399
Riso10729 DVSS_B.t159 VSS_A 387.463926754735
Riso10730 DVSS_B.t159 VSS_B 62.5553504710182
Riso10731 DVSS_B.t160 DVSS_B.t296 66.3487
Riso10732 DVSS_B.t160 DVSS_B.t99 66.3487
Riso10733 DVSS_B.t161 DVSS_B.t162 6908.82637391204
Riso10734 DVSS_B.t161 DVSS_B.t163 71.3200989987613
Riso10735 DVSS_B.t161 DVSS_B.t165 601.860166295639
Riso10736 DVSS_B.t161 DVSS_B.t167 614.058583319162
Riso10737 DVSS_B.t161 DVSS_B.t169 127.365817092781
Riso10738 DVSS_B.t161 DVSS_B.t173 865.019927505012
Riso10739 DVSS_B.t161 DVSS_B.t177 45.7588345540327
Riso10740 DVSS_B.t161 DVSS_B.t20 64821.2331559547
Riso10741 DVSS_B.t161 DVSS_B.t202 865.019927505012
Riso10742 DVSS_B.t161 DVSS_B.t204 378.720874047976
Riso10743 DVSS_B.t161 DVSS_B.t206 245.430468611619
Riso10744 DVSS_B.t161 DVSS_B.t21 759.402039509168
Riso10745 DVSS_B.t161 DVSS_B.t212 301.629264721787
Riso10746 DVSS_B.t161 DVSS_B.t214 464.185794824784
Riso10747 DVSS_B.t161 DVSS_B.t215 66743.8987490535
Riso10748 DVSS_B.t161 DVSS_B.t216 894.81960891215
Riso10749 DVSS_B.t161 DVSS_B.t218 76.4772668349339
Riso10750 DVSS_B.t161 DVSS_B.t225 589.416945263892
Riso10751 DVSS_B.t161 DVSS_B.t236 301.629264721787
Riso10752 DVSS_B.t161 DVSS_B.t238 177.330345729179
Riso10753 DVSS_B.t161 DVSS_B.t240 273.352113567922
Riso10754 DVSS_B.t161 DVSS_B.t250 56.2174109034491
Riso10755 DVSS_B.t161 DVSS_B.t252 143.994896857435
Riso10756 DVSS_B.t161 DVSS_B.t256 39.5116216084411
Riso10757 DVSS_B.t161 DVSS_B.t258 193.08639546778
Riso10758 DVSS_B.t161 DVSS_B.t259 16003.8170839232
Riso10759 DVSS_B.t161 DVSS_B.t260 147.70733470254
Riso10760 DVSS_B.t161 DVSS_B.t264 535.575649681531
Riso10761 DVSS_B.t161 DVSS_B.t266 589.416945263892
Riso10762 DVSS_B.t161 DVSS_B.t267 30389.4490518181
Riso10763 DVSS_B.t161 DVSS_B.t268 204.957454616503
Riso10764 DVSS_B.t161 DVSS_B.t271 192.38103102842
Riso10765 DVSS_B.t161 DVSS_B.t273 65.8351296657675
Riso10766 DVSS_B.t161 DVSS_B.t275 96.7923944972666
Riso10767 DVSS_B.t161 DVSS_B.t277 355.517133955106
Riso10768 DVSS_B.t161 DVSS_B.t279 245.430468611619
Riso10769 DVSS_B.t161 DVSS_B.t281 606.017590930004
Riso10770 DVSS_B.t161 DVSS_B.t283 83.3670983464817
Riso10771 DVSS_B.t161 DVSS_B.t285 87.9890919899137
Riso10772 DVSS_B.t161 DVSS_B.t287 76.4772668349339
Riso10773 DVSS_B.t161 DVSS_B.t288 6908.82637391204
Riso10774 DVSS_B.t161 DVSS_B.t289 45.7588345540327
Riso10775 DVSS_B.t161 DVSS_B.t291 614.058583319162
Riso10776 DVSS_B.t161 DVSS_B.t293 127.365817092781
Riso10777 DVSS_B.t161 DVSS_B.t295 169.425334649602
Riso10778 DVSS_B.t161 DVSS_B.t297 0.0669619380195351
Riso10779 DVSS_B.t161 DVSS_B.t299 111.520603016028
Riso10780 DVSS_B.t161 DVSS_B.t301 581.747278381021
Riso10781 DVSS_B.t161 DVSS_B.t302 70870.6984835324
Riso10782 DVSS_B.t161 DVSS_B.t303 581.747278381021
Riso10783 DVSS_B.t161 DVSS_B.t305 39.5116216084411
Riso10784 DVSS_B.t161 DVSS_B.t322 966.597395115256
Riso10785 DVSS_B.t161 DVSS_B.t325 47763.9053073471
Riso10786 DVSS_B.t161 DVSS_B.t326 378.720874047976
Riso10787 DVSS_B.t161 DVSS_B.t329 274.923336678163
Riso10788 DVSS_B.t161 DVSS_B.t331 521.995460199884
Riso10789 DVSS_B.t161 DVSS_B.t333 499.541191045827
Riso10790 DVSS_B.t161 DVSS_B.t335 270.419103155661
Riso10791 DVSS_B.t161 DVSS_B.t337 235.856282102029
Riso10792 DVSS_B.t161 DVSS_B.t339 521.995460199884
Riso10793 DVSS_B.t161 DVSS_B.t341 499.541191045827
Riso10794 DVSS_B.t161 DVSS_B.t343 207.506022800375
Riso10795 DVSS_B.t161 DVSS_B.t345 95584.5780209661
Riso10796 DVSS_B.t161 DVSS_B.t346 351.336107826984
Riso10797 DVSS_B.t161 DVSS_B.t348 65.8351296657675
Riso10798 DVSS_B.t161 DVSS_B.t35 193.08639546778
Riso10799 DVSS_B.t161 DVSS_B.t350 192.38103102842
Riso10800 DVSS_B.t161 DVSS_B.t352 204.957454616503
Riso10801 DVSS_B.t161 DVSS_B.t355 305126.461528137
Riso10802 DVSS_B.t161 DVSS_B.t356 458.560356001596
Riso10803 DVSS_B.t161 DVSS_B.t358 535.575649681531
Riso10804 DVSS_B.t161 DVSS_B.t36 48965.6843096446
Riso10805 DVSS_B.t161 DVSS_B.t360 329.385311919813
Riso10806 DVSS_B.t161 DVSS_B.t364 606.017590930004
Riso10807 DVSS_B.t161 DVSS_B.t366 612.753765051766
Riso10808 DVSS_B.t161 DVSS_B.t37 759.402039509168
Riso10809 DVSS_B.t161 DVSS_B.t509 612.753765051766
Riso10810 DVSS_B.t161 DVSS_B.t515 47.6763241724958
Riso10811 DVSS_B.t161 DVSS_B.t525 825.400454164463
Riso10812 DVSS_B.t161 DVSS_B.t529 218.521217781216
Riso10813 DVSS_B.t161 DVSS_B.t531 47.6763241724958
Riso10814 DVSS_B.t161 DVSS_B.t59 16003.8170839232
Riso10815 DVSS_B.t161 DVSS_B.t60 100.073932320985
Riso10816 DVSS_B.t161 DVSS_B.t66 40.195373193485
Riso10817 DVSS_B.t161 DVSS_B.t68 111.520603016028
Riso10818 DVSS_B.t161 DVSS_B.t70 355.517133955106
Riso10819 DVSS_B.t161 DVSS_B.t72 565.453961567905
Riso10820 DVSS_B.t161 DVSS_B.t74 966.597395115256
Riso10821 DVSS_B.t161 DVSS_B.t76 160.891370359028
Riso10822 DVSS_B.t161 DVSS_B.t80 143.994896857435
Riso10823 DVSS_B.t161 DVSS_B.t82 83.3670983464817
Riso10824 DVSS_B.t161 DVSS_B.t84 825.400454164463
Riso10825 DVSS_B.t161 DVSS_B.t89 47763.9053073471
Riso10826 DVSS_B.t161 DVSS_B.t90 464.185794824784
Riso10827 DVSS_B.t161 DVSS_B.t94 329.385311919813
Riso10828 DVSS_B.t161 DVSS_B.t96 501.320341360051
Riso10829 DVSS_B.t161 VSS_A 950.933817304375
Riso10830 DVSS_B.t161 VSS_B 146.889913555606
Riso10831 DVSS_B.t162 DVSS_B.t163 4929.08458510493
Riso10832 DVSS_B.t162 DVSS_B.t165 82460.5726766347
Riso10833 DVSS_B.t162 DVSS_B.t167 85021.6703476705
Riso10834 DVSS_B.t162 DVSS_B.t169 9207.12333381897
Riso10835 DVSS_B.t162 DVSS_B.t173 66331.7999168554
Riso10836 DVSS_B.t162 DVSS_B.t177 4944.50053369684
Riso10837 DVSS_B.t162 DVSS_B.t20 5371287.55065382
Riso10838 DVSS_B.t162 DVSS_B.t202 66331.7999168554
Riso10839 DVSS_B.t162 DVSS_B.t204 56007.4325108503
Riso10840 DVSS_B.t162 DVSS_B.t206 38487.7136174266
Riso10841 DVSS_B.t162 DVSS_B.t21 62918.0646509061
Riso10842 DVSS_B.t162 DVSS_B.t212 46170.475915438
Riso10843 DVSS_B.t162 DVSS_B.t214 66843.7815089632
Riso10844 DVSS_B.t162 DVSS_B.t215 5529861.40027241
Riso10845 DVSS_B.t162 DVSS_B.t216 74137.7196807307
Riso10846 DVSS_B.t162 DVSS_B.t218 14181.5819936387
Riso10847 DVSS_B.t162 DVSS_B.t225 82611.4739982678
Riso10848 DVSS_B.t162 DVSS_B.t236 46170.475915438
Riso10849 DVSS_B.t162 DVSS_B.t238 13280.217618926
Riso10850 DVSS_B.t162 DVSS_B.t240 42348.0482739152
Riso10851 DVSS_B.t162 DVSS_B.t250 10903.6832094396
Riso10852 DVSS_B.t162 DVSS_B.t252 10533.5432811596
Riso10853 DVSS_B.t162 DVSS_B.t256 5859.79269866367
Riso10854 DVSS_B.t162 DVSS_B.t258 31032.3768517356
Riso10855 DVSS_B.t162 DVSS_B.t259 1970367.90354018
Riso10856 DVSS_B.t162 DVSS_B.t260 24330.4508558166
Riso10857 DVSS_B.t162 DVSS_B.t264 76066.3971647328
Riso10858 DVSS_B.t162 DVSS_B.t266 82611.4739982678
Riso10859 DVSS_B.t162 DVSS_B.t267 2367726.02309182
Riso10860 DVSS_B.t162 DVSS_B.t268 15683.044694889
Riso10861 DVSS_B.t162 DVSS_B.t271 14568.7896683985
Riso10862 DVSS_B.t162 DVSS_B.t273 12497.2493486506
Riso10863 DVSS_B.t162 DVSS_B.t275 6836.61190771296
Riso10864 DVSS_B.t162 DVSS_B.t277 53163.9183626096
Riso10865 DVSS_B.t162 DVSS_B.t279 38487.7136174266
Riso10866 DVSS_B.t162 DVSS_B.t281 84407.412709954
Riso10867 DVSS_B.t162 DVSS_B.t283 5823.39683040378
Riso10868 DVSS_B.t162 DVSS_B.t285 15905.9367405996
Riso10869 DVSS_B.t162 DVSS_B.t287 14181.5819936387
Riso10870 DVSS_B.t162 DVSS_B.t288 74217.3085055022
Riso10871 DVSS_B.t162 DVSS_B.t289 4944.50053369684
Riso10872 DVSS_B.t162 DVSS_B.t291 85021.6703476705
Riso10873 DVSS_B.t162 DVSS_B.t293 9207.12333381897
Riso10874 DVSS_B.t162 DVSS_B.t295 27567.1410655379
Riso10875 DVSS_B.t162 DVSS_B.t297 6908.82637391204
Riso10876 DVSS_B.t162 DVSS_B.t299 7967.68053225433
Riso10877 DVSS_B.t162 DVSS_B.t301 79351.4366846994
Riso10878 DVSS_B.t162 DVSS_B.t302 9557037.37683869
Riso10879 DVSS_B.t162 DVSS_B.t303 79351.4366846994
Riso10880 DVSS_B.t162 DVSS_B.t305 5859.79269866367
Riso10881 DVSS_B.t162 DVSS_B.t322 73977.476734458
Riso10882 DVSS_B.t162 DVSS_B.t325 6893584.12037005
Riso10883 DVSS_B.t162 DVSS_B.t326 56007.4325108503
Riso10884 DVSS_B.t162 DVSS_B.t329 23193.515088944
Riso10885 DVSS_B.t162 DVSS_B.t331 43629.8766824788
Riso10886 DVSS_B.t162 DVSS_B.t333 41619.2692615585
Riso10887 DVSS_B.t162 DVSS_B.t335 22698.7901115978
Riso10888 DVSS_B.t162 DVSS_B.t337 19850.2577833588
Riso10889 DVSS_B.t162 DVSS_B.t339 43629.8766824788
Riso10890 DVSS_B.t162 DVSS_B.t341 41619.2692615585
Riso10891 DVSS_B.t162 DVSS_B.t343 17367.359998879
Riso10892 DVSS_B.t162 DVSS_B.t345 8006205.86947276
Riso10893 DVSS_B.t162 DVSS_B.t346 29654.9898349209
Riso10894 DVSS_B.t162 DVSS_B.t348 12497.2493486506
Riso10895 DVSS_B.t162 DVSS_B.t35 31032.3768517356
Riso10896 DVSS_B.t162 DVSS_B.t350 14568.7896683985
Riso10897 DVSS_B.t162 DVSS_B.t352 15683.044694889
Riso10898 DVSS_B.t162 DVSS_B.t355 25258318.2007129
Riso10899 DVSS_B.t162 DVSS_B.t356 36596.7748805698
Riso10900 DVSS_B.t162 DVSS_B.t358 76066.3971647328
Riso10901 DVSS_B.t162 DVSS_B.t36 4057447.81048613
Riso10902 DVSS_B.t162 DVSS_B.t360 49827.0133224777
Riso10903 DVSS_B.t162 DVSS_B.t364 84407.412709954
Riso10904 DVSS_B.t162 DVSS_B.t366 84374.8210822581
Riso10905 DVSS_B.t162 DVSS_B.t37 62918.0646509061
Riso10906 DVSS_B.t162 DVSS_B.t509 84374.8210822581
Riso10907 DVSS_B.t162 DVSS_B.t515 9432.15897420093
Riso10908 DVSS_B.t162 DVSS_B.t525 64046.9738052015
Riso10909 DVSS_B.t162 DVSS_B.t529 34690.5328322013
Riso10910 DVSS_B.t162 DVSS_B.t531 9432.15897420093
Riso10911 DVSS_B.t162 DVSS_B.t59 1970367.90354018
Riso10912 DVSS_B.t162 DVSS_B.t60 17596.6421664006
Riso10913 DVSS_B.t162 DVSS_B.t66 8098.82253532833
Riso10914 DVSS_B.t162 DVSS_B.t68 7967.68053225433
Riso10915 DVSS_B.t162 DVSS_B.t70 53163.9183626096
Riso10916 DVSS_B.t162 DVSS_B.t72 79771.9891130797
Riso10917 DVSS_B.t162 DVSS_B.t74 73977.476734458
Riso10918 DVSS_B.t162 DVSS_B.t76 11909.8739342248
Riso10919 DVSS_B.t162 DVSS_B.t80 10533.5432811596
Riso10920 DVSS_B.t162 DVSS_B.t82 5823.39683040378
Riso10921 DVSS_B.t162 DVSS_B.t84 64046.9738052015
Riso10922 DVSS_B.t162 DVSS_B.t89 6893584.12037005
Riso10923 DVSS_B.t162 DVSS_B.t90 66843.7815089632
Riso10924 DVSS_B.t162 DVSS_B.t94 49827.0133224777
Riso10925 DVSS_B.t162 DVSS_B.t96 71691.1467683795
Riso10926 DVSS_B.t162 VSS_A 80339.221837661
Riso10927 DVSS_B.t162 VSS_B 12375.04865508
Riso10928 DVSS_B.t163 DVSS_B.t165 821.05872182601
Riso10929 DVSS_B.t163 DVSS_B.t167 845.756866887152
Riso10930 DVSS_B.t163 DVSS_B.t169 61.9974472219196
Riso10931 DVSS_B.t163 DVSS_B.t173 474.767117194336
Riso10932 DVSS_B.t163 DVSS_B.t177 51.3537434843255
Riso10933 DVSS_B.t163 DVSS_B.t20 41991.8840541086
Riso10934 DVSS_B.t163 DVSS_B.t202 474.767117194336
Riso10935 DVSS_B.t163 DVSS_B.t204 557.485954050173
Riso10936 DVSS_B.t163 DVSS_B.t206 384.931604244092
Riso10937 DVSS_B.t163 DVSS_B.t21 491.661267426074
Riso10938 DVSS_B.t163 DVSS_B.t212 460.555343198971
Riso10939 DVSS_B.t163 DVSS_B.t214 664.731980596939
Riso10940 DVSS_B.t163 DVSS_B.t215 43202.3959484596
Riso10941 DVSS_B.t163 DVSS_B.t216 579.323695766906
Riso10942 DVSS_B.t163 DVSS_B.t218 144.27707938407
Riso10943 DVSS_B.t163 DVSS_B.t225 821.285965472145
Riso10944 DVSS_B.t163 DVSS_B.t236 460.555343198971
Riso10945 DVSS_B.t163 DVSS_B.t238 92.343219038709
Riso10946 DVSS_B.t163 DVSS_B.t240 422.935267274999
Riso10947 DVSS_B.t163 DVSS_B.t250 111.533655489254
Riso10948 DVSS_B.t163 DVSS_B.t252 71.6539647462688
Riso10949 DVSS_B.t163 DVSS_B.t256 60.6770563199413
Riso10950 DVSS_B.t163 DVSS_B.t258 311.442835995061
Riso10951 DVSS_B.t163 DVSS_B.t259 20253.2352385158
Riso10952 DVSS_B.t163 DVSS_B.t260 245.186423879089
Riso10953 DVSS_B.t163 DVSS_B.t264 756.129593837453
Riso10954 DVSS_B.t163 DVSS_B.t266 821.285965472145
Riso10955 DVSS_B.t163 DVSS_B.t267 17559.393457777
Riso10956 DVSS_B.t163 DVSS_B.t268 111.598709116481
Riso10957 DVSS_B.t163 DVSS_B.t271 102.476923084952
Riso10958 DVSS_B.t163 DVSS_B.t273 127.472546662925
Riso10959 DVSS_B.t163 DVSS_B.t275 45.1930296028835
Riso10960 DVSS_B.t163 DVSS_B.t277 529.426758340874
Riso10961 DVSS_B.t163 DVSS_B.t279 384.931604244092
Riso10962 DVSS_B.t163 DVSS_B.t281 839.348019014978
Riso10963 DVSS_B.t163 DVSS_B.t283 38.1774208156255
Riso10964 DVSS_B.t163 DVSS_B.t285 161.451292988835
Riso10965 DVSS_B.t163 DVSS_B.t287 144.27707938407
Riso10966 DVSS_B.t163 DVSS_B.t288 4929.08458510493
Riso10967 DVSS_B.t163 DVSS_B.t289 51.3537434843255
Riso10968 DVSS_B.t163 DVSS_B.t291 845.756866887152
Riso10969 DVSS_B.t163 DVSS_B.t293 61.9974472219196
Riso10970 DVSS_B.t163 DVSS_B.t295 277.214909619886
Riso10971 DVSS_B.t163 DVSS_B.t297 71.3200989987613
Riso10972 DVSS_B.t163 DVSS_B.t299 53.1416086115977
Riso10973 DVSS_B.t163 DVSS_B.t301 790.528085348893
Riso10974 DVSS_B.t163 DVSS_B.t302 95386.6655189855
Riso10975 DVSS_B.t163 DVSS_B.t303 790.528085348893
Riso10976 DVSS_B.t163 DVSS_B.t305 60.6770563199413
Riso10977 DVSS_B.t163 DVSS_B.t322 528.66345423479
Riso10978 DVSS_B.t163 DVSS_B.t325 68652.5090812305
Riso10979 DVSS_B.t163 DVSS_B.t326 557.485954050173
Riso10980 DVSS_B.t163 DVSS_B.t329 184.662937462476
Riso10981 DVSS_B.t163 DVSS_B.t331 344.519765849641
Riso10982 DVSS_B.t163 DVSS_B.t333 329.057954922643
Riso10983 DVSS_B.t163 DVSS_B.t335 180.744914189729
Riso10984 DVSS_B.t163 DVSS_B.t337 156.939705570187
Riso10985 DVSS_B.t163 DVSS_B.t339 344.519765849641
Riso10986 DVSS_B.t163 DVSS_B.t341 329.057954922643
Riso10987 DVSS_B.t163 DVSS_B.t343 136.820184567762
Riso10988 DVSS_B.t163 DVSS_B.t345 61923.0274468314
Riso10989 DVSS_B.t163 DVSS_B.t346 231.059680892629
Riso10990 DVSS_B.t163 DVSS_B.t348 127.472546662925
Riso10991 DVSS_B.t163 DVSS_B.t35 311.442835995061
Riso10992 DVSS_B.t163 DVSS_B.t350 102.476923084952
Riso10993 DVSS_B.t163 DVSS_B.t352 111.598709116481
Riso10994 DVSS_B.t163 DVSS_B.t355 193201.779276518
Riso10995 DVSS_B.t163 DVSS_B.t356 270.861953512135
Riso10996 DVSS_B.t163 DVSS_B.t358 756.129593837453
Riso10997 DVSS_B.t163 DVSS_B.t36 31720.490926387
Riso10998 DVSS_B.t163 DVSS_B.t360 496.550881867929
Riso10999 DVSS_B.t163 DVSS_B.t364 839.348019014978
Riso11000 DVSS_B.t163 DVSS_B.t366 839.694281613022
Riso11001 DVSS_B.t163 DVSS_B.t37 491.661267426074
Riso11002 DVSS_B.t163 DVSS_B.t509 839.694281613022
Riso11003 DVSS_B.t163 DVSS_B.t515 96.7700046662516
Riso11004 DVSS_B.t163 DVSS_B.t525 462.865390698092
Riso11005 DVSS_B.t163 DVSS_B.t529 347.522660033029
Riso11006 DVSS_B.t163 DVSS_B.t531 96.7700046662516
Riso11007 DVSS_B.t163 DVSS_B.t59 20253.2352385158
Riso11008 DVSS_B.t163 DVSS_B.t60 178.279357304186
Riso11009 DVSS_B.t163 DVSS_B.t66 83.3460413099905
Riso11010 DVSS_B.t163 DVSS_B.t68 53.1416086115977
Riso11011 DVSS_B.t163 DVSS_B.t70 529.426758340874
Riso11012 DVSS_B.t163 DVSS_B.t72 792.958506136697
Riso11013 DVSS_B.t163 DVSS_B.t74 528.66345423479
Riso11014 DVSS_B.t163 DVSS_B.t76 81.8911724869594
Riso11015 DVSS_B.t163 DVSS_B.t80 71.6539647462688
Riso11016 DVSS_B.t163 DVSS_B.t82 38.1774208156255
Riso11017 DVSS_B.t163 DVSS_B.t84 462.865390698092
Riso11018 DVSS_B.t163 DVSS_B.t89 68652.5090812305
Riso11019 DVSS_B.t163 DVSS_B.t90 664.731980596939
Riso11020 DVSS_B.t163 DVSS_B.t94 496.550881867929
Riso11021 DVSS_B.t163 DVSS_B.t96 712.739786382861
Riso11022 DVSS_B.t163 VSS_A 641.923716120421
Riso11023 DVSS_B.t163 VSS_B 101.969150412222
Riso11024 DVSS_B.t164 DVSS_B.t365 66.3487
Riso11025 DVSS_B.t165 DVSS_B.t167 33.0365885539555
Riso11026 DVSS_B.t165 DVSS_B.t169 1097.9088162146
Riso11027 DVSS_B.t165 DVSS_B.t173 4711.49183365018
Riso11028 DVSS_B.t165 DVSS_B.t177 675.160027347944
Riso11029 DVSS_B.t165 DVSS_B.t20 285041.936615725
Riso11030 DVSS_B.t165 DVSS_B.t202 4711.49183365018
Riso11031 DVSS_B.t165 DVSS_B.t204 106.878699912654
Riso11032 DVSS_B.t165 DVSS_B.t206 188.721252122947
Riso11033 DVSS_B.t165 DVSS_B.t21 3351.65029404371
Riso11034 DVSS_B.t165 DVSS_B.t212 153.710185553332
Riso11035 DVSS_B.t165 DVSS_B.t214 75.4076890896578
Riso11036 DVSS_B.t165 DVSS_B.t215 294427.314023741
Riso11037 DVSS_B.t165 DVSS_B.t216 3949.07158768492
Riso11038 DVSS_B.t165 DVSS_B.t218 388.962476066754
Riso11039 DVSS_B.t165 DVSS_B.t225 45.0145537094426
Riso11040 DVSS_B.t165 DVSS_B.t236 153.710185553332
Riso11041 DVSS_B.t165 DVSS_B.t238 1232.61419372744
Riso11042 DVSS_B.t165 DVSS_B.t240 171.045004423548
Riso11043 DVSS_B.t165 DVSS_B.t250 472.993773132697
Riso11044 DVSS_B.t165 DVSS_B.t252 1154.41816228409
Riso11045 DVSS_B.t165 DVSS_B.t256 640.888703578106
Riso11046 DVSS_B.t165 DVSS_B.t258 222.853240234206
Riso11047 DVSS_B.t165 DVSS_B.t259 17466.9831258118
Riso11048 DVSS_B.t165 DVSS_B.t260 249.996583362437
Riso11049 DVSS_B.t165 DVSS_B.t264 59.4841705656115
Riso11050 DVSS_B.t165 DVSS_B.t266 45.0145537094426
Riso11051 DVSS_B.t165 DVSS_B.t267 156043.689694447
Riso11052 DVSS_B.t165 DVSS_B.t268 1245.85472827431
Riso11053 DVSS_B.t165 DVSS_B.t271 1248.49975426886
Riso11054 DVSS_B.t165 DVSS_B.t273 430.2400162077
Riso11055 DVSS_B.t165 DVSS_B.t275 964.774618085351
Riso11056 DVSS_B.t165 DVSS_B.t277 121.42682277223
Riso11057 DVSS_B.t165 DVSS_B.t279 188.721252122947
Riso11058 DVSS_B.t165 DVSS_B.t281 38.6914833270304
Riso11059 DVSS_B.t165 DVSS_B.t283 893.222204612647
Riso11060 DVSS_B.t165 DVSS_B.t285 349.650379585254
Riso11061 DVSS_B.t165 DVSS_B.t287 388.962476066754
Riso11062 DVSS_B.t165 DVSS_B.t288 82460.5726766347
Riso11063 DVSS_B.t165 DVSS_B.t289 675.160027347944
Riso11064 DVSS_B.t165 DVSS_B.t291 33.0365885539555
Riso11065 DVSS_B.t165 DVSS_B.t293 1097.9088162146
Riso11066 DVSS_B.t165 DVSS_B.t295 237.772304343155
Riso11067 DVSS_B.t165 DVSS_B.t297 601.860166295639
Riso11068 DVSS_B.t165 DVSS_B.t299 1033.78611700937
Riso11069 DVSS_B.t165 DVSS_B.t301 24.979218186684
Riso11070 DVSS_B.t165 DVSS_B.t302 3772.03724425347
Riso11071 DVSS_B.t165 DVSS_B.t303 24.979218186684
Riso11072 DVSS_B.t165 DVSS_B.t305 640.888703578106
Riso11073 DVSS_B.t165 DVSS_B.t322 5301.68074521247
Riso11074 DVSS_B.t165 DVSS_B.t325 10534.5098164946
Riso11075 DVSS_B.t165 DVSS_B.t326 106.878699912654
Riso11076 DVSS_B.t165 DVSS_B.t329 1014.37648073561
Riso11077 DVSS_B.t165 DVSS_B.t331 1965.21744785168
Riso11078 DVSS_B.t165 DVSS_B.t333 1864.9189976479
Riso11079 DVSS_B.t165 DVSS_B.t335 988.339710175633
Riso11080 DVSS_B.t165 DVSS_B.t337 907.476921633463
Riso11081 DVSS_B.t165 DVSS_B.t339 1965.21744785168
Riso11082 DVSS_B.t165 DVSS_B.t341 1864.9189976479
Riso11083 DVSS_B.t165 DVSS_B.t343 809.936571701867
Riso11084 DVSS_B.t165 DVSS_B.t345 399436.327558874
Riso11085 DVSS_B.t165 DVSS_B.t346 1440.37759036216
Riso11086 DVSS_B.t165 DVSS_B.t348 430.2400162077
Riso11087 DVSS_B.t165 DVSS_B.t35 222.853240234206
Riso11088 DVSS_B.t165 DVSS_B.t350 1248.49975426886
Riso11089 DVSS_B.t165 DVSS_B.t352 1245.85472827431
Riso11090 DVSS_B.t165 DVSS_B.t355 1314367.02586471
Riso11091 DVSS_B.t165 DVSS_B.t356 2189.74688276068
Riso11092 DVSS_B.t165 DVSS_B.t358 59.4841705656115
Riso11093 DVSS_B.t165 DVSS_B.t36 215319.468695624
Riso11094 DVSS_B.t165 DVSS_B.t360 137.08798428344
Riso11095 DVSS_B.t165 DVSS_B.t364 38.6914833270304
Riso11096 DVSS_B.t165 DVSS_B.t366 28.0433554249434
Riso11097 DVSS_B.t165 DVSS_B.t37 3351.65029404371
Riso11098 DVSS_B.t165 DVSS_B.t509 28.0433554249434
Riso11099 DVSS_B.t165 DVSS_B.t515 516.527354415745
Riso11100 DVSS_B.t165 DVSS_B.t525 4313.55419720386
Riso11101 DVSS_B.t165 DVSS_B.t529 206.219303014057
Riso11102 DVSS_B.t165 DVSS_B.t531 516.527354415745
Riso11103 DVSS_B.t165 DVSS_B.t59 17466.9831258118
Riso11104 DVSS_B.t165 DVSS_B.t60 312.62790815385
Riso11105 DVSS_B.t165 DVSS_B.t66 559.89400534837
Riso11106 DVSS_B.t165 DVSS_B.t68 1033.78611700937
Riso11107 DVSS_B.t165 DVSS_B.t70 121.42682277223
Riso11108 DVSS_B.t165 DVSS_B.t72 51.9743475156552
Riso11109 DVSS_B.t165 DVSS_B.t74 5301.68074521247
Riso11110 DVSS_B.t165 DVSS_B.t76 1200.33032032532
Riso11111 DVSS_B.t165 DVSS_B.t80 1154.41816228409
Riso11112 DVSS_B.t165 DVSS_B.t82 893.222204612647
Riso11113 DVSS_B.t165 DVSS_B.t84 4313.55419720386
Riso11114 DVSS_B.t165 DVSS_B.t89 10534.5098164946
Riso11115 DVSS_B.t165 DVSS_B.t90 75.4076890896578
Riso11116 DVSS_B.t165 DVSS_B.t94 137.08798428344
Riso11117 DVSS_B.t165 DVSS_B.t96 67.3816326394865
Riso11118 DVSS_B.t165 VSS_A 3441.39175307995
Riso11119 DVSS_B.t165 VSS_B 442.03676853049
Riso11120 DVSS_B.t166 DVSS_B.t290 66.3487
Riso11121 DVSS_B.t166 DVSS_B.t508 66.3487
Riso11122 DVSS_B.t167 DVSS_B.t169 1137.19646012927
Riso11123 DVSS_B.t167 DVSS_B.t173 4938.93592093696
Riso11124 DVSS_B.t167 DVSS_B.t177 691.873322947754
Riso11125 DVSS_B.t167 DVSS_B.t20 300806.840138046
Riso11126 DVSS_B.t167 DVSS_B.t202 4938.93592093696
Riso11127 DVSS_B.t167 DVSS_B.t204 97.5946493043866
Riso11128 DVSS_B.t167 DVSS_B.t206 179.768104098423
Riso11129 DVSS_B.t167 DVSS_B.t21 3536.39034334166
Riso11130 DVSS_B.t167 DVSS_B.t212 143.90454214285
Riso11131 DVSS_B.t167 DVSS_B.t214 67.0134771184729
Riso11132 DVSS_B.t167 DVSS_B.t215 310636.028204317
Riso11133 DVSS_B.t167 DVSS_B.t216 4166.71824272996
Riso11134 DVSS_B.t167 DVSS_B.t218 392.977710119948
Riso11135 DVSS_B.t167 DVSS_B.t225 38.4726731151985
Riso11136 DVSS_B.t167 DVSS_B.t236 143.90454214285
Riso11137 DVSS_B.t167 DVSS_B.t238 1283.27393248009
Riso11138 DVSS_B.t167 DVSS_B.t240 161.511668520082
Riso11139 DVSS_B.t167 DVSS_B.t250 479.661992024892
Riso11140 DVSS_B.t167 DVSS_B.t252 1197.67097069084
Riso11141 DVSS_B.t167 DVSS_B.t256 655.295069852987
Riso11142 DVSS_B.t167 DVSS_B.t258 216.175585679901
Riso11143 DVSS_B.t167 DVSS_B.t259 18890.2992751647
Riso11144 DVSS_B.t167 DVSS_B.t260 247.218186126518
Riso11145 DVSS_B.t167 DVSS_B.t264 51.8257131020259
Riso11146 DVSS_B.t167 DVSS_B.t266 38.4726731151985
Riso11147 DVSS_B.t167 DVSS_B.t267 163855.22726995
Riso11148 DVSS_B.t167 DVSS_B.t268 1301.78926433233
Riso11149 DVSS_B.t167 DVSS_B.t271 1302.18187956251
Riso11150 DVSS_B.t167 DVSS_B.t273 435.4814869732
Riso11151 DVSS_B.t167 DVSS_B.t275 996.354394714662
Riso11152 DVSS_B.t167 DVSS_B.t277 111.793240106292
Riso11153 DVSS_B.t167 DVSS_B.t279 179.768104098423
Riso11154 DVSS_B.t167 DVSS_B.t281 32.7677916466635
Riso11155 DVSS_B.t167 DVSS_B.t283 921.234359567808
Riso11156 DVSS_B.t167 DVSS_B.t285 352.625416284088
Riso11157 DVSS_B.t167 DVSS_B.t287 392.977710119948
Riso11158 DVSS_B.t167 DVSS_B.t288 85021.6703476705
Riso11159 DVSS_B.t167 DVSS_B.t289 691.873322947754
Riso11160 DVSS_B.t167 DVSS_B.t291 0.066933273861193
Riso11161 DVSS_B.t167 DVSS_B.t293 1137.19646012927
Riso11162 DVSS_B.t167 DVSS_B.t295 232.847406108514
Riso11163 DVSS_B.t167 DVSS_B.t297 614.058583319162
Riso11164 DVSS_B.t167 DVSS_B.t299 1069.14737763547
Riso11165 DVSS_B.t167 DVSS_B.t301 34.6001889847887
Riso11166 DVSS_B.t167 DVSS_B.t302 5129.86435669173
Riso11167 DVSS_B.t167 DVSS_B.t303 34.6001889847887
Riso11168 DVSS_B.t167 DVSS_B.t305 655.295069852987
Riso11169 DVSS_B.t167 DVSS_B.t322 5557.57268119184
Riso11170 DVSS_B.t167 DVSS_B.t325 9574.23111791886
Riso11171 DVSS_B.t167 DVSS_B.t326 97.5946493043866
Riso11172 DVSS_B.t167 DVSS_B.t329 1073.13468243865
Riso11173 DVSS_B.t167 DVSS_B.t331 2080.06605910858
Riso11174 DVSS_B.t167 DVSS_B.t333 1977.08820267175
Riso11175 DVSS_B.t167 DVSS_B.t335 1047.57509322062
Riso11176 DVSS_B.t167 DVSS_B.t337 958.140680105178
Riso11177 DVSS_B.t167 DVSS_B.t339 2080.06605910858
Riso11178 DVSS_B.t167 DVSS_B.t341 1977.08820267175
Riso11179 DVSS_B.t167 DVSS_B.t343 855.689315893372
Riso11180 DVSS_B.t167 DVSS_B.t345 418826.517212025
Riso11181 DVSS_B.t167 DVSS_B.t346 1510.31827316559
Riso11182 DVSS_B.t167 DVSS_B.t348 435.4814869732
Riso11183 DVSS_B.t167 DVSS_B.t35 216.175585679901
Riso11184 DVSS_B.t167 DVSS_B.t350 1302.18187956251
Riso11185 DVSS_B.t167 DVSS_B.t352 1301.78926433233
Riso11186 DVSS_B.t167 DVSS_B.t355 1378139.43652159
Riso11187 DVSS_B.t167 DVSS_B.t356 2295.76849571105
Riso11188 DVSS_B.t167 DVSS_B.t358 51.8257131020259
Riso11189 DVSS_B.t167 DVSS_B.t36 227228.209882152
Riso11190 DVSS_B.t167 DVSS_B.t360 127.265515984791
Riso11191 DVSS_B.t167 DVSS_B.t364 32.7677916466635
Riso11192 DVSS_B.t167 DVSS_B.t366 30.6563956400345
Riso11193 DVSS_B.t167 DVSS_B.t37 3536.39034334166
Riso11194 DVSS_B.t167 DVSS_B.t509 30.6563956400345
Riso11195 DVSS_B.t167 DVSS_B.t515 524.832487119032
Riso11196 DVSS_B.t167 DVSS_B.t525 4521.99078027773
Riso11197 DVSS_B.t167 DVSS_B.t529 198.204652562234
Riso11198 DVSS_B.t167 DVSS_B.t531 524.832487119032
Riso11199 DVSS_B.t167 DVSS_B.t59 18890.2992751647
Riso11200 DVSS_B.t167 DVSS_B.t60 314.732131921202
Riso11201 DVSS_B.t167 DVSS_B.t66 570.047053121932
Riso11202 DVSS_B.t167 DVSS_B.t68 1069.14737763547
Riso11203 DVSS_B.t167 DVSS_B.t70 111.793240106292
Riso11204 DVSS_B.t167 DVSS_B.t72 44.8438994372296
Riso11205 DVSS_B.t167 DVSS_B.t74 5557.57268119184
Riso11206 DVSS_B.t167 DVSS_B.t76 1247.43798014778
Riso11207 DVSS_B.t167 DVSS_B.t80 1197.67097069084
Riso11208 DVSS_B.t167 DVSS_B.t82 921.234359567808
Riso11209 DVSS_B.t167 DVSS_B.t84 4521.99078027773
Riso11210 DVSS_B.t167 DVSS_B.t89 9574.23111791886
Riso11211 DVSS_B.t167 DVSS_B.t90 67.0134771184729
Riso11212 DVSS_B.t167 DVSS_B.t94 127.265515984791
Riso11213 DVSS_B.t167 DVSS_B.t96 59.2903242208422
Riso11214 DVSS_B.t167 VSS_A 3643.79817756143
Riso11215 DVSS_B.t167 VSS_B 473.040304149113
Riso11216 DVSS_B.t168 DVSS_B.t292 66.3487
Riso11217 DVSS_B.t168 DVSS_B.t79 66.3487
Riso11218 DVSS_B.t169 DVSS_B.t173 279.529907837103
Riso11219 DVSS_B.t169 DVSS_B.t177 94.740972712739
Riso11220 DVSS_B.t169 DVSS_B.t20 30248.5998985103
Riso11221 DVSS_B.t169 DVSS_B.t202 279.529907837103
Riso11222 DVSS_B.t169 DVSS_B.t204 777.288539394317
Riso11223 DVSS_B.t169 DVSS_B.t206 555.724566746506
Riso11224 DVSS_B.t169 DVSS_B.t21 354.017985522937
Riso11225 DVSS_B.t169 DVSS_B.t212 655.183721093454
Riso11226 DVSS_B.t169 DVSS_B.t214 913.066104973993
Riso11227 DVSS_B.t169 DVSS_B.t215 31088.6064472304
Riso11228 DVSS_B.t169 DVSS_B.t216 417.114931228516
Riso11229 DVSS_B.t169 DVSS_B.t218 234.788916088336
Riso11230 DVSS_B.t169 DVSS_B.t225 1111.51376120472
Riso11231 DVSS_B.t169 DVSS_B.t236 655.183721093454
Riso11232 DVSS_B.t169 DVSS_B.t238 52.4523658602611
Riso11233 DVSS_B.t169 DVSS_B.t240 606.04407936099
Riso11234 DVSS_B.t169 DVSS_B.t250 188.755979333325
Riso11235 DVSS_B.t169 DVSS_B.t252 39.2269431528519
Riso11236 DVSS_B.t169 DVSS_B.t256 110.172941514254
Riso11237 DVSS_B.t169 DVSS_B.t258 456.671337357699
Riso11238 DVSS_B.t169 DVSS_B.t259 25814.7164644003
Riso11239 DVSS_B.t169 DVSS_B.t260 365.395880187529
Riso11240 DVSS_B.t169 DVSS_B.t264 1030.72588892974
Riso11241 DVSS_B.t169 DVSS_B.t266 1111.51376120472
Riso11242 DVSS_B.t169 DVSS_B.t267 10943.2821036243
Riso11243 DVSS_B.t169 DVSS_B.t268 65.8582834743072
Riso11244 DVSS_B.t169 DVSS_B.t271 59.3348568916052
Riso11245 DVSS_B.t169 DVSS_B.t273 211.617833773057
Riso11246 DVSS_B.t169 DVSS_B.t275 46.3695435855487
Riso11247 DVSS_B.t169 DVSS_B.t277 742.895490213834
Riso11248 DVSS_B.t169 DVSS_B.t279 555.724566746506
Riso11249 DVSS_B.t169 DVSS_B.t281 1132.144430239
Riso11250 DVSS_B.t169 DVSS_B.t283 53.9339739343007
Riso11251 DVSS_B.t169 DVSS_B.t285 257.378732740072
Riso11252 DVSS_B.t169 DVSS_B.t287 234.788916088336
Riso11253 DVSS_B.t169 DVSS_B.t288 9207.12333381897
Riso11254 DVSS_B.t169 DVSS_B.t289 94.740972712739
Riso11255 DVSS_B.t169 DVSS_B.t291 1137.19646012927
Riso11256 DVSS_B.t169 DVSS_B.t293 0.0669605346151477
Riso11257 DVSS_B.t169 DVSS_B.t295 409.761129884918
Riso11258 DVSS_B.t169 DVSS_B.t297 127.365817092781
Riso11259 DVSS_B.t169 DVSS_B.t299 39.4864207553317
Riso11260 DVSS_B.t169 DVSS_B.t301 1054.6548102543
Riso11261 DVSS_B.t169 DVSS_B.t302 126527.673048251
Riso11262 DVSS_B.t169 DVSS_B.t303 1054.6548102543
Riso11263 DVSS_B.t169 DVSS_B.t305 110.172941514254
Riso11264 DVSS_B.t169 DVSS_B.t322 310.286104075645
Riso11265 DVSS_B.t169 DVSS_B.t325 94433.275440951
Riso11266 DVSS_B.t169 DVSS_B.t326 777.288539394317
Riso11267 DVSS_B.t169 DVSS_B.t329 135.622745336641
Riso11268 DVSS_B.t169 DVSS_B.t331 247.345050962216
Riso11269 DVSS_B.t169 DVSS_B.t333 235.752011765084
Riso11270 DVSS_B.t169 DVSS_B.t335 131.835531400682
Riso11271 DVSS_B.t169 DVSS_B.t337 114.312120261242
Riso11272 DVSS_B.t169 DVSS_B.t339 247.345050962216
Riso11273 DVSS_B.t169 DVSS_B.t341 235.752011765084
Riso11274 DVSS_B.t169 DVSS_B.t343 98.6629773506209
Riso11275 DVSS_B.t169 DVSS_B.t345 43525.1984708715
Riso11276 DVSS_B.t169 DVSS_B.t346 165.593531413816
Riso11277 DVSS_B.t169 DVSS_B.t348 211.617833773057
Riso11278 DVSS_B.t169 DVSS_B.t35 456.671337357699
Riso11279 DVSS_B.t169 DVSS_B.t350 59.3348568916052
Riso11280 DVSS_B.t169 DVSS_B.t352 65.8582834743072
Riso11281 DVSS_B.t169 DVSS_B.t355 132014.657918973
Riso11282 DVSS_B.t169 DVSS_B.t356 171.223475945
Riso11283 DVSS_B.t169 DVSS_B.t358 1030.72588892974
Riso11284 DVSS_B.t169 DVSS_B.t36 22849.663934589
Riso11285 DVSS_B.t169 DVSS_B.t360 701.461273908505
Riso11286 DVSS_B.t169 DVSS_B.t364 1132.144430239
Riso11287 DVSS_B.t169 DVSS_B.t366 1125.77049601466
Riso11288 DVSS_B.t169 DVSS_B.t37 354.017985522937
Riso11289 DVSS_B.t169 DVSS_B.t509 1125.77049601466
Riso11290 DVSS_B.t169 DVSS_B.t515 166.841217186626
Riso11291 DVSS_B.t169 DVSS_B.t525 277.959706294235
Riso11292 DVSS_B.t169 DVSS_B.t529 505.583934969606
Riso11293 DVSS_B.t169 DVSS_B.t531 166.841217186626
Riso11294 DVSS_B.t169 DVSS_B.t59 25814.7164644003
Riso11295 DVSS_B.t169 DVSS_B.t60 278.233698099827
Riso11296 DVSS_B.t169 DVSS_B.t66 146.294854276344
Riso11297 DVSS_B.t169 DVSS_B.t68 39.4864207553317
Riso11298 DVSS_B.t169 DVSS_B.t70 742.895490213834
Riso11299 DVSS_B.t169 DVSS_B.t72 1076.97387545588
Riso11300 DVSS_B.t169 DVSS_B.t74 310.286104075645
Riso11301 DVSS_B.t169 DVSS_B.t76 45.6492696871384
Riso11302 DVSS_B.t169 DVSS_B.t80 39.2269431528519
Riso11303 DVSS_B.t169 DVSS_B.t82 53.9339739343007
Riso11304 DVSS_B.t169 DVSS_B.t84 277.959706294235
Riso11305 DVSS_B.t169 DVSS_B.t89 94433.275440951
Riso11306 DVSS_B.t169 DVSS_B.t90 913.066104973993
Riso11307 DVSS_B.t169 DVSS_B.t94 701.461273908505
Riso11308 DVSS_B.t169 DVSS_B.t96 975.247973283235
Riso11309 DVSS_B.t169 VSS_A 473.686638139063
Riso11310 DVSS_B.t169 VSS_B 76.512492733405
Riso11311 DVSS_B.t172 DVSS_B.t201 356.886
Riso11312 DVSS_B.t172 DVSS_B.t524 356.886
Riso11313 DVSS_B.t173 DVSS_B.t177 674.911320812678
Riso11314 DVSS_B.t173 DVSS_B.t20 91833.4273023299
Riso11315 DVSS_B.t173 DVSS_B.t202 0.734714453092216
Riso11316 DVSS_B.t173 DVSS_B.t204 3627.22331487166
Riso11317 DVSS_B.t173 DVSS_B.t206 2738.1879270341
Riso11318 DVSS_B.t173 DVSS_B.t21 1079.93290101286
Riso11319 DVSS_B.t173 DVSS_B.t212 3161.03173244147
Riso11320 DVSS_B.t173 DVSS_B.t214 4145.28543218869
Riso11321 DVSS_B.t173 DVSS_B.t215 84506.6247086359
Riso11322 DVSS_B.t173 DVSS_B.t216 1257.5905883367
Riso11323 DVSS_B.t173 DVSS_B.t218 1379.5863745688
Riso11324 DVSS_B.t173 DVSS_B.t225 4895.95716119418
Riso11325 DVSS_B.t173 DVSS_B.t236 3161.03173244147
Riso11326 DVSS_B.t173 DVSS_B.t238 171.310401408015
Riso11327 DVSS_B.t173 DVSS_B.t240 2955.42519812732
Riso11328 DVSS_B.t173 DVSS_B.t250 1181.07341951412
Riso11329 DVSS_B.t173 DVSS_B.t252 239.038099154453
Riso11330 DVSS_B.t173 DVSS_B.t256 766.813532806521
Riso11331 DVSS_B.t173 DVSS_B.t258 2294.0836112258
Riso11332 DVSS_B.t173 DVSS_B.t259 99882.7711276314
Riso11333 DVSS_B.t173 DVSS_B.t260 1867.81662389783
Riso11334 DVSS_B.t173 DVSS_B.t264 4609.3219343324
Riso11335 DVSS_B.t173 DVSS_B.t266 4895.95716119418
Riso11336 DVSS_B.t173 DVSS_B.t267 13343.7912941093
Riso11337 DVSS_B.t173 DVSS_B.t268 120.147484756445
Riso11338 DVSS_B.t173 DVSS_B.t271 143.806861945201
Riso11339 DVSS_B.t173 DVSS_B.t273 1284.29831177199
Riso11340 DVSS_B.t173 DVSS_B.t275 372.541745736499
Riso11341 DVSS_B.t173 DVSS_B.t277 3505.66140063924
Riso11342 DVSS_B.t173 DVSS_B.t279 2738.1879270341
Riso11343 DVSS_B.t173 DVSS_B.t281 4950.8019516136
Riso11344 DVSS_B.t173 DVSS_B.t283 423.316479358039
Riso11345 DVSS_B.t173 DVSS_B.t285 1461.53357567074
Riso11346 DVSS_B.t173 DVSS_B.t287 1379.5863745688
Riso11347 DVSS_B.t173 DVSS_B.t288 66331.7999168554
Riso11348 DVSS_B.t173 DVSS_B.t289 674.911320812678
Riso11349 DVSS_B.t173 DVSS_B.t291 4938.93592093696
Riso11350 DVSS_B.t173 DVSS_B.t293 279.529907837103
Riso11351 DVSS_B.t173 DVSS_B.t295 2076.95142132434
Riso11352 DVSS_B.t173 DVSS_B.t297 865.019927505012
Riso11353 DVSS_B.t173 DVSS_B.t299 324.2344810484
Riso11354 DVSS_B.t173 DVSS_B.t301 4503.60149517769
Riso11355 DVSS_B.t173 DVSS_B.t302 534258.655740254
Riso11356 DVSS_B.t173 DVSS_B.t303 4503.60149517769
Riso11357 DVSS_B.t173 DVSS_B.t305 766.813532806521
Riso11358 DVSS_B.t173 DVSS_B.t322 33.8520154296181
Riso11359 DVSS_B.t173 DVSS_B.t325 429889.38954122
Riso11360 DVSS_B.t173 DVSS_B.t326 3627.22331487166
Riso11361 DVSS_B.t173 DVSS_B.t329 154.20667248465
Riso11362 DVSS_B.t173 DVSS_B.t331 255.978327288967
Riso11363 DVSS_B.t173 DVSS_B.t333 262.019915718981
Riso11364 DVSS_B.t173 DVSS_B.t335 156.698938080491
Riso11365 DVSS_B.t173 DVSS_B.t337 128.387486825608
Riso11366 DVSS_B.t173 DVSS_B.t339 255.978327288967
Riso11367 DVSS_B.t173 DVSS_B.t341 262.019915718981
Riso11368 DVSS_B.t173 DVSS_B.t343 114.067900062964
Riso11369 DVSS_B.t173 DVSS_B.t345 14377.4900820108
Riso11370 DVSS_B.t173 DVSS_B.t346 61.9071393830628
Riso11371 DVSS_B.t173 DVSS_B.t348 1284.29831177199
Riso11372 DVSS_B.t173 DVSS_B.t35 2294.0836112258
Riso11373 DVSS_B.t173 DVSS_B.t350 143.806861945201
Riso11374 DVSS_B.t173 DVSS_B.t352 120.147484756445
Riso11375 DVSS_B.t173 DVSS_B.t355 37404.9707973938
Riso11376 DVSS_B.t173 DVSS_B.t356 35.3502409917698
Riso11377 DVSS_B.t173 DVSS_B.t358 4609.3219343324
Riso11378 DVSS_B.t173 DVSS_B.t36 69370.5810801209
Riso11379 DVSS_B.t173 DVSS_B.t360 3347.29584005319
Riso11380 DVSS_B.t173 DVSS_B.t364 4950.8019516136
Riso11381 DVSS_B.t173 DVSS_B.t366 4858.51815592351
Riso11382 DVSS_B.t173 DVSS_B.t37 1079.93290101286
Riso11383 DVSS_B.t173 DVSS_B.t509 4858.51815592351
Riso11384 DVSS_B.t173 DVSS_B.t515 1074.50071467724
Riso11385 DVSS_B.t173 DVSS_B.t525 45.1294064389068
Riso11386 DVSS_B.t173 DVSS_B.t529 2515.92973021671
Riso11387 DVSS_B.t173 DVSS_B.t531 1074.50071467724
Riso11388 DVSS_B.t173 DVSS_B.t59 99882.7711276314
Riso11389 DVSS_B.t173 DVSS_B.t60 1524.27135243234
Riso11390 DVSS_B.t173 DVSS_B.t66 968.233469880474
Riso11391 DVSS_B.t173 DVSS_B.t68 324.2344810484
Riso11392 DVSS_B.t173 DVSS_B.t70 3505.66140063924
Riso11393 DVSS_B.t173 DVSS_B.t72 4779.56298821661
Riso11394 DVSS_B.t173 DVSS_B.t74 33.8520154296181
Riso11395 DVSS_B.t173 DVSS_B.t76 202.98064324748
Riso11396 DVSS_B.t173 DVSS_B.t80 239.038099154453
Riso11397 DVSS_B.t173 DVSS_B.t82 423.316479358039
Riso11398 DVSS_B.t173 DVSS_B.t84 45.1294064389068
Riso11399 DVSS_B.t173 DVSS_B.t89 429889.38954122
Riso11400 DVSS_B.t173 DVSS_B.t90 4145.28543218869
Riso11401 DVSS_B.t173 DVSS_B.t94 3347.29584005319
Riso11402 DVSS_B.t173 DVSS_B.t96 4394.55328284415
Riso11403 DVSS_B.t173 VSS_A 543.908737380346
Riso11404 DVSS_B.t173 VSS_B 98.4691861198579
Riso11405 DVSS_B.t176 DVSS_B.t288 66.3487
Riso11406 DVSS_B.t176 DVSS_B.t304 66.3487
Riso11407 DVSS_B.t177 DVSS_B.t20 53550.3143366467
Riso11408 DVSS_B.t177 DVSS_B.t202 674.911320812678
Riso11409 DVSS_B.t177 DVSS_B.t204 440.107046991465
Riso11410 DVSS_B.t177 DVSS_B.t206 293.661858064571
Riso11411 DVSS_B.t177 DVSS_B.t21 627.21801896889
Riso11412 DVSS_B.t177 DVSS_B.t212 356.485532304664
Riso11413 DVSS_B.t177 DVSS_B.t214 532.56913051225
Riso11414 DVSS_B.t177 DVSS_B.t215 55123.5723632429
Riso11415 DVSS_B.t177 DVSS_B.t216 739.061574108129
Riso11416 DVSS_B.t177 DVSS_B.t218 99.136606089643
Riso11417 DVSS_B.t177 DVSS_B.t225 667.676121839881
Riso11418 DVSS_B.t177 DVSS_B.t236 356.485532304664
Riso11419 DVSS_B.t177 DVSS_B.t238 135.465253635219
Riso11420 DVSS_B.t177 DVSS_B.t240 325.036895980636
Riso11421 DVSS_B.t177 DVSS_B.t250 74.3817418629053
Riso11422 DVSS_B.t177 DVSS_B.t252 108.056845527655
Riso11423 DVSS_B.t177 DVSS_B.t256 38.4890506767861
Riso11424 DVSS_B.t177 DVSS_B.t258 234.005959370114
Riso11425 DVSS_B.t177 DVSS_B.t259 17376.9302411812
Riso11426 DVSS_B.t177 DVSS_B.t260 181.350375513102
Riso11427 DVSS_B.t177 DVSS_B.t264 610.402445272832
Riso11428 DVSS_B.t177 DVSS_B.t266 667.676121839881
Riso11429 DVSS_B.t177 DVSS_B.t267 24140.9189869209
Riso11430 DVSS_B.t177 DVSS_B.t268 159.27238581442
Riso11431 DVSS_B.t177 DVSS_B.t271 148.252747570981
Riso11432 DVSS_B.t177 DVSS_B.t273 86.2531813066918
Riso11433 DVSS_B.t177 DVSS_B.t275 70.7923747934473
Riso11434 DVSS_B.t177 DVSS_B.t277 415.356226692483
Riso11435 DVSS_B.t177 DVSS_B.t279 293.661858064571
Riso11436 DVSS_B.t177 DVSS_B.t281 684.570816833709
Riso11437 DVSS_B.t177 DVSS_B.t283 60.4880974028925
Riso11438 DVSS_B.t177 DVSS_B.t285 112.759210419962
Riso11439 DVSS_B.t177 DVSS_B.t287 99.136606089643
Riso11440 DVSS_B.t177 DVSS_B.t288 4944.50053369684
Riso11441 DVSS_B.t177 DVSS_B.t289 0.0669558029435427
Riso11442 DVSS_B.t177 DVSS_B.t291 691.873322947754
Riso11443 DVSS_B.t177 DVSS_B.t293 94.740972712739
Riso11444 DVSS_B.t177 DVSS_B.t295 206.666984905013
Riso11445 DVSS_B.t177 DVSS_B.t297 45.7588345540327
Riso11446 DVSS_B.t177 DVSS_B.t299 82.245187014794
Riso11447 DVSS_B.t177 DVSS_B.t301 651.43860095945
Riso11448 DVSS_B.t177 DVSS_B.t302 79017.582081604
Riso11449 DVSS_B.t177 DVSS_B.t303 651.43860095945
Riso11450 DVSS_B.t177 DVSS_B.t305 38.4890506767861
Riso11451 DVSS_B.t177 DVSS_B.t322 753.166959651821
Riso11452 DVSS_B.t177 DVSS_B.t325 54902.736047811
Riso11453 DVSS_B.t177 DVSS_B.t326 440.107046991465
Riso11454 DVSS_B.t177 DVSS_B.t329 230.448600219772
Riso11455 DVSS_B.t177 DVSS_B.t331 434.964359487285
Riso11456 DVSS_B.t177 DVSS_B.t333 415.950577477514
Riso11457 DVSS_B.t177 DVSS_B.t335 226.296395459279
Riso11458 DVSS_B.t177 DVSS_B.t337 197.019287184486
Riso11459 DVSS_B.t177 DVSS_B.t339 434.964359487285
Riso11460 DVSS_B.t177 DVSS_B.t341 415.950577477514
Riso11461 DVSS_B.t177 DVSS_B.t343 172.774678807058
Riso11462 DVSS_B.t177 DVSS_B.t345 79144.2747388014
Riso11463 DVSS_B.t177 DVSS_B.t346 292.39068860095
Riso11464 DVSS_B.t177 DVSS_B.t348 86.2531813066918
Riso11465 DVSS_B.t177 DVSS_B.t35 234.005959370114
Riso11466 DVSS_B.t177 DVSS_B.t350 148.252747570981
Riso11467 DVSS_B.t177 DVSS_B.t352 159.27238581442
Riso11468 DVSS_B.t177 DVSS_B.t355 250676.099857889
Riso11469 DVSS_B.t177 DVSS_B.t356 367.611513524965
Riso11470 DVSS_B.t177 DVSS_B.t358 610.402445272832
Riso11471 DVSS_B.t177 DVSS_B.t36 40451.6800873232
Riso11472 DVSS_B.t177 DVSS_B.t360 387.004240446117
Riso11473 DVSS_B.t177 DVSS_B.t364 684.570816833709
Riso11474 DVSS_B.t177 DVSS_B.t366 688.798245257702
Riso11475 DVSS_B.t177 DVSS_B.t37 627.21801896889
Riso11476 DVSS_B.t177 DVSS_B.t509 688.798245257702
Riso11477 DVSS_B.t177 DVSS_B.t515 63.6596384219644
Riso11478 DVSS_B.t177 DVSS_B.t525 649.213023500142
Riso11479 DVSS_B.t177 DVSS_B.t529 263.131400120466
Riso11480 DVSS_B.t177 DVSS_B.t531 63.6596384219644
Riso11481 DVSS_B.t177 DVSS_B.t59 17376.9302411812
Riso11482 DVSS_B.t177 DVSS_B.t60 126.672952128409
Riso11483 DVSS_B.t177 DVSS_B.t66 54.1270416819037
Riso11484 DVSS_B.t177 DVSS_B.t68 82.245187014794
Riso11485 DVSS_B.t177 DVSS_B.t70 415.356226692483
Riso11486 DVSS_B.t177 DVSS_B.t72 642.438944358431
Riso11487 DVSS_B.t177 DVSS_B.t74 753.166959651821
Riso11488 DVSS_B.t177 DVSS_B.t76 121.817346279206
Riso11489 DVSS_B.t177 DVSS_B.t80 108.056845527655
Riso11490 DVSS_B.t177 DVSS_B.t82 60.4880974028925
Riso11491 DVSS_B.t177 DVSS_B.t84 649.213023500142
Riso11492 DVSS_B.t177 DVSS_B.t89 54902.736047811
Riso11493 DVSS_B.t177 DVSS_B.t90 532.56913051225
Riso11494 DVSS_B.t177 DVSS_B.t94 387.004240446117
Riso11495 DVSS_B.t177 DVSS_B.t96 573.231930994408
Riso11496 DVSS_B.t177 VSS_A 798.539665208439
Riso11497 DVSS_B.t177 VSS_B 124.672921191028
Riso11498 DVSS_B.t20 DVSS_B.t202 91833.4273023299
Riso11499 DVSS_B.t20 DVSS_B.t204 221284.434969797
Riso11500 DVSS_B.t20 DVSS_B.t206 167230.178903881
Riso11501 DVSS_B.t20 DVSS_B.t21 1808.14389518217
Riso11502 DVSS_B.t20 DVSS_B.t212 193291.874540739
Riso11503 DVSS_B.t20 DVSS_B.t214 252804.567869559
Riso11504 DVSS_B.t20 DVSS_B.t215 118748.690063569
Riso11505 DVSS_B.t20 DVSS_B.t216 2019.407801609
Riso11506 DVSS_B.t20 DVSS_B.t218 91171.9297878209
Riso11507 DVSS_B.t20 DVSS_B.t225 299284.151972714
Riso11508 DVSS_B.t20 DVSS_B.t236 193291.874540739
Riso11509 DVSS_B.t20 DVSS_B.t238 22188.2168858471
Riso11510 DVSS_B.t20 DVSS_B.t240 180643.257548106
Riso11511 DVSS_B.t20 DVSS_B.t250 81929.1409717417
Riso11512 DVSS_B.t20 DVSS_B.t252 27407.4219963598
Riso11513 DVSS_B.t20 DVSS_B.t256 59086.6505497519
Riso11514 DVSS_B.t20 DVSS_B.t258 139807.878450652
Riso11515 DVSS_B.t20 DVSS_B.t259 5128230.27762007
Riso11516 DVSS_B.t20 DVSS_B.t260 113622.822277908
Riso11517 DVSS_B.t20 DVSS_B.t264 281838.598653096
Riso11518 DVSS_B.t20 DVSS_B.t266 299284.151972714
Riso11519 DVSS_B.t20 DVSS_B.t267 1965785.10579495
Riso11520 DVSS_B.t20 DVSS_B.t268 17681.9128486962
Riso11521 DVSS_B.t20 DVSS_B.t271 19843.4573476661
Riso11522 DVSS_B.t20 DVSS_B.t273 86943.6189384556
Riso11523 DVSS_B.t20 DVSS_B.t275 36200.1342263067
Riso11524 DVSS_B.t20 DVSS_B.t277 214181.539928551
Riso11525 DVSS_B.t20 DVSS_B.t279 167230.178903881
Riso11526 DVSS_B.t20 DVSS_B.t281 302210.668472346
Riso11527 DVSS_B.t20 DVSS_B.t283 39168.7352655608
Riso11528 DVSS_B.t20 DVSS_B.t285 94304.6622532973
Riso11529 DVSS_B.t20 DVSS_B.t287 91171.9297878209
Riso11530 DVSS_B.t20 DVSS_B.t288 5371287.55065382
Riso11531 DVSS_B.t20 DVSS_B.t289 53550.3143366467
Riso11532 DVSS_B.t20 DVSS_B.t291 300806.840138046
Riso11533 DVSS_B.t20 DVSS_B.t293 30248.5998985103
Riso11534 DVSS_B.t20 DVSS_B.t295 126446.039955791
Riso11535 DVSS_B.t20 DVSS_B.t297 64821.2331559547
Riso11536 DVSS_B.t20 DVSS_B.t299 33198.905016901
Riso11537 DVSS_B.t20 DVSS_B.t301 271345.616930748
Riso11538 DVSS_B.t20 DVSS_B.t302 31660133.1750641
Riso11539 DVSS_B.t20 DVSS_B.t303 271345.616930748
Riso11540 DVSS_B.t20 DVSS_B.t305 59086.6505497519
Riso11541 DVSS_B.t20 DVSS_B.t322 102113.183180115
Riso11542 DVSS_B.t20 DVSS_B.t325 25843612.8636325
Riso11543 DVSS_B.t20 DVSS_B.t326 221284.434969797
Riso11544 DVSS_B.t20 DVSS_B.t329 14481.9592057011
Riso11545 DVSS_B.t20 DVSS_B.t331 25168.5081244866
Riso11546 DVSS_B.t20 DVSS_B.t333 20435.8001911633
Riso11547 DVSS_B.t20 DVSS_B.t335 11928.4331000521
Riso11548 DVSS_B.t20 DVSS_B.t337 12038.007376179
Riso11549 DVSS_B.t20 DVSS_B.t339 25168.5081244866
Riso11550 DVSS_B.t20 DVSS_B.t341 20435.8001911633
Riso11551 DVSS_B.t20 DVSS_B.t343 9010.95370100162
Riso11552 DVSS_B.t20 DVSS_B.t345 13011414.3544171
Riso11553 DVSS_B.t20 DVSS_B.t346 51206.4253236502
Riso11554 DVSS_B.t20 DVSS_B.t348 86943.6189384556
Riso11555 DVSS_B.t20 DVSS_B.t35 139807.878450652
Riso11556 DVSS_B.t20 DVSS_B.t350 19843.4573476661
Riso11557 DVSS_B.t20 DVSS_B.t352 17681.9128486962
Riso11558 DVSS_B.t20 DVSS_B.t355 38721253.2956749
Riso11559 DVSS_B.t20 DVSS_B.t356 54069.9612868166
Riso11560 DVSS_B.t20 DVSS_B.t358 281838.598653096
Riso11561 DVSS_B.t20 DVSS_B.t36 8878.69722710815
Riso11562 DVSS_B.t20 DVSS_B.t360 204659.622788756
Riso11563 DVSS_B.t20 DVSS_B.t364 302210.668472346
Riso11564 DVSS_B.t20 DVSS_B.t366 295014.910543005
Riso11565 DVSS_B.t20 DVSS_B.t37 1808.14389518217
Riso11566 DVSS_B.t20 DVSS_B.t509 295014.910543005
Riso11567 DVSS_B.t20 DVSS_B.t515 76415.2390147892
Riso11568 DVSS_B.t20 DVSS_B.t525 90330.3520036328
Riso11569 DVSS_B.t20 DVSS_B.t529 153497.18132599
Riso11570 DVSS_B.t20 DVSS_B.t531 76415.2390147892
Riso11571 DVSS_B.t20 DVSS_B.t59 5128230.27762007
Riso11572 DVSS_B.t20 DVSS_B.t60 96042.5977667053
Riso11573 DVSS_B.t20 DVSS_B.t66 70647.0877514356
Riso11574 DVSS_B.t20 DVSS_B.t68 33198.905016901
Riso11575 DVSS_B.t20 DVSS_B.t70 214181.539928551
Riso11576 DVSS_B.t20 DVSS_B.t72 292328.518538128
Riso11577 DVSS_B.t20 DVSS_B.t74 102113.183180115
Riso11578 DVSS_B.t20 DVSS_B.t76 24713.1945018133
Riso11579 DVSS_B.t20 DVSS_B.t80 27407.4219963598
Riso11580 DVSS_B.t20 DVSS_B.t82 39168.7352655608
Riso11581 DVSS_B.t20 DVSS_B.t84 90330.3520036328
Riso11582 DVSS_B.t20 DVSS_B.t89 25843612.8636325
Riso11583 DVSS_B.t20 DVSS_B.t90 252804.567869559
Riso11584 DVSS_B.t20 DVSS_B.t94 204659.622788756
Riso11585 DVSS_B.t20 DVSS_B.t96 268436.821470259
Riso11586 DVSS_B.t20 VSS_A 50979.1846096463
Riso11587 DVSS_B.t20 VSS_B 6140.96680769188
Riso11588 DVSS_B.t201 DVSS_B.t73 356.886
Riso11589 DVSS_B.t202 DVSS_B.t204 3627.22331487166
Riso11590 DVSS_B.t202 DVSS_B.t206 2738.1879270341
Riso11591 DVSS_B.t202 DVSS_B.t21 1079.93290101286
Riso11592 DVSS_B.t202 DVSS_B.t212 3161.03173244147
Riso11593 DVSS_B.t202 DVSS_B.t214 4145.28543218869
Riso11594 DVSS_B.t202 DVSS_B.t215 84506.6247086359
Riso11595 DVSS_B.t202 DVSS_B.t216 1257.5905883367
Riso11596 DVSS_B.t202 DVSS_B.t218 1379.5863745688
Riso11597 DVSS_B.t202 DVSS_B.t225 4895.95716119418
Riso11598 DVSS_B.t202 DVSS_B.t236 3161.03173244147
Riso11599 DVSS_B.t202 DVSS_B.t238 171.310401408015
Riso11600 DVSS_B.t202 DVSS_B.t240 2955.42519812732
Riso11601 DVSS_B.t202 DVSS_B.t250 1181.07341951412
Riso11602 DVSS_B.t202 DVSS_B.t252 239.038099154453
Riso11603 DVSS_B.t202 DVSS_B.t256 766.813532806521
Riso11604 DVSS_B.t202 DVSS_B.t258 2294.0836112258
Riso11605 DVSS_B.t202 DVSS_B.t259 99882.7711276314
Riso11606 DVSS_B.t202 DVSS_B.t260 1867.81662389783
Riso11607 DVSS_B.t202 DVSS_B.t264 4609.3219343324
Riso11608 DVSS_B.t202 DVSS_B.t266 4895.95716119418
Riso11609 DVSS_B.t202 DVSS_B.t267 13343.7912941093
Riso11610 DVSS_B.t202 DVSS_B.t268 120.147484756445
Riso11611 DVSS_B.t202 DVSS_B.t271 143.806861945201
Riso11612 DVSS_B.t202 DVSS_B.t273 1284.29831177199
Riso11613 DVSS_B.t202 DVSS_B.t275 372.541745736499
Riso11614 DVSS_B.t202 DVSS_B.t277 3505.66140063924
Riso11615 DVSS_B.t202 DVSS_B.t279 2738.1879270341
Riso11616 DVSS_B.t202 DVSS_B.t281 4950.8019516136
Riso11617 DVSS_B.t202 DVSS_B.t283 423.316479358039
Riso11618 DVSS_B.t202 DVSS_B.t285 1461.53357567074
Riso11619 DVSS_B.t202 DVSS_B.t287 1379.5863745688
Riso11620 DVSS_B.t202 DVSS_B.t288 66331.7999168554
Riso11621 DVSS_B.t202 DVSS_B.t289 674.911320812678
Riso11622 DVSS_B.t202 DVSS_B.t291 4938.93592093696
Riso11623 DVSS_B.t202 DVSS_B.t293 279.529907837103
Riso11624 DVSS_B.t202 DVSS_B.t295 2076.95142132434
Riso11625 DVSS_B.t202 DVSS_B.t297 865.019927505012
Riso11626 DVSS_B.t202 DVSS_B.t299 324.2344810484
Riso11627 DVSS_B.t202 DVSS_B.t301 4503.60149517769
Riso11628 DVSS_B.t202 DVSS_B.t302 534258.655740254
Riso11629 DVSS_B.t202 DVSS_B.t303 4503.60149517769
Riso11630 DVSS_B.t202 DVSS_B.t305 766.813532806521
Riso11631 DVSS_B.t202 DVSS_B.t322 33.8520154296181
Riso11632 DVSS_B.t202 DVSS_B.t325 429889.38954122
Riso11633 DVSS_B.t202 DVSS_B.t326 3627.22331487166
Riso11634 DVSS_B.t202 DVSS_B.t329 154.20667248465
Riso11635 DVSS_B.t202 DVSS_B.t331 255.978327288967
Riso11636 DVSS_B.t202 DVSS_B.t333 262.019915718981
Riso11637 DVSS_B.t202 DVSS_B.t335 156.698938080491
Riso11638 DVSS_B.t202 DVSS_B.t337 128.387486825608
Riso11639 DVSS_B.t202 DVSS_B.t339 255.978327288967
Riso11640 DVSS_B.t202 DVSS_B.t341 262.019915718981
Riso11641 DVSS_B.t202 DVSS_B.t343 114.067900062964
Riso11642 DVSS_B.t202 DVSS_B.t345 14377.4900820108
Riso11643 DVSS_B.t202 DVSS_B.t346 61.9071393830628
Riso11644 DVSS_B.t202 DVSS_B.t348 1284.29831177199
Riso11645 DVSS_B.t202 DVSS_B.t35 2294.0836112258
Riso11646 DVSS_B.t202 DVSS_B.t350 143.806861945201
Riso11647 DVSS_B.t202 DVSS_B.t352 120.147484756445
Riso11648 DVSS_B.t202 DVSS_B.t355 37404.9707973938
Riso11649 DVSS_B.t202 DVSS_B.t356 35.3502409917698
Riso11650 DVSS_B.t202 DVSS_B.t358 4609.3219343324
Riso11651 DVSS_B.t202 DVSS_B.t36 69370.5810801209
Riso11652 DVSS_B.t202 DVSS_B.t360 3347.29584005319
Riso11653 DVSS_B.t202 DVSS_B.t364 4950.8019516136
Riso11654 DVSS_B.t202 DVSS_B.t366 4858.51815592351
Riso11655 DVSS_B.t202 DVSS_B.t37 1079.93290101286
Riso11656 DVSS_B.t202 DVSS_B.t509 4858.51815592351
Riso11657 DVSS_B.t202 DVSS_B.t515 1074.50071467724
Riso11658 DVSS_B.t202 DVSS_B.t525 45.1294064389068
Riso11659 DVSS_B.t202 DVSS_B.t529 2515.92973021671
Riso11660 DVSS_B.t202 DVSS_B.t531 1074.50071467724
Riso11661 DVSS_B.t202 DVSS_B.t59 99882.7711276314
Riso11662 DVSS_B.t202 DVSS_B.t60 1524.27135243234
Riso11663 DVSS_B.t202 DVSS_B.t66 968.233469880474
Riso11664 DVSS_B.t202 DVSS_B.t68 324.2344810484
Riso11665 DVSS_B.t202 DVSS_B.t70 3505.66140063924
Riso11666 DVSS_B.t202 DVSS_B.t72 4779.56298821661
Riso11667 DVSS_B.t202 DVSS_B.t74 33.8520154296181
Riso11668 DVSS_B.t202 DVSS_B.t76 202.98064324748
Riso11669 DVSS_B.t202 DVSS_B.t80 239.038099154453
Riso11670 DVSS_B.t202 DVSS_B.t82 423.316479358039
Riso11671 DVSS_B.t202 DVSS_B.t84 45.1294064389068
Riso11672 DVSS_B.t202 DVSS_B.t89 429889.38954122
Riso11673 DVSS_B.t202 DVSS_B.t90 4145.28543218869
Riso11674 DVSS_B.t202 DVSS_B.t94 3347.29584005319
Riso11675 DVSS_B.t202 DVSS_B.t96 4394.55328284415
Riso11676 DVSS_B.t202 VSS_A 543.908737380346
Riso11677 DVSS_B.t202 VSS_B 98.4691861198579
Riso11678 DVSS_B.t203 DVSS_B.t276 66.3487
Riso11679 DVSS_B.t203 DVSS_B.t325 66.3487
Riso11680 DVSS_B.t204 DVSS_B.t206 71.5543709276809
Riso11681 DVSS_B.t204 DVSS_B.t21 2599.54510433101
Riso11682 DVSS_B.t204 DVSS_B.t212 52.3201427373384
Riso11683 DVSS_B.t204 DVSS_B.t214 48.5258328959326
Riso11684 DVSS_B.t204 DVSS_B.t215 228397.092667708
Riso11685 DVSS_B.t204 DVSS_B.t216 3062.96717577838
Riso11686 DVSS_B.t204 DVSS_B.t218 222.568773448401
Riso11687 DVSS_B.t204 DVSS_B.t225 82.0885388395866
Riso11688 DVSS_B.t204 DVSS_B.t236 52.3201427373384
Riso11689 DVSS_B.t204 DVSS_B.t238 901.799708800677
Riso11690 DVSS_B.t204 DVSS_B.t240 61.3908745452568
Riso11691 DVSS_B.t204 DVSS_B.t250 281.425793249431
Riso11692 DVSS_B.t204 DVSS_B.t252 826.213964054565
Riso11693 DVSS_B.t204 DVSS_B.t256 410.56219728836
Riso11694 DVSS_B.t204 DVSS_B.t258 94.8612575334884
Riso11695 DVSS_B.t204 DVSS_B.t259 15528.6834245137
Riso11696 DVSS_B.t204 DVSS_B.t260 120.490989435447
Riso11697 DVSS_B.t204 DVSS_B.t264 64.6789904678678
Riso11698 DVSS_B.t204 DVSS_B.t266 82.0885388395866
Riso11699 DVSS_B.t204 DVSS_B.t267 119899.559659017
Riso11700 DVSS_B.t204 DVSS_B.t268 931.322282719418
Riso11701 DVSS_B.t204 DVSS_B.t271 923.444701167119
Riso11702 DVSS_B.t204 DVSS_B.t273 251.082048960639
Riso11703 DVSS_B.t204 DVSS_B.t275 668.708267486351
Riso11704 DVSS_B.t204 DVSS_B.t277 37.3646039190236
Riso11705 DVSS_B.t204 DVSS_B.t279 71.5543709276809
Riso11706 DVSS_B.t204 DVSS_B.t281 90.3392273743521
Riso11707 DVSS_B.t204 DVSS_B.t283 612.731860276877
Riso11708 DVSS_B.t204 DVSS_B.t285 196.111484467771
Riso11709 DVSS_B.t204 DVSS_B.t287 222.568773448401
Riso11710 DVSS_B.t204 DVSS_B.t288 56007.4325108503
Riso11711 DVSS_B.t204 DVSS_B.t289 440.107046991465
Riso11712 DVSS_B.t204 DVSS_B.t291 97.5946493043866
Riso11713 DVSS_B.t204 DVSS_B.t293 777.288539394317
Riso11714 DVSS_B.t204 DVSS_B.t295 107.585042718235
Riso11715 DVSS_B.t204 DVSS_B.t297 378.720874047976
Riso11716 DVSS_B.t204 DVSS_B.t299 724.113429647593
Riso11717 DVSS_B.t204 DVSS_B.t301 108.015798519143
Riso11718 DVSS_B.t204 DVSS_B.t302 14648.7915513392
Riso11719 DVSS_B.t204 DVSS_B.t303 108.015798519143
Riso11720 DVSS_B.t204 DVSS_B.t305 410.56219728836
Riso11721 DVSS_B.t204 DVSS_B.t322 4079.27892648699
Riso11722 DVSS_B.t204 DVSS_B.t325 4738.68196417508
Riso11723 DVSS_B.t204 DVSS_B.t326 0.0669518983903541
Riso11724 DVSS_B.t204 DVSS_B.t329 817.79885240711
Riso11725 DVSS_B.t204 DVSS_B.t331 1583.2454741209
Riso11726 DVSS_B.t204 DVSS_B.t333 1507.39836295828
Riso11727 DVSS_B.t204 DVSS_B.t335 800.272026587105
Riso11728 DVSS_B.t204 DVSS_B.t337 724.90073211588
Riso11729 DVSS_B.t204 DVSS_B.t339 1583.2454741209
Riso11730 DVSS_B.t204 DVSS_B.t341 1507.39836295828
Riso11731 DVSS_B.t204 DVSS_B.t343 646.233585482921
Riso11732 DVSS_B.t204 DVSS_B.t345 313406.534402903
Riso11733 DVSS_B.t204 DVSS_B.t346 1131.51049792537
Riso11734 DVSS_B.t204 DVSS_B.t348 251.082048960639
Riso11735 DVSS_B.t204 DVSS_B.t35 94.8612575334884
Riso11736 DVSS_B.t204 DVSS_B.t350 923.444701167119
Riso11737 DVSS_B.t204 DVSS_B.t352 931.322282719418
Riso11738 DVSS_B.t204 DVSS_B.t355 1029274.17369711
Riso11739 DVSS_B.t204 DVSS_B.t356 1702.77146005235
Riso11740 DVSS_B.t204 DVSS_B.t358 64.6789904678678
Riso11741 DVSS_B.t204 DVSS_B.t36 167157.322652288
Riso11742 DVSS_B.t204 DVSS_B.t360 44.3292819159557
Riso11743 DVSS_B.t204 DVSS_B.t364 90.3392273743521
Riso11744 DVSS_B.t204 DVSS_B.t366 103.281412064433
Riso11745 DVSS_B.t204 DVSS_B.t37 2599.54510433101
Riso11746 DVSS_B.t204 DVSS_B.t509 103.281412064433
Riso11747 DVSS_B.t204 DVSS_B.t515 313.226652519204
Riso11748 DVSS_B.t204 DVSS_B.t525 3331.76901849228
Riso11749 DVSS_B.t204 DVSS_B.t529 82.7595259617916
Riso11750 DVSS_B.t204 DVSS_B.t531 313.226652519204
Riso11751 DVSS_B.t204 DVSS_B.t59 15528.6834245137
Riso11752 DVSS_B.t204 DVSS_B.t60 171.823249801803
Riso11753 DVSS_B.t204 DVSS_B.t66 345.922641505063
Riso11754 DVSS_B.t204 DVSS_B.t68 724.113429647593
Riso11755 DVSS_B.t204 DVSS_B.t70 37.3646039190236
Riso11756 DVSS_B.t204 DVSS_B.t72 73.3838775697343
Riso11757 DVSS_B.t204 DVSS_B.t74 4079.27892648699
Riso11758 DVSS_B.t204 DVSS_B.t76 868.557821068668
Riso11759 DVSS_B.t204 DVSS_B.t80 826.213964054565
Riso11760 DVSS_B.t204 DVSS_B.t82 612.731860276877
Riso11761 DVSS_B.t204 DVSS_B.t84 3331.76901849228
Riso11762 DVSS_B.t204 DVSS_B.t89 4738.68196417508
Riso11763 DVSS_B.t204 DVSS_B.t90 48.5258328959326
Riso11764 DVSS_B.t204 DVSS_B.t94 44.3292819159557
Riso11765 DVSS_B.t204 DVSS_B.t96 56.3160214267571
Riso11766 DVSS_B.t204 VSS_A 2785.67582856353
Riso11767 DVSS_B.t204 VSS_B 373.117935885685
Riso11768 DVSS_B.t205 DVSS_B.t239 66.3487
Riso11769 DVSS_B.t205 DVSS_B.t278 66.3487
Riso11770 DVSS_B.t206 DVSS_B.t21 1963.77827422438
Riso11771 DVSS_B.t206 DVSS_B.t212 47.2328783777763
Riso11772 DVSS_B.t206 DVSS_B.t214 103.455109941924
Riso11773 DVSS_B.t206 DVSS_B.t215 172584.231989164
Riso11774 DVSS_B.t206 DVSS_B.t216 2313.92458841985
Riso11775 DVSS_B.t206 DVSS_B.t218 132.741397694769
Riso11776 DVSS_B.t206 DVSS_B.t225 158.751118895686
Riso11777 DVSS_B.t206 DVSS_B.t236 47.2328783777763
Riso11778 DVSS_B.t206 DVSS_B.t238 659.809944290633
Riso11779 DVSS_B.t206 DVSS_B.t240 40.2423027109723
Riso11780 DVSS_B.t206 DVSS_B.t250 173.715177751818
Riso11781 DVSS_B.t206 DVSS_B.t252 595.459595398748
Riso11782 DVSS_B.t206 DVSS_B.t256 270.089197572388
Riso11783 DVSS_B.t206 DVSS_B.t258 47.4981958486241
Riso11784 DVSS_B.t206 DVSS_B.t259 12305.1715296435
Riso11785 DVSS_B.t206 DVSS_B.t260 64.0976883711976
Riso11786 DVSS_B.t206 DVSS_B.t264 131.492176180475
Riso11787 DVSS_B.t206 DVSS_B.t266 158.751118895686
Riso11788 DVSS_B.t206 DVSS_B.t267 90314.0663627717
Riso11789 DVSS_B.t206 DVSS_B.t268 690.627690878538
Riso11790 DVSS_B.t206 DVSS_B.t271 680.365763172506
Riso11791 DVSS_B.t206 DVSS_B.t273 152.362531404108
Riso11792 DVSS_B.t206 DVSS_B.t275 470.094852276946
Riso11793 DVSS_B.t206 DVSS_B.t277 63.121539742705
Riso11794 DVSS_B.t206 DVSS_B.t279 0.0669631241162035
Riso11795 DVSS_B.t206 DVSS_B.t281 170.426344560564
Riso11796 DVSS_B.t206 DVSS_B.t283 426.951441478237
Riso11797 DVSS_B.t206 DVSS_B.t285 114.937243831437
Riso11798 DVSS_B.t206 DVSS_B.t287 132.741397694769
Riso11799 DVSS_B.t206 DVSS_B.t288 38487.7136174266
Riso11800 DVSS_B.t206 DVSS_B.t289 293.661858064571
Riso11801 DVSS_B.t206 DVSS_B.t291 179.768104098423
Riso11802 DVSS_B.t206 DVSS_B.t293 555.724566746506
Riso11803 DVSS_B.t206 DVSS_B.t295 55.4607577805091
Riso11804 DVSS_B.t206 DVSS_B.t297 245.430468611619
Riso11805 DVSS_B.t206 DVSS_B.t299 513.427141558949
Riso11806 DVSS_B.t206 DVSS_B.t301 187.489631184087
Riso11807 DVSS_B.t206 DVSS_B.t302 24402.562176266
Riso11808 DVSS_B.t206 DVSS_B.t303 187.489631184087
Riso11809 DVSS_B.t206 DVSS_B.t305 270.089197572388
Riso11810 DVSS_B.t206 DVSS_B.t322 3077.28539325724
Riso11811 DVSS_B.t206 DVSS_B.t325 10294.4503625885
Riso11812 DVSS_B.t206 DVSS_B.t326 71.5543709276809
Riso11813 DVSS_B.t206 DVSS_B.t329 635.017204831869
Riso11814 DVSS_B.t206 DVSS_B.t331 1226.54467158065
Riso11815 DVSS_B.t206 DVSS_B.t333 1166.67508274692
Riso11816 DVSS_B.t206 DVSS_B.t335 620.89887488105
Riso11817 DVSS_B.t206 DVSS_B.t337 560.846374407703
Riso11818 DVSS_B.t206 DVSS_B.t339 1226.54467158065
Riso11819 DVSS_B.t206 DVSS_B.t341 1166.67508274692
Riso11820 DVSS_B.t206 DVSS_B.t343 498.627975749426
Riso11821 DVSS_B.t206 DVSS_B.t345 242344.249646951
Riso11822 DVSS_B.t206 DVSS_B.t346 876.316776312441
Riso11823 DVSS_B.t206 DVSS_B.t348 152.362531404108
Riso11824 DVSS_B.t206 DVSS_B.t35 47.4981958486241
Riso11825 DVSS_B.t206 DVSS_B.t350 680.365763172506
Riso11826 DVSS_B.t206 DVSS_B.t352 690.627690878538
Riso11827 DVSS_B.t206 DVSS_B.t355 793893.647711296
Riso11828 DVSS_B.t206 DVSS_B.t356 1301.64033941102
Riso11829 DVSS_B.t206 DVSS_B.t358 131.492176180475
Riso11830 DVSS_B.t206 DVSS_B.t36 126324.967122298
Riso11831 DVSS_B.t206 DVSS_B.t360 54.9159904850838
Riso11832 DVSS_B.t206 DVSS_B.t364 170.426344560564
Riso11833 DVSS_B.t206 DVSS_B.t366 186.051842169747
Riso11834 DVSS_B.t206 DVSS_B.t37 1963.77827422438
Riso11835 DVSS_B.t206 DVSS_B.t509 186.051842169747
Riso11836 DVSS_B.t206 DVSS_B.t515 196.603341877455
Riso11837 DVSS_B.t206 DVSS_B.t525 2525.42304704974
Riso11838 DVSS_B.t206 DVSS_B.t529 40.337814292832
Riso11839 DVSS_B.t206 DVSS_B.t531 196.603341877455
Riso11840 DVSS_B.t206 DVSS_B.t59 12305.1715296435
Riso11841 DVSS_B.t206 DVSS_B.t60 98.9549925743394
Riso11842 DVSS_B.t206 DVSS_B.t66 220.684588107135
Riso11843 DVSS_B.t206 DVSS_B.t68 513.427141558949
Riso11844 DVSS_B.t206 DVSS_B.t70 63.121539742705
Riso11845 DVSS_B.t206 DVSS_B.t72 145.524585147351
Riso11846 DVSS_B.t206 DVSS_B.t74 3077.28539325724
Riso11847 DVSS_B.t206 DVSS_B.t76 630.823983892936
Riso11848 DVSS_B.t206 DVSS_B.t80 595.459595398748
Riso11849 DVSS_B.t206 DVSS_B.t82 426.951441478237
Riso11850 DVSS_B.t206 DVSS_B.t84 2525.42304704974
Riso11851 DVSS_B.t206 DVSS_B.t89 10294.4503625885
Riso11852 DVSS_B.t206 DVSS_B.t90 103.455109941924
Riso11853 DVSS_B.t206 DVSS_B.t94 54.9159904850838
Riso11854 DVSS_B.t206 DVSS_B.t96 117.298463198008
Riso11855 DVSS_B.t206 VSS_A 2166.67139250205
Riso11856 DVSS_B.t206 VSS_B 293.703719473628
Riso11857 DVSS_B.t21 DVSS_B.t212 2270.06096723262
Riso11858 DVSS_B.t21 DVSS_B.t214 2970.60638495689
Riso11859 DVSS_B.t21 DVSS_B.t215 1849.74008675692
Riso11860 DVSS_B.t21 DVSS_B.t216 24.5195627375037
Riso11861 DVSS_B.t21 DVSS_B.t218 1069.28575457998
Riso11862 DVSS_B.t21 DVSS_B.t225 3517.84507675175
Riso11863 DVSS_B.t21 DVSS_B.t236 2270.06096723262
Riso11864 DVSS_B.t21 DVSS_B.t238 259.647724191737
Riso11865 DVSS_B.t21 DVSS_B.t240 2121.38144986007
Riso11866 DVSS_B.t21 DVSS_B.t250 960.35609311862
Riso11867 DVSS_B.t21 DVSS_B.t252 320.747134139474
Riso11868 DVSS_B.t21 DVSS_B.t256 692.133423369118
Riso11869 DVSS_B.t21 DVSS_B.t258 1641.69978473303
Riso11870 DVSS_B.t21 DVSS_B.t259 60408.8262950235
Riso11871 DVSS_B.t21 DVSS_B.t260 1334.25846881591
Riso11872 DVSS_B.t21 DVSS_B.t264 3312.2307745694
Riso11873 DVSS_B.t21 DVSS_B.t266 3517.84507675175
Riso11874 DVSS_B.t21 DVSS_B.t267 23006.2204247602
Riso11875 DVSS_B.t21 DVSS_B.t268 206.908701947177
Riso11876 DVSS_B.t21 DVSS_B.t271 232.204689527914
Riso11877 DVSS_B.t21 DVSS_B.t273 1019.39484448801
Riso11878 DVSS_B.t21 DVSS_B.t275 423.743903210092
Riso11879 DVSS_B.t21 DVSS_B.t277 2515.83137630572
Riso11880 DVSS_B.t21 DVSS_B.t279 1963.77827422438
Riso11881 DVSS_B.t21 DVSS_B.t281 3552.56647874686
Riso11882 DVSS_B.t21 DVSS_B.t283 458.545066819516
Riso11883 DVSS_B.t21 DVSS_B.t285 1106.39558484302
Riso11884 DVSS_B.t21 DVSS_B.t287 1069.28575457998
Riso11885 DVSS_B.t21 DVSS_B.t288 62918.0646509061
Riso11886 DVSS_B.t21 DVSS_B.t289 627.21801896889
Riso11887 DVSS_B.t21 DVSS_B.t291 3536.39034334166
Riso11888 DVSS_B.t21 DVSS_B.t293 354.017985522937
Riso11889 DVSS_B.t21 DVSS_B.t295 1484.80768019199
Riso11890 DVSS_B.t21 DVSS_B.t297 759.402039509168
Riso11891 DVSS_B.t21 DVSS_B.t299 388.576423607267
Riso11892 DVSS_B.t21 DVSS_B.t301 3190.8616407285
Riso11893 DVSS_B.t21 DVSS_B.t302 372385.581077599
Riso11894 DVSS_B.t21 DVSS_B.t303 3190.8616407285
Riso11895 DVSS_B.t21 DVSS_B.t305 692.133423369118
Riso11896 DVSS_B.t21 DVSS_B.t322 1200.34188810837
Riso11897 DVSS_B.t21 DVSS_B.t325 303700.365180286
Riso11898 DVSS_B.t21 DVSS_B.t326 2599.54510433101
Riso11899 DVSS_B.t21 DVSS_B.t329 169.73570666981
Riso11900 DVSS_B.t21 DVSS_B.t331 294.9253215709
Riso11901 DVSS_B.t21 DVSS_B.t333 239.417655627765
Riso11902 DVSS_B.t21 DVSS_B.t335 139.780889018338
Riso11903 DVSS_B.t21 DVSS_B.t337 141.016603597504
Riso11904 DVSS_B.t21 DVSS_B.t339 294.9253215709
Riso11905 DVSS_B.t21 DVSS_B.t341 239.417655627765
Riso11906 DVSS_B.t21 DVSS_B.t343 105.520772747074
Riso11907 DVSS_B.t21 DVSS_B.t345 156246.281601183
Riso11908 DVSS_B.t21 DVSS_B.t346 609.912201082061
Riso11909 DVSS_B.t21 DVSS_B.t348 1019.39484448801
Riso11910 DVSS_B.t21 DVSS_B.t35 1641.69978473303
Riso11911 DVSS_B.t21 DVSS_B.t350 232.204689527914
Riso11912 DVSS_B.t21 DVSS_B.t352 206.908701947177
Riso11913 DVSS_B.t21 DVSS_B.t355 467153.605348124
Riso11914 DVSS_B.t21 DVSS_B.t356 641.600097861451
Riso11915 DVSS_B.t21 DVSS_B.t358 3312.2307745694
Riso11916 DVSS_B.t21 DVSS_B.t36 1365.86422144868
Riso11917 DVSS_B.t21 DVSS_B.t360 2403.7564237484
Riso11918 DVSS_B.t21 DVSS_B.t364 3552.56647874686
Riso11919 DVSS_B.t21 DVSS_B.t366 3468.61426668308
Riso11920 DVSS_B.t21 DVSS_B.t37 0.7285061716083
Riso11921 DVSS_B.t21 DVSS_B.t509 3468.61426668308
Riso11922 DVSS_B.t21 DVSS_B.t515 895.52864188739
Riso11923 DVSS_B.t21 DVSS_B.t525 1064.91919263715
Riso11924 DVSS_B.t21 DVSS_B.t529 1802.46419310098
Riso11925 DVSS_B.t21 DVSS_B.t531 895.52864188739
Riso11926 DVSS_B.t21 DVSS_B.t59 60408.8262950235
Riso11927 DVSS_B.t21 DVSS_B.t60 1127.19949677682
Riso11928 DVSS_B.t21 DVSS_B.t66 827.77919494209
Riso11929 DVSS_B.t21 DVSS_B.t68 388.576423607267
Riso11930 DVSS_B.t21 DVSS_B.t70 2515.83137630572
Riso11931 DVSS_B.t21 DVSS_B.t72 3435.7886399363
Riso11932 DVSS_B.t21 DVSS_B.t74 1200.34188810837
Riso11933 DVSS_B.t21 DVSS_B.t76 289.204087648065
Riso11934 DVSS_B.t21 DVSS_B.t80 320.747134139474
Riso11935 DVSS_B.t21 DVSS_B.t82 458.545066819516
Riso11936 DVSS_B.t21 DVSS_B.t84 1064.91919263715
Riso11937 DVSS_B.t21 DVSS_B.t89 303700.365180286
Riso11938 DVSS_B.t21 DVSS_B.t90 2970.60638495689
Riso11939 DVSS_B.t21 DVSS_B.t94 2403.7564237484
Riso11940 DVSS_B.t21 DVSS_B.t96 3154.49876083327
Riso11941 DVSS_B.t21 VSS_A 597.669941163351
Riso11942 DVSS_B.t21 VSS_B 72.1237042772921
Riso11943 DVSS_B.t211 DVSS_B.t235 66.3487
Riso11944 DVSS_B.t212 DVSS_B.t214 77.9234896871547
Riso11945 DVSS_B.t212 DVSS_B.t215 199473.496951341
Riso11946 DVSS_B.t212 DVSS_B.t216 2674.78097178792
Riso11947 DVSS_B.t212 DVSS_B.t218 169.01180822186
Riso11948 DVSS_B.t212 DVSS_B.t225 124.559161219804
Riso11949 DVSS_B.t212 DVSS_B.t236 0.0669613762348249
Riso11950 DVSS_B.t212 DVSS_B.t238 770.790757756116
Riso11951 DVSS_B.t212 DVSS_B.t240 39.9338310088635
Riso11952 DVSS_B.t212 DVSS_B.t250 217.967918143908
Riso11953 DVSS_B.t212 DVSS_B.t252 699.749955373392
Riso11954 DVSS_B.t212 DVSS_B.t256 329.831116315631
Riso11955 DVSS_B.t212 DVSS_B.t258 64.7122241211656
Riso11956 DVSS_B.t212 DVSS_B.t259 14108.9201766695
Riso11957 DVSS_B.t212 DVSS_B.t260 85.4045105546178
Riso11958 DVSS_B.t212 DVSS_B.t264 101.047933157361
Riso11959 DVSS_B.t212 DVSS_B.t266 124.559161219804
Riso11960 DVSS_B.t212 DVSS_B.t267 104400.801012502
Riso11961 DVSS_B.t212 DVSS_B.t268 802.746340396736
Riso11962 DVSS_B.t212 DVSS_B.t271 792.71123251731
Riso11963 DVSS_B.t212 DVSS_B.t273 192.571528843419
Riso11964 DVSS_B.t212 DVSS_B.t275 558.140652804569
Riso11965 DVSS_B.t212 DVSS_B.t277 45.700815089765
Riso11966 DVSS_B.t212 DVSS_B.t279 47.2328783777763
Riso11967 DVSS_B.t212 DVSS_B.t281 135.094910480707
Riso11968 DVSS_B.t212 DVSS_B.t283 508.82956523527
Riso11969 DVSS_B.t212 DVSS_B.t285 147.428864999296
Riso11970 DVSS_B.t212 DVSS_B.t287 169.01180822186
Riso11971 DVSS_B.t212 DVSS_B.t288 46170.475915438
Riso11972 DVSS_B.t212 DVSS_B.t289 356.485532304664
Riso11973 DVSS_B.t212 DVSS_B.t291 143.90454214285
Riso11974 DVSS_B.t212 DVSS_B.t293 655.183721093454
Riso11975 DVSS_B.t212 DVSS_B.t295 74.7572036679649
Riso11976 DVSS_B.t212 DVSS_B.t297 301.629264721787
Riso11977 DVSS_B.t212 DVSS_B.t299 607.39700190446
Riso11978 DVSS_B.t212 DVSS_B.t301 153.786829898628
Riso11979 DVSS_B.t212 DVSS_B.t302 20362.0256261366
Riso11980 DVSS_B.t212 DVSS_B.t303 153.786829898628
Riso11981 DVSS_B.t212 DVSS_B.t305 329.831116315631
Riso11982 DVSS_B.t212 DVSS_B.t322 3553.67173534402
Riso11983 DVSS_B.t212 DVSS_B.t325 7695.39710611325
Riso11984 DVSS_B.t212 DVSS_B.t326 52.3201427373384
Riso11985 DVSS_B.t212 DVSS_B.t329 725.826774281133
Riso11986 DVSS_B.t212 DVSS_B.t331 1403.73641123665
Riso11987 DVSS_B.t212 DVSS_B.t333 1336.65155367204
Riso11988 DVSS_B.t212 DVSS_B.t335 710.499128937085
Riso11989 DVSS_B.t212 DVSS_B.t337 641.599023178827
Riso11990 DVSS_B.t212 DVSS_B.t339 1403.73641123665
Riso11991 DVSS_B.t212 DVSS_B.t341 1336.65155367204
Riso11992 DVSS_B.t212 DVSS_B.t343 571.268811926643
Riso11993 DVSS_B.t212 DVSS_B.t345 276588.929005051
Riso11994 DVSS_B.t212 DVSS_B.t346 999.397407999825
Riso11995 DVSS_B.t212 DVSS_B.t348 192.571528843419
Riso11996 DVSS_B.t212 DVSS_B.t35 64.7122241211656
Riso11997 DVSS_B.t212 DVSS_B.t350 792.71123251731
Riso11998 DVSS_B.t212 DVSS_B.t352 802.746340396736
Riso11999 DVSS_B.t212 DVSS_B.t355 907168.010149936
Riso12000 DVSS_B.t212 DVSS_B.t356 1493.73757154513
Riso12001 DVSS_B.t212 DVSS_B.t358 101.047933157361
Riso12002 DVSS_B.t212 DVSS_B.t36 146011.861354288
Riso12003 DVSS_B.t212 DVSS_B.t360 39.3851640073845
Riso12004 DVSS_B.t212 DVSS_B.t364 135.094910480707
Riso12005 DVSS_B.t212 DVSS_B.t366 150.299905664749
Riso12006 DVSS_B.t212 DVSS_B.t37 2270.06096723262
Riso12007 DVSS_B.t212 DVSS_B.t509 150.299905664749
Riso12008 DVSS_B.t212 DVSS_B.t515 244.933396986607
Riso12009 DVSS_B.t212 DVSS_B.t525 2909.79337294189
Riso12010 DVSS_B.t212 DVSS_B.t529 55.5007434259351
Riso12011 DVSS_B.t212 DVSS_B.t531 244.933396986607
Riso12012 DVSS_B.t212 DVSS_B.t59 14108.9201766695
Riso12013 DVSS_B.t212 DVSS_B.t60 127.867970069098
Riso12014 DVSS_B.t212 DVSS_B.t66 273.034318536977
Riso12015 DVSS_B.t212 DVSS_B.t68 607.39700190446
Riso12016 DVSS_B.t212 DVSS_B.t70 45.700815089765
Riso12017 DVSS_B.t212 DVSS_B.t72 112.998715877139
Riso12018 DVSS_B.t212 DVSS_B.t74 3553.67173534402
Riso12019 DVSS_B.t212 DVSS_B.t76 739.040062311947
Riso12020 DVSS_B.t212 DVSS_B.t80 699.749955373392
Riso12021 DVSS_B.t212 DVSS_B.t82 508.82956523527
Riso12022 DVSS_B.t212 DVSS_B.t84 2909.79337294189
Riso12023 DVSS_B.t212 DVSS_B.t89 7695.39710611325
Riso12024 DVSS_B.t212 DVSS_B.t90 77.9234896871547
Riso12025 DVSS_B.t212 DVSS_B.t94 39.3851640073845
Riso12026 DVSS_B.t212 DVSS_B.t96 89.2266897151904
Riso12027 DVSS_B.t212 VSS_A 2475.47400537645
Riso12028 DVSS_B.t212 VSS_B 335.248023435087
Riso12029 DVSS_B.t213 DVSS_B.t89 66.3487
Riso12030 DVSS_B.t213 DVSS_B.t95 66.3487
Riso12031 DVSS_B.t214 DVSS_B.t215 260970.965447925
Riso12032 DVSS_B.t214 DVSS_B.t216 3500.13836749136
Riso12033 DVSS_B.t214 DVSS_B.t218 282.849813709337
Riso12034 DVSS_B.t214 DVSS_B.t225 54.7087004546916
Riso12035 DVSS_B.t214 DVSS_B.t236 77.9234896871547
Riso12036 DVSS_B.t214 DVSS_B.t238 1047.88026180653
Riso12037 DVSS_B.t214 DVSS_B.t240 90.1243198683169
Riso12038 DVSS_B.t214 DVSS_B.t250 352.291731781694
Riso12039 DVSS_B.t214 DVSS_B.t252 966.987108626961
Riso12040 DVSS_B.t214 DVSS_B.t256 499.929882371037
Riso12041 DVSS_B.t214 DVSS_B.t258 132.676898823758
Riso12042 DVSS_B.t214 DVSS_B.t259 17055.7207303611
Riso12043 DVSS_B.t214 DVSS_B.t260 162.399697753047
Riso12044 DVSS_B.t214 DVSS_B.t264 41.876057778947
Riso12045 DVSS_B.t214 DVSS_B.t266 54.7087004546916
Riso12046 DVSS_B.t214 DVSS_B.t267 137218.323477462
Riso12047 DVSS_B.t214 DVSS_B.t268 1074.85151390555
Riso12048 DVSS_B.t214 DVSS_B.t271 1069.31055322979
Riso12049 DVSS_B.t214 DVSS_B.t273 316.659018362866
Riso12050 DVSS_B.t214 DVSS_B.t275 791.360055108464
Riso12051 DVSS_B.t214 DVSS_B.t277 57.1423886815744
Riso12052 DVSS_B.t214 DVSS_B.t279 103.455109941924
Riso12053 DVSS_B.t214 DVSS_B.t281 61.1176455433427
Riso12054 DVSS_B.t214 DVSS_B.t283 727.840655660984
Riso12055 DVSS_B.t214 DVSS_B.t285 251.176031268153
Riso12056 DVSS_B.t214 DVSS_B.t287 282.849813709337
Riso12057 DVSS_B.t214 DVSS_B.t288 66843.7815089632
Riso12058 DVSS_B.t214 DVSS_B.t289 532.56913051225
Riso12059 DVSS_B.t214 DVSS_B.t291 67.0134771184729
Riso12060 DVSS_B.t214 DVSS_B.t293 913.066104973993
Riso12061 DVSS_B.t214 DVSS_B.t295 147.785663010534
Riso12062 DVSS_B.t214 DVSS_B.t297 464.185794824784
Riso12063 DVSS_B.t214 DVSS_B.t299 853.747951435537
Riso12064 DVSS_B.t214 DVSS_B.t301 77.0720256126252
Riso12065 DVSS_B.t214 DVSS_B.t302 10744.50541548
Riso12066 DVSS_B.t214 DVSS_B.t303 77.0720256126252
Riso12067 DVSS_B.t214 DVSS_B.t305 499.929882371037
Riso12068 DVSS_B.t214 DVSS_B.t322 4663.09862657295
Riso12069 DVSS_B.t214 DVSS_B.t325 4666.6047454208
Riso12070 DVSS_B.t214 DVSS_B.t326 48.5258328959326
Riso12071 DVSS_B.t214 DVSS_B.t329 921.490871494623
Riso12072 DVSS_B.t214 DVSS_B.t331 1785.19581796598
Riso12073 DVSS_B.t214 DVSS_B.t333 1699.15905109992
Riso12074 DVSS_B.t214 DVSS_B.t335 901.261525658017
Riso12075 DVSS_B.t214 DVSS_B.t337 818.872200183999
Riso12076 DVSS_B.t214 DVSS_B.t339 1785.19581796598
Riso12077 DVSS_B.t214 DVSS_B.t341 1699.15905109992
Riso12078 DVSS_B.t214 DVSS_B.t343 730.668823794262
Riso12079 DVSS_B.t214 DVSS_B.t345 355096.620855778
Riso12080 DVSS_B.t214 DVSS_B.t346 1281.3217844149
Riso12081 DVSS_B.t214 DVSS_B.t348 316.659018362866
Riso12082 DVSS_B.t214 DVSS_B.t35 132.676898823758
Riso12083 DVSS_B.t214 DVSS_B.t350 1069.31055322979
Riso12084 DVSS_B.t214 DVSS_B.t352 1074.85151390555
Riso12085 DVSS_B.t214 DVSS_B.t355 1167228.71388788
Riso12086 DVSS_B.t214 DVSS_B.t356 1937.1746499499
Riso12087 DVSS_B.t214 DVSS_B.t358 41.876057778947
Riso12088 DVSS_B.t214 DVSS_B.t36 190967.49721738
Riso12089 DVSS_B.t214 DVSS_B.t360 66.9277539587393
Riso12090 DVSS_B.t214 DVSS_B.t364 61.1176455433427
Riso12091 DVSS_B.t214 DVSS_B.t366 71.930841701856
Riso12092 DVSS_B.t214 DVSS_B.t37 2970.60638495689
Riso12093 DVSS_B.t214 DVSS_B.t509 71.930841701856
Riso12094 DVSS_B.t214 DVSS_B.t515 389.265181236999
Riso12095 DVSS_B.t214 DVSS_B.t525 3801.99609325663
Riso12096 DVSS_B.t214 DVSS_B.t529 117.741717576346
Riso12097 DVSS_B.t214 DVSS_B.t531 389.265181236999
Riso12098 DVSS_B.t214 DVSS_B.t59 17055.7207303611
Riso12099 DVSS_B.t214 DVSS_B.t60 221.81785222355
Riso12100 DVSS_B.t214 DVSS_B.t66 426.881819674908
Riso12101 DVSS_B.t214 DVSS_B.t68 853.747951435537
Riso12102 DVSS_B.t214 DVSS_B.t70 57.1423886815744
Riso12103 DVSS_B.t214 DVSS_B.t72 48.1911828276996
Riso12104 DVSS_B.t214 DVSS_B.t74 4663.09862657295
Riso12105 DVSS_B.t214 DVSS_B.t76 1012.86316632585
Riso12106 DVSS_B.t214 DVSS_B.t80 966.987108626961
Riso12107 DVSS_B.t214 DVSS_B.t82 727.840655660984
Riso12108 DVSS_B.t214 DVSS_B.t84 3801.99609325663
Riso12109 DVSS_B.t214 DVSS_B.t89 4666.6047454208
Riso12110 DVSS_B.t214 DVSS_B.t90 0.0669484573630588
Riso12111 DVSS_B.t214 DVSS_B.t94 66.9277539587393
Riso12112 DVSS_B.t214 DVSS_B.t96 35.9750167198669
Riso12113 DVSS_B.t214 VSS_A 3135.36726769897
Riso12114 DVSS_B.t214 VSS_B 415.614138800484
Riso12115 DVSS_B.t215 DVSS_B.t216 1193.65345507479
Riso12116 DVSS_B.t215 DVSS_B.t218 93991.6011429424
Riso12117 DVSS_B.t215 DVSS_B.t225 309003.581823049
Riso12118 DVSS_B.t215 DVSS_B.t236 199473.496951341
Riso12119 DVSS_B.t215 DVSS_B.t238 22781.7824910632
Riso12120 DVSS_B.t215 DVSS_B.t240 186421.110881427
Riso12121 DVSS_B.t215 DVSS_B.t250 84410.5546553117
Riso12122 DVSS_B.t215 DVSS_B.t252 28160.0167209367
Riso12123 DVSS_B.t215 DVSS_B.t256 60830.3955142515
Riso12124 DVSS_B.t215 DVSS_B.t258 144302.503409491
Riso12125 DVSS_B.t215 DVSS_B.t259 5317411.98324079
Riso12126 DVSS_B.t215 DVSS_B.t260 117298.867272222
Riso12127 DVSS_B.t215 DVSS_B.t264 290955.975929473
Riso12128 DVSS_B.t215 DVSS_B.t266 309003.581823049
Riso12129 DVSS_B.t215 DVSS_B.t267 2017121.05658796
Riso12130 DVSS_B.t215 DVSS_B.t268 18139.9221284919
Riso12131 DVSS_B.t215 DVSS_B.t271 20366.2564823647
Riso12132 DVSS_B.t215 DVSS_B.t273 89602.440420155
Riso12133 DVSS_B.t215 DVSS_B.t275 37225.5559804971
Riso12134 DVSS_B.t215 DVSS_B.t277 221048.167412563
Riso12135 DVSS_B.t215 DVSS_B.t279 172584.231989164
Riso12136 DVSS_B.t215 DVSS_B.t281 312052.952243949
Riso12137 DVSS_B.t215 DVSS_B.t283 40288.2411169231
Riso12138 DVSS_B.t215 DVSS_B.t285 97258.9432227065
Riso12139 DVSS_B.t215 DVSS_B.t287 93991.6011429424
Riso12140 DVSS_B.t215 DVSS_B.t288 5529861.40027241
Riso12141 DVSS_B.t215 DVSS_B.t289 55123.5723632429
Riso12142 DVSS_B.t215 DVSS_B.t291 310636.028204317
Riso12143 DVSS_B.t215 DVSS_B.t293 31088.6064472304
Riso12144 DVSS_B.t215 DVSS_B.t295 130523.099666635
Riso12145 DVSS_B.t215 DVSS_B.t297 66743.8987490535
Riso12146 DVSS_B.t215 DVSS_B.t299 34130.3836964753
Riso12147 DVSS_B.t215 DVSS_B.t301 280315.825321491
Riso12148 DVSS_B.t215 DVSS_B.t302 32720756.3787064
Riso12149 DVSS_B.t215 DVSS_B.t303 280315.825321491
Riso12150 DVSS_B.t215 DVSS_B.t305 60830.3955142515
Riso12151 DVSS_B.t215 DVSS_B.t321 356.886
Riso12152 DVSS_B.t215 DVSS_B.t322 94796.4676199515
Riso12153 DVSS_B.t215 DVSS_B.t325 26686298.2911839
Riso12154 DVSS_B.t215 DVSS_B.t326 228397.092667708
Riso12155 DVSS_B.t215 DVSS_B.t329 14860.418060744
Riso12156 DVSS_B.t215 DVSS_B.t331 25863.8262185714
Riso12157 DVSS_B.t215 DVSS_B.t333 21072.2431704822
Riso12158 DVSS_B.t215 DVSS_B.t335 12288.2165626864
Riso12159 DVSS_B.t215 DVSS_B.t337 12349.730636394
Riso12160 DVSS_B.t215 DVSS_B.t339 25863.8262185714
Riso12161 DVSS_B.t215 DVSS_B.t341 21072.2431704822
Riso12162 DVSS_B.t215 DVSS_B.t343 9273.59352143077
Riso12163 DVSS_B.t215 DVSS_B.t345 8226689.39927381
Riso12164 DVSS_B.t215 DVSS_B.t346 36902.4195125134
Riso12165 DVSS_B.t215 DVSS_B.t348 89602.440420155
Riso12166 DVSS_B.t215 DVSS_B.t35 144302.503409491
Riso12167 DVSS_B.t215 DVSS_B.t350 20366.2564823647
Riso12168 DVSS_B.t215 DVSS_B.t352 18139.9221284919
Riso12169 DVSS_B.t215 DVSS_B.t355 22881895.1664086
Riso12170 DVSS_B.t215 DVSS_B.t356 41555.9290545273
Riso12171 DVSS_B.t215 DVSS_B.t358 290955.975929473
Riso12172 DVSS_B.t215 DVSS_B.t36 89702.2562938143
Riso12173 DVSS_B.t215 DVSS_B.t360 211209.867705168
Riso12174 DVSS_B.t215 DVSS_B.t364 312052.952243949
Riso12175 DVSS_B.t215 DVSS_B.t366 304690.572670685
Riso12176 DVSS_B.t215 DVSS_B.t37 1849.74008675692
Riso12177 DVSS_B.t215 DVSS_B.t509 304690.572670685
Riso12178 DVSS_B.t215 DVSS_B.t515 78710.8236224348
Riso12179 DVSS_B.t215 DVSS_B.t525 78789.8900828376
Riso12180 DVSS_B.t215 DVSS_B.t529 158420.093222739
Riso12181 DVSS_B.t215 DVSS_B.t531 78710.8236224348
Riso12182 DVSS_B.t215 DVSS_B.t59 5317411.98324079
Riso12183 DVSS_B.t215 DVSS_B.t60 99094.6522705427
Riso12184 DVSS_B.t215 DVSS_B.t66 72754.8298298054
Riso12185 DVSS_B.t215 DVSS_B.t68 34130.3836964753
Riso12186 DVSS_B.t215 DVSS_B.t70 221048.167412563
Riso12187 DVSS_B.t215 DVSS_B.t72 301800.699963798
Riso12188 DVSS_B.t215 DVSS_B.t74 94796.4676199515
Riso12189 DVSS_B.t215 DVSS_B.t76 25383.4488256153
Riso12190 DVSS_B.t215 DVSS_B.t80 28160.0167209367
Riso12191 DVSS_B.t215 DVSS_B.t82 40288.2411169231
Riso12192 DVSS_B.t215 DVSS_B.t84 78789.8900828376
Riso12193 DVSS_B.t215 DVSS_B.t89 26686298.2911839
Riso12194 DVSS_B.t215 DVSS_B.t90 260970.965447925
Riso12195 DVSS_B.t215 DVSS_B.t94 211209.867705168
Riso12196 DVSS_B.t215 DVSS_B.t96 277111.868518398
Riso12197 DVSS_B.t215 VSS_A 52315.7267315446
Riso12198 DVSS_B.t215 VSS_B 6359.48310586661
Riso12199 DVSS_B.t216 DVSS_B.t218 1259.97226690772
Riso12200 DVSS_B.t216 DVSS_B.t225 4144.86599049757
Riso12201 DVSS_B.t216 DVSS_B.t236 2674.78097178792
Riso12202 DVSS_B.t216 DVSS_B.t238 305.899848295005
Riso12203 DVSS_B.t216 DVSS_B.t240 2499.61044774272
Riso12204 DVSS_B.t216 DVSS_B.t250 1131.61180128419
Riso12205 DVSS_B.t216 DVSS_B.t252 377.905408751209
Riso12206 DVSS_B.t216 DVSS_B.t256 815.55433493059
Riso12207 DVSS_B.t216 DVSS_B.t258 1934.44962983755
Riso12208 DVSS_B.t216 DVSS_B.t259 71189.8857666033
Riso12209 DVSS_B.t216 DVSS_B.t260 1572.21050854826
Riso12210 DVSS_B.t216 DVSS_B.t264 3902.62273900003
Riso12211 DVSS_B.t216 DVSS_B.t266 4144.86599049757
Riso12212 DVSS_B.t216 DVSS_B.t267 27102.4989264301
Riso12213 DVSS_B.t216 DVSS_B.t268 243.747490641345
Riso12214 DVSS_B.t216 DVSS_B.t271 273.558402987551
Riso12215 DVSS_B.t216 DVSS_B.t273 1201.18090126108
Riso12216 DVSS_B.t216 DVSS_B.t275 499.285736972116
Riso12217 DVSS_B.t216 DVSS_B.t277 2964.33901136751
Riso12218 DVSS_B.t216 DVSS_B.t279 2313.92458841985
Riso12219 DVSS_B.t216 DVSS_B.t281 4185.77398365015
Riso12220 DVSS_B.t216 DVSS_B.t283 540.297757716894
Riso12221 DVSS_B.t216 DVSS_B.t285 1303.70511255102
Riso12222 DVSS_B.t216 DVSS_B.t287 1259.97226690772
Riso12223 DVSS_B.t216 DVSS_B.t288 74137.7196807307
Riso12224 DVSS_B.t216 DVSS_B.t289 739.061574108129
Riso12225 DVSS_B.t216 DVSS_B.t291 4166.71824272996
Riso12226 DVSS_B.t216 DVSS_B.t293 417.114931228516
Riso12227 DVSS_B.t216 DVSS_B.t295 1749.59464889799
Riso12228 DVSS_B.t216 DVSS_B.t297 894.81960891215
Riso12229 DVSS_B.t216 DVSS_B.t299 457.84162694637
Riso12230 DVSS_B.t216 DVSS_B.t301 3759.63852788941
Riso12231 DVSS_B.t216 DVSS_B.t302 438772.442517721
Riso12232 DVSS_B.t216 DVSS_B.t303 3759.63852788941
Riso12233 DVSS_B.t216 DVSS_B.t305 815.55433493059
Riso12234 DVSS_B.t216 DVSS_B.t322 1399.17721668151
Riso12235 DVSS_B.t216 DVSS_B.t325 357844.645595919
Riso12236 DVSS_B.t216 DVSS_B.t326 3062.96717577838
Riso12237 DVSS_B.t216 DVSS_B.t329 199.928236778347
Riso12238 DVSS_B.t216 DVSS_B.t331 347.442597128555
Riso12239 DVSS_B.t216 DVSS_B.t333 282.149290746011
Riso12240 DVSS_B.t216 DVSS_B.t335 164.710331421615
Riso12241 DVSS_B.t216 DVSS_B.t337 166.105709087362
Riso12242 DVSS_B.t216 DVSS_B.t339 347.442597128555
Riso12243 DVSS_B.t216 DVSS_B.t341 282.149290746011
Riso12244 DVSS_B.t216 DVSS_B.t343 124.336765763888
Riso12245 DVSS_B.t216 DVSS_B.t345 172957.749592578
Riso12246 DVSS_B.t216 DVSS_B.t346 688.647477431631
Riso12247 DVSS_B.t216 DVSS_B.t348 1201.18090126108
Riso12248 DVSS_B.t216 DVSS_B.t35 1934.44962983755
Riso12249 DVSS_B.t216 DVSS_B.t350 273.558402987551
Riso12250 DVSS_B.t216 DVSS_B.t352 243.747490641345
Riso12251 DVSS_B.t216 DVSS_B.t355 511329.938048711
Riso12252 DVSS_B.t216 DVSS_B.t356 730.879516389674
Riso12253 DVSS_B.t216 DVSS_B.t358 3902.62273900003
Riso12254 DVSS_B.t216 DVSS_B.t36 1525.45207938451
Riso12255 DVSS_B.t216 DVSS_B.t360 2832.29656107666
Riso12256 DVSS_B.t216 DVSS_B.t364 4185.77398365015
Riso12257 DVSS_B.t216 DVSS_B.t366 4086.87057991939
Riso12258 DVSS_B.t216 DVSS_B.t37 24.5195627375037
Riso12259 DVSS_B.t216 DVSS_B.t509 4086.87057991939
Riso12260 DVSS_B.t216 DVSS_B.t515 1055.22265795635
Riso12261 DVSS_B.t216 DVSS_B.t525 1232.5095552274
Riso12262 DVSS_B.t216 DVSS_B.t529 2123.86448774016
Riso12263 DVSS_B.t216 DVSS_B.t531 1055.22265795635
Riso12264 DVSS_B.t216 DVSS_B.t59 71189.8857666033
Riso12265 DVSS_B.t216 DVSS_B.t60 1328.22611317325
Riso12266 DVSS_B.t216 DVSS_B.t66 975.390915890718
Riso12267 DVSS_B.t216 DVSS_B.t68 457.84162694637
Riso12268 DVSS_B.t216 DVSS_B.t70 2964.33901136751
Riso12269 DVSS_B.t216 DVSS_B.t72 4048.19146128993
Riso12270 DVSS_B.t216 DVSS_B.t74 1399.17721668151
Riso12271 DVSS_B.t216 DVSS_B.t76 340.731975831849
Riso12272 DVSS_B.t216 DVSS_B.t80 377.905408751209
Riso12273 DVSS_B.t216 DVSS_B.t82 540.297757716894
Riso12274 DVSS_B.t216 DVSS_B.t84 1232.5095552274
Riso12275 DVSS_B.t216 DVSS_B.t89 357844.645595919
Riso12276 DVSS_B.t216 DVSS_B.t90 3500.13836749136
Riso12277 DVSS_B.t216 DVSS_B.t94 2832.29656107666
Riso12278 DVSS_B.t216 DVSS_B.t96 3716.7915678926
Riso12279 DVSS_B.t216 VSS_A 703.968886632642
Riso12280 DVSS_B.t216 VSS_B 85.0104598329013
Riso12281 DVSS_B.t217 DVSS_B.t286 66.3487
Riso12282 DVSS_B.t218 DVSS_B.t225 372.208667222645
Riso12283 DVSS_B.t218 DVSS_B.t236 169.01180822186
Riso12284 DVSS_B.t218 DVSS_B.t238 303.522917586147
Riso12285 DVSS_B.t218 DVSS_B.t240 150.515575426522
Riso12286 DVSS_B.t218 DVSS_B.t250 48.0502522241637
Riso12287 DVSS_B.t218 DVSS_B.t252 258.995941993776
Riso12288 DVSS_B.t218 DVSS_B.t256 87.6236246275127
Riso12289 DVSS_B.t218 DVSS_B.t258 100.688121339617
Riso12290 DVSS_B.t218 DVSS_B.t259 10400.459422215
Riso12291 DVSS_B.t218 DVSS_B.t260 74.2739785645732
Riso12292 DVSS_B.t218 DVSS_B.t264 332.6617452678
Riso12293 DVSS_B.t218 DVSS_B.t266 372.208667222645
Riso12294 DVSS_B.t218 DVSS_B.t267 46579.9448017665
Riso12295 DVSS_B.t218 DVSS_B.t268 334.420645368493
Riso12296 DVSS_B.t218 DVSS_B.t271 321.358416056588
Riso12297 DVSS_B.t218 DVSS_B.t273 40.5736441198819
Riso12298 DVSS_B.t218 DVSS_B.t275 187.160613669425
Riso12299 DVSS_B.t218 DVSS_B.t277 205.845575114945
Riso12300 DVSS_B.t218 DVSS_B.t279 132.741397694769
Riso12301 DVSS_B.t218 DVSS_B.t281 385.418442089825
Riso12302 DVSS_B.t218 DVSS_B.t283 164.943130981174
Riso12303 DVSS_B.t218 DVSS_B.t285 40.1585431710517
Riso12304 DVSS_B.t218 DVSS_B.t287 0.0669633383379671
Riso12305 DVSS_B.t218 DVSS_B.t288 14181.5819936387
Riso12306 DVSS_B.t218 DVSS_B.t289 99.136606089643
Riso12307 DVSS_B.t218 DVSS_B.t291 392.977710119948
Riso12308 DVSS_B.t218 DVSS_B.t293 234.788916088336
Riso12309 DVSS_B.t218 DVSS_B.t295 86.7502214305712
Riso12310 DVSS_B.t218 DVSS_B.t297 76.4772668349339
Riso12311 DVSS_B.t218 DVSS_B.t299 210.608303480258
Riso12312 DVSS_B.t218 DVSS_B.t301 377.306590246691
Riso12313 DVSS_B.t218 DVSS_B.t302 46308.9518006876
Riso12314 DVSS_B.t218 DVSS_B.t303 377.306590246691
Riso12315 DVSS_B.t218 DVSS_B.t305 87.6236246275127
Riso12316 DVSS_B.t218 DVSS_B.t322 1546.21827101092
Riso12317 DVSS_B.t218 DVSS_B.t325 28860.394216829
Riso12318 DVSS_B.t218 DVSS_B.t326 222.568773448401
Riso12319 DVSS_B.t218 DVSS_B.t329 368.441579884516
Riso12320 DVSS_B.t218 DVSS_B.t331 706.537390827892
Riso12321 DVSS_B.t218 DVSS_B.t333 673.720797197605
Riso12322 DVSS_B.t218 DVSS_B.t335 361.264492816181
Riso12323 DVSS_B.t218 DVSS_B.t337 320.756942452822
Riso12324 DVSS_B.t218 DVSS_B.t339 706.537390827892
Riso12325 DVSS_B.t218 DVSS_B.t341 673.720797197605
Riso12326 DVSS_B.t218 DVSS_B.t343 283.657168782409
Riso12327 DVSS_B.t218 DVSS_B.t345 134856.114742898
Riso12328 DVSS_B.t218 DVSS_B.t346 490.99314728297
Riso12329 DVSS_B.t218 DVSS_B.t348 40.5736441198819
Riso12330 DVSS_B.t218 DVSS_B.t35 100.688121339617
Riso12331 DVSS_B.t218 DVSS_B.t350 321.358416056588
Riso12332 DVSS_B.t218 DVSS_B.t352 334.420645368493
Riso12333 DVSS_B.t218 DVSS_B.t355 436956.347726649
Riso12334 DVSS_B.t218 DVSS_B.t356 689.653900104367
Riso12335 DVSS_B.t218 DVSS_B.t358 332.6617452678
Riso12336 DVSS_B.t218 DVSS_B.t36 68870.8886662303
Riso12337 DVSS_B.t218 DVSS_B.t360 187.694774537035
Riso12338 DVSS_B.t218 DVSS_B.t364 385.418442089825
Riso12339 DVSS_B.t218 DVSS_B.t366 394.245788265761
Riso12340 DVSS_B.t218 DVSS_B.t37 1069.28575457998
Riso12341 DVSS_B.t218 DVSS_B.t509 394.245788265761
Riso12342 DVSS_B.t218 DVSS_B.t515 56.5456454577286
Riso12343 DVSS_B.t218 DVSS_B.t525 1292.92884016145
Riso12344 DVSS_B.t218 DVSS_B.t529 116.056780885282
Riso12345 DVSS_B.t218 DVSS_B.t531 56.5456454577286
Riso12346 DVSS_B.t218 DVSS_B.t59 10400.459422215
Riso12347 DVSS_B.t218 DVSS_B.t60 46.8793194804254
Riso12348 DVSS_B.t218 DVSS_B.t66 66.0506712423182
Riso12349 DVSS_B.t218 DVSS_B.t68 210.608303480258
Riso12350 DVSS_B.t218 DVSS_B.t70 205.845575114945
Riso12351 DVSS_B.t218 DVSS_B.t72 354.265870681961
Riso12352 DVSS_B.t218 DVSS_B.t74 1546.21827101092
Riso12353 DVSS_B.t218 DVSS_B.t76 282.293306706015
Riso12354 DVSS_B.t218 DVSS_B.t80 258.995941993776
Riso12355 DVSS_B.t218 DVSS_B.t82 164.943130981174
Riso12356 DVSS_B.t218 DVSS_B.t84 1292.92884016145
Riso12357 DVSS_B.t218 DVSS_B.t89 28860.394216829
Riso12358 DVSS_B.t218 DVSS_B.t90 282.849813709337
Riso12359 DVSS_B.t218 DVSS_B.t94 187.694774537035
Riso12360 DVSS_B.t218 DVSS_B.t96 308.50546699101
Riso12361 DVSS_B.t218 VSS_A 1265.49853916147
Riso12362 DVSS_B.t218 VSS_B 182.507969883354
Riso12363 DVSS_B.t224 DVSS_B.t265 66.3487
Riso12364 DVSS_B.t224 DVSS_B.t71 66.3487
Riso12365 DVSS_B.t225 DVSS_B.t236 124.559161219804
Riso12366 DVSS_B.t225 DVSS_B.t238 1261.34547800515
Riso12367 DVSS_B.t225 DVSS_B.t240 141.192432322004
Riso12368 DVSS_B.t225 DVSS_B.t250 456.741889505727
Riso12369 DVSS_B.t225 DVSS_B.t252 1172.74346760215
Riso12370 DVSS_B.t225 DVSS_B.t256 630.687802164506
Riso12371 DVSS_B.t225 DVSS_B.t258 194.950282763221
Riso12372 DVSS_B.t225 DVSS_B.t259 19294.7038607015
Riso12373 DVSS_B.t225 DVSS_B.t260 227.919609065341
Riso12374 DVSS_B.t225 DVSS_B.t264 41.4323828810664
Riso12375 DVSS_B.t225 DVSS_B.t266 0.0669462231741366
Riso12376 DVSS_B.t225 DVSS_B.t267 162503.362388323
Riso12377 DVSS_B.t225 DVSS_B.t268 1284.48854080193
Riso12378 DVSS_B.t225 DVSS_B.t271 1282.41505295747
Riso12379 DVSS_B.t225 DVSS_B.t273 413.569554202947
Riso12380 DVSS_B.t225 DVSS_B.t275 970.549336675552
Riso12381 DVSS_B.t225 DVSS_B.t277 94.9167779741231
Riso12382 DVSS_B.t225 DVSS_B.t279 158.751118895686
Riso12383 DVSS_B.t225 DVSS_B.t281 34.3731374145579
Riso12384 DVSS_B.t225 DVSS_B.t283 895.948253129192
Riso12385 DVSS_B.t225 DVSS_B.t285 333.092877667317
Riso12386 DVSS_B.t225 DVSS_B.t287 372.208667222645
Riso12387 DVSS_B.t225 DVSS_B.t288 82611.4739982678
Riso12388 DVSS_B.t225 DVSS_B.t289 667.676121839881
Riso12389 DVSS_B.t225 DVSS_B.t291 38.4726731151985
Riso12390 DVSS_B.t225 DVSS_B.t293 1111.51376120472
Riso12391 DVSS_B.t225 DVSS_B.t295 212.287023272873
Riso12392 DVSS_B.t225 DVSS_B.t297 589.416945263892
Riso12393 DVSS_B.t225 DVSS_B.t299 1043.18869048351
Riso12394 DVSS_B.t225 DVSS_B.t301 46.780126226811
Riso12395 DVSS_B.t225 DVSS_B.t302 6800.24213876067
Riso12396 DVSS_B.t225 DVSS_B.t303 46.780126226811
Riso12397 DVSS_B.t225 DVSS_B.t305 630.687802164506
Riso12398 DVSS_B.t225 DVSS_B.t322 5508.91057242201
Riso12399 DVSS_B.t225 DVSS_B.t325 8002.91344454062
Riso12400 DVSS_B.t225 DVSS_B.t326 82.0885388395866
Riso12401 DVSS_B.t225 DVSS_B.t329 1073.21585286728
Riso12402 DVSS_B.t225 DVSS_B.t331 2080.59450478278
Riso12403 DVSS_B.t225 DVSS_B.t333 1979.79905726273
Riso12404 DVSS_B.t225 DVSS_B.t335 1049.08570413196
Riso12405 DVSS_B.t225 DVSS_B.t337 956.393960265213
Riso12406 DVSS_B.t225 DVSS_B.t339 2080.59450478278
Riso12407 DVSS_B.t225 DVSS_B.t341 1979.79905726273
Riso12408 DVSS_B.t225 DVSS_B.t343 854.286782911363
Riso12409 DVSS_B.t225 DVSS_B.t345 415933.579486965
Riso12410 DVSS_B.t225 DVSS_B.t346 1500.05408974299
Riso12411 DVSS_B.t225 DVSS_B.t348 413.569554202947
Riso12412 DVSS_B.t225 DVSS_B.t35 194.950282763221
Riso12413 DVSS_B.t225 DVSS_B.t350 1282.41505295747
Riso12414 DVSS_B.t225 DVSS_B.t352 1284.48854080193
Riso12415 DVSS_B.t225 DVSS_B.t355 1368369.85280467
Riso12416 DVSS_B.t225 DVSS_B.t356 2277.97077852301
Riso12417 DVSS_B.t225 DVSS_B.t358 41.4323828810664
Riso12418 DVSS_B.t225 DVSS_B.t36 226077.977707052
Riso12419 DVSS_B.t225 DVSS_B.t360 109.090438368552
Riso12420 DVSS_B.t225 DVSS_B.t364 34.3731374145579
Riso12421 DVSS_B.t225 DVSS_B.t366 42.1368545735411
Riso12422 DVSS_B.t225 DVSS_B.t37 3517.84507675175
Riso12423 DVSS_B.t225 DVSS_B.t509 42.1368545735411
Riso12424 DVSS_B.t225 DVSS_B.t515 501.086289805427
Riso12425 DVSS_B.t225 DVSS_B.t525 4484.05060352092
Riso12426 DVSS_B.t225 DVSS_B.t529 176.854954431604
Riso12427 DVSS_B.t225 DVSS_B.t531 501.086289805427
Riso12428 DVSS_B.t225 DVSS_B.t59 19294.7038607015
Riso12429 DVSS_B.t225 DVSS_B.t60 296.495015805917
Riso12430 DVSS_B.t225 DVSS_B.t66 545.709058089536
Riso12431 DVSS_B.t225 DVSS_B.t68 1043.18869048351
Riso12432 DVSS_B.t225 DVSS_B.t70 94.9167779741231
Riso12433 DVSS_B.t225 DVSS_B.t72 35.4891836806249
Riso12434 DVSS_B.t225 DVSS_B.t74 5508.91057242201
Riso12435 DVSS_B.t225 DVSS_B.t76 1223.76750438314
Riso12436 DVSS_B.t225 DVSS_B.t80 1172.74346760215
Riso12437 DVSS_B.t225 DVSS_B.t82 895.948253129192
Riso12438 DVSS_B.t225 DVSS_B.t84 4484.05060352092
Riso12439 DVSS_B.t225 DVSS_B.t89 8002.91344454062
Riso12440 DVSS_B.t225 DVSS_B.t90 54.7087004546916
Riso12441 DVSS_B.t225 DVSS_B.t94 109.090438368552
Riso12442 DVSS_B.t225 DVSS_B.t96 47.8963494175188
Riso12443 DVSS_B.t225 VSS_A 3647.05326907738
Riso12444 DVSS_B.t225 VSS_B 477.964857302939
Riso12445 DVSS_B.t235 DVSS_B.t359 66.3487
Riso12446 DVSS_B.t236 DVSS_B.t238 770.790757756116
Riso12447 DVSS_B.t236 DVSS_B.t240 39.9338310088635
Riso12448 DVSS_B.t236 DVSS_B.t250 217.967918143908
Riso12449 DVSS_B.t236 DVSS_B.t252 699.749955373392
Riso12450 DVSS_B.t236 DVSS_B.t256 329.831116315631
Riso12451 DVSS_B.t236 DVSS_B.t258 64.7122241211656
Riso12452 DVSS_B.t236 DVSS_B.t259 14108.9201766695
Riso12453 DVSS_B.t236 DVSS_B.t260 85.4045105546178
Riso12454 DVSS_B.t236 DVSS_B.t264 101.047933157361
Riso12455 DVSS_B.t236 DVSS_B.t266 124.559161219804
Riso12456 DVSS_B.t236 DVSS_B.t267 104400.801012502
Riso12457 DVSS_B.t236 DVSS_B.t268 802.746340396736
Riso12458 DVSS_B.t236 DVSS_B.t271 792.71123251731
Riso12459 DVSS_B.t236 DVSS_B.t273 192.571528843419
Riso12460 DVSS_B.t236 DVSS_B.t275 558.140652804569
Riso12461 DVSS_B.t236 DVSS_B.t277 45.700815089765
Riso12462 DVSS_B.t236 DVSS_B.t279 47.2328783777763
Riso12463 DVSS_B.t236 DVSS_B.t281 135.094910480707
Riso12464 DVSS_B.t236 DVSS_B.t283 508.82956523527
Riso12465 DVSS_B.t236 DVSS_B.t285 147.428864999296
Riso12466 DVSS_B.t236 DVSS_B.t287 169.01180822186
Riso12467 DVSS_B.t236 DVSS_B.t288 46170.475915438
Riso12468 DVSS_B.t236 DVSS_B.t289 356.485532304664
Riso12469 DVSS_B.t236 DVSS_B.t291 143.90454214285
Riso12470 DVSS_B.t236 DVSS_B.t293 655.183721093454
Riso12471 DVSS_B.t236 DVSS_B.t295 74.7572036679649
Riso12472 DVSS_B.t236 DVSS_B.t297 301.629264721787
Riso12473 DVSS_B.t236 DVSS_B.t299 607.39700190446
Riso12474 DVSS_B.t236 DVSS_B.t301 153.786829898628
Riso12475 DVSS_B.t236 DVSS_B.t302 20362.0256261366
Riso12476 DVSS_B.t236 DVSS_B.t303 153.786829898628
Riso12477 DVSS_B.t236 DVSS_B.t305 329.831116315631
Riso12478 DVSS_B.t236 DVSS_B.t322 3553.67173534402
Riso12479 DVSS_B.t236 DVSS_B.t325 7695.39710611325
Riso12480 DVSS_B.t236 DVSS_B.t326 52.3201427373384
Riso12481 DVSS_B.t236 DVSS_B.t329 725.826774281133
Riso12482 DVSS_B.t236 DVSS_B.t331 1403.73641123665
Riso12483 DVSS_B.t236 DVSS_B.t333 1336.65155367204
Riso12484 DVSS_B.t236 DVSS_B.t335 710.499128937085
Riso12485 DVSS_B.t236 DVSS_B.t337 641.599023178827
Riso12486 DVSS_B.t236 DVSS_B.t339 1403.73641123665
Riso12487 DVSS_B.t236 DVSS_B.t341 1336.65155367204
Riso12488 DVSS_B.t236 DVSS_B.t343 571.268811926643
Riso12489 DVSS_B.t236 DVSS_B.t345 276588.929005051
Riso12490 DVSS_B.t236 DVSS_B.t346 999.397407999825
Riso12491 DVSS_B.t236 DVSS_B.t348 192.571528843419
Riso12492 DVSS_B.t236 DVSS_B.t35 64.7122241211656
Riso12493 DVSS_B.t236 DVSS_B.t350 792.71123251731
Riso12494 DVSS_B.t236 DVSS_B.t352 802.746340396736
Riso12495 DVSS_B.t236 DVSS_B.t355 907168.010149936
Riso12496 DVSS_B.t236 DVSS_B.t356 1493.73757154513
Riso12497 DVSS_B.t236 DVSS_B.t358 101.047933157361
Riso12498 DVSS_B.t236 DVSS_B.t36 146011.861354288
Riso12499 DVSS_B.t236 DVSS_B.t360 39.3851640073845
Riso12500 DVSS_B.t236 DVSS_B.t364 135.094910480707
Riso12501 DVSS_B.t236 DVSS_B.t366 150.299905664749
Riso12502 DVSS_B.t236 DVSS_B.t37 2270.06096723262
Riso12503 DVSS_B.t236 DVSS_B.t509 150.299905664749
Riso12504 DVSS_B.t236 DVSS_B.t515 244.933396986607
Riso12505 DVSS_B.t236 DVSS_B.t525 2909.79337294189
Riso12506 DVSS_B.t236 DVSS_B.t529 55.5007434259351
Riso12507 DVSS_B.t236 DVSS_B.t531 244.933396986607
Riso12508 DVSS_B.t236 DVSS_B.t59 14108.9201766695
Riso12509 DVSS_B.t236 DVSS_B.t60 127.867970069098
Riso12510 DVSS_B.t236 DVSS_B.t66 273.034318536977
Riso12511 DVSS_B.t236 DVSS_B.t68 607.39700190446
Riso12512 DVSS_B.t236 DVSS_B.t70 45.700815089765
Riso12513 DVSS_B.t236 DVSS_B.t72 112.998715877139
Riso12514 DVSS_B.t236 DVSS_B.t74 3553.67173534402
Riso12515 DVSS_B.t236 DVSS_B.t76 739.040062311947
Riso12516 DVSS_B.t236 DVSS_B.t80 699.749955373392
Riso12517 DVSS_B.t236 DVSS_B.t82 508.82956523527
Riso12518 DVSS_B.t236 DVSS_B.t84 2909.79337294189
Riso12519 DVSS_B.t236 DVSS_B.t89 7695.39710611325
Riso12520 DVSS_B.t236 DVSS_B.t90 77.9234896871547
Riso12521 DVSS_B.t236 DVSS_B.t94 39.3851640073845
Riso12522 DVSS_B.t236 DVSS_B.t96 89.2266897151904
Riso12523 DVSS_B.t236 VSS_A 2475.47400537645
Riso12524 DVSS_B.t236 VSS_B 335.248023435087
Riso12525 DVSS_B.t237 DVSS_B.t270 66.3487
Riso12526 DVSS_B.t238 DVSS_B.t240 716.27522470411
Riso12527 DVSS_B.t238 DVSS_B.t250 251.74064281669
Riso12528 DVSS_B.t238 DVSS_B.t252 44.5668318689253
Riso12529 DVSS_B.t238 DVSS_B.t256 155.47808943041
Riso12530 DVSS_B.t238 DVSS_B.t258 547.111623432985
Riso12531 DVSS_B.t238 DVSS_B.t259 27342.2633718909
Riso12532 DVSS_B.t238 DVSS_B.t260 441.666986304882
Riso12533 DVSS_B.t238 DVSS_B.t264 1176.36938262871
Riso12534 DVSS_B.t238 DVSS_B.t266 1261.34547800515
Riso12535 DVSS_B.t238 DVSS_B.t267 7011.62794483948
Riso12536 DVSS_B.t238 DVSS_B.t268 40.6910082497086
Riso12537 DVSS_B.t238 DVSS_B.t271 36.2081064728562
Riso12538 DVSS_B.t238 DVSS_B.t273 277.945008730063
Riso12539 DVSS_B.t238 DVSS_B.t275 71.0243998897834
Riso12540 DVSS_B.t238 DVSS_B.t277 865.890602077562
Riso12541 DVSS_B.t238 DVSS_B.t279 659.809944290633
Riso12542 DVSS_B.t238 DVSS_B.t281 1281.11449088449
Riso12543 DVSS_B.t238 DVSS_B.t283 81.4756957685454
Riso12544 DVSS_B.t238 DVSS_B.t285 327.290710701564
Riso12545 DVSS_B.t238 DVSS_B.t287 303.522917586147
Riso12546 DVSS_B.t238 DVSS_B.t288 13280.217618926
Riso12547 DVSS_B.t238 DVSS_B.t289 135.465253635219
Riso12548 DVSS_B.t238 DVSS_B.t291 1283.27393248009
Riso12549 DVSS_B.t238 DVSS_B.t293 52.4523658602611
Riso12550 DVSS_B.t238 DVSS_B.t295 493.10314461379
Riso12551 DVSS_B.t238 DVSS_B.t297 177.330345729179
Riso12552 DVSS_B.t238 DVSS_B.t299 61.293985764678
Riso12553 DVSS_B.t238 DVSS_B.t301 1181.38943748577
Riso12554 DVSS_B.t238 DVSS_B.t302 140884.735487341
Riso12555 DVSS_B.t238 DVSS_B.t303 1181.38943748577
Riso12556 DVSS_B.t238 DVSS_B.t305 155.47808943041
Riso12557 DVSS_B.t238 DVSS_B.t322 189.764863487279
Riso12558 DVSS_B.t238 DVSS_B.t325 108345.301787446
Riso12559 DVSS_B.t238 DVSS_B.t326 901.799708800677
Riso12560 DVSS_B.t238 DVSS_B.t329 99.0805268761054
Riso12561 DVSS_B.t238 DVSS_B.t331 176.925825280798
Riso12562 DVSS_B.t238 DVSS_B.t333 168.358611818707
Riso12563 DVSS_B.t238 DVSS_B.t335 95.6536446825186
Riso12564 DVSS_B.t238 DVSS_B.t337 83.142110443058
Riso12565 DVSS_B.t238 DVSS_B.t339 176.925825280798
Riso12566 DVSS_B.t238 DVSS_B.t341 168.358611818707
Riso12567 DVSS_B.t238 DVSS_B.t343 71.1899529479837
Riso12568 DVSS_B.t238 DVSS_B.t345 30605.7189530108
Riso12569 DVSS_B.t238 DVSS_B.t346 118.548917898901
Riso12570 DVSS_B.t238 DVSS_B.t348 277.945008730063
Riso12571 DVSS_B.t238 DVSS_B.t35 547.111623432985
Riso12572 DVSS_B.t238 DVSS_B.t350 36.2081064728562
Riso12573 DVSS_B.t238 DVSS_B.t352 40.6910082497086
Riso12574 DVSS_B.t238 DVSS_B.t355 90538.9695347866
Riso12575 DVSS_B.t238 DVSS_B.t356 110.320005130579
Riso12576 DVSS_B.t238 DVSS_B.t358 1176.36938262871
Riso12577 DVSS_B.t238 DVSS_B.t36 16760.8848293949
Riso12578 DVSS_B.t238 DVSS_B.t360 821.41042056164
Riso12579 DVSS_B.t238 DVSS_B.t364 1281.11449088449
Riso12580 DVSS_B.t238 DVSS_B.t366 1267.02317681228
Riso12581 DVSS_B.t238 DVSS_B.t37 259.647724191737
Riso12582 DVSS_B.t238 DVSS_B.t509 1267.02317681228
Riso12583 DVSS_B.t238 DVSS_B.t515 225.827843192229
Riso12584 DVSS_B.t238 DVSS_B.t525 172.630597085251
Riso12585 DVSS_B.t238 DVSS_B.t529 602.999913131121
Riso12586 DVSS_B.t238 DVSS_B.t531 225.827843192229
Riso12587 DVSS_B.t238 DVSS_B.t59 27342.2633718909
Riso12588 DVSS_B.t238 DVSS_B.t60 347.828006380335
Riso12589 DVSS_B.t238 DVSS_B.t66 200.873646577457
Riso12590 DVSS_B.t238 DVSS_B.t68 61.293985764678
Riso12591 DVSS_B.t238 DVSS_B.t70 865.890602077562
Riso12592 DVSS_B.t238 DVSS_B.t72 1225.65473018169
Riso12593 DVSS_B.t238 DVSS_B.t74 189.764863487279
Riso12594 DVSS_B.t238 DVSS_B.t76 37.6360792307161
Riso12595 DVSS_B.t238 DVSS_B.t80 44.5668318689253
Riso12596 DVSS_B.t238 DVSS_B.t82 81.4756957685454
Riso12597 DVSS_B.t238 DVSS_B.t84 172.630597085251
Riso12598 DVSS_B.t238 DVSS_B.t89 108345.301787446
Riso12599 DVSS_B.t238 DVSS_B.t90 1047.88026180653
Riso12600 DVSS_B.t238 DVSS_B.t94 821.41042056164
Riso12601 DVSS_B.t238 DVSS_B.t96 1116.17945814663
Riso12602 DVSS_B.t238 VSS_A 347.068330764454
Riso12603 DVSS_B.t238 VSS_B 55.9349162746284
Riso12604 DVSS_B.t240 DVSS_B.t250 195.523461033595
Riso12605 DVSS_B.t240 DVSS_B.t252 648.31907335736
Riso12606 DVSS_B.t240 DVSS_B.t256 299.848929253968
Riso12607 DVSS_B.t240 DVSS_B.t258 55.6778213378557
Riso12608 DVSS_B.t240 DVSS_B.t259 13265.8862892806
Riso12609 DVSS_B.t240 DVSS_B.t260 74.33215506546
Riso12610 DVSS_B.t240 DVSS_B.t264 115.723047616393
Riso12611 DVSS_B.t240 DVSS_B.t266 141.192432322004
Riso12612 DVSS_B.t240 DVSS_B.t267 97548.6252991728
Riso12613 DVSS_B.t240 DVSS_B.t268 747.897509793716
Riso12614 DVSS_B.t240 DVSS_B.t271 737.638163560689
Riso12615 DVSS_B.t240 DVSS_B.t273 172.122662093952
Riso12616 DVSS_B.t240 DVSS_B.t275 514.486696016195
Riso12617 DVSS_B.t240 DVSS_B.t277 53.8795951513506
Riso12618 DVSS_B.t240 DVSS_B.t279 40.2423027109723
Riso12619 DVSS_B.t240 DVSS_B.t281 152.362126855649
Riso12620 DVSS_B.t240 DVSS_B.t283 468.16527481512
Riso12621 DVSS_B.t240 DVSS_B.t285 130.814238197969
Riso12622 DVSS_B.t240 DVSS_B.t287 150.515575426522
Riso12623 DVSS_B.t240 DVSS_B.t288 42348.0482739152
Riso12624 DVSS_B.t240 DVSS_B.t289 325.036895980636
Riso12625 DVSS_B.t240 DVSS_B.t291 161.511668520082
Riso12626 DVSS_B.t240 DVSS_B.t293 606.04407936099
Riso12627 DVSS_B.t240 DVSS_B.t295 64.67705992303
Riso12628 DVSS_B.t240 DVSS_B.t297 273.352113567922
Riso12629 DVSS_B.t240 DVSS_B.t299 560.886312213448
Riso12630 DVSS_B.t240 DVSS_B.t301 170.536125876715
Riso12631 DVSS_B.t240 DVSS_B.t302 22390.6054943606
Riso12632 DVSS_B.t240 DVSS_B.t303 170.536125876715
Riso12633 DVSS_B.t240 DVSS_B.t305 299.848929253968
Riso12634 DVSS_B.t240 DVSS_B.t322 3322.00078260901
Riso12635 DVSS_B.t240 DVSS_B.t325 8934.28213825394
Riso12636 DVSS_B.t240 DVSS_B.t326 61.3908745452568
Riso12637 DVSS_B.t240 DVSS_B.t329 682.154872893259
Riso12638 DVSS_B.t240 DVSS_B.t331 1318.5024447117
Riso12639 DVSS_B.t240 DVSS_B.t333 1254.95143329596
Riso12640 DVSS_B.t240 DVSS_B.t335 667.453950844456
Riso12641 DVSS_B.t240 DVSS_B.t337 602.673543104529
Riso12642 DVSS_B.t240 DVSS_B.t339 1318.5024447117
Riso12643 DVSS_B.t240 DVSS_B.t341 1254.95143329596
Riso12644 DVSS_B.t240 DVSS_B.t343 536.242445209177
Riso12645 DVSS_B.t240 DVSS_B.t345 260008.538978984
Riso12646 DVSS_B.t240 DVSS_B.t346 939.820977566687
Riso12647 DVSS_B.t240 DVSS_B.t348 172.122662093952
Riso12648 DVSS_B.t240 DVSS_B.t35 55.6778213378557
Riso12649 DVSS_B.t240 DVSS_B.t350 737.638163560689
Riso12650 DVSS_B.t240 DVSS_B.t352 747.897509793716
Riso12651 DVSS_B.t240 DVSS_B.t355 852299.50857903
Riso12652 DVSS_B.t240 DVSS_B.t356 1400.54115277239
Riso12653 DVSS_B.t240 DVSS_B.t358 115.723047616393
Riso12654 DVSS_B.t240 DVSS_B.t36 136457.149781234
Riso12655 DVSS_B.t240 DVSS_B.t360 46.645703209474
Riso12656 DVSS_B.t240 DVSS_B.t364 152.362126855649
Riso12657 DVSS_B.t240 DVSS_B.t366 167.929152553776
Riso12658 DVSS_B.t240 DVSS_B.t37 2121.38144986007
Riso12659 DVSS_B.t240 DVSS_B.t509 167.929152553776
Riso12660 DVSS_B.t240 DVSS_B.t515 220.486720560366
Riso12661 DVSS_B.t240 DVSS_B.t525 2723.0323177363
Riso12662 DVSS_B.t240 DVSS_B.t529 47.5093959312749
Riso12663 DVSS_B.t240 DVSS_B.t531 220.486720560366
Riso12664 DVSS_B.t240 DVSS_B.t59 13265.8862892806
Riso12665 DVSS_B.t240 DVSS_B.t60 113.042834835847
Riso12666 DVSS_B.t240 DVSS_B.t66 246.624640197016
Riso12667 DVSS_B.t240 DVSS_B.t68 560.886312213448
Riso12668 DVSS_B.t240 DVSS_B.t70 53.8795951513506
Riso12669 DVSS_B.t240 DVSS_B.t72 128.748619763153
Riso12670 DVSS_B.t240 DVSS_B.t74 3322.00078260901
Riso12671 DVSS_B.t240 DVSS_B.t76 685.77623796367
Riso12672 DVSS_B.t240 DVSS_B.t80 648.31907335736
Riso12673 DVSS_B.t240 DVSS_B.t82 468.16527481512
Riso12674 DVSS_B.t240 DVSS_B.t84 2723.0323177363
Riso12675 DVSS_B.t240 DVSS_B.t89 8934.28213825394
Riso12676 DVSS_B.t240 DVSS_B.t90 90.1243198683169
Riso12677 DVSS_B.t240 DVSS_B.t94 46.645703209474
Riso12678 DVSS_B.t240 DVSS_B.t96 102.698565104169
Riso12679 DVSS_B.t240 VSS_A 2327.11910676975
Riso12680 DVSS_B.t240 VSS_B 315.511714871761
Riso12681 DVSS_B.t249 DVSS_B.t514 66.3487
Riso12682 DVSS_B.t250 DVSS_B.t252 210.377405142835
Riso12683 DVSS_B.t250 DVSS_B.t256 65.063609472613
Riso12684 DVSS_B.t250 DVSS_B.t258 133.755482870674
Riso12685 DVSS_B.t250 DVSS_B.t259 12783.9267833552
Riso12686 DVSS_B.t250 DVSS_B.t260 100.13086294793
Riso12687 DVSS_B.t250 DVSS_B.t264 411.008229675483
Riso12688 DVSS_B.t250 DVSS_B.t266 456.741889505727
Riso12689 DVSS_B.t250 DVSS_B.t267 40490.5137345776
Riso12690 DVSS_B.t250 DVSS_B.t268 283.038332471676
Riso12691 DVSS_B.t250 DVSS_B.t271 269.288762490318
Riso12692 DVSS_B.t250 DVSS_B.t273 40.7811341923897
Riso12693 DVSS_B.t250 DVSS_B.t275 147.473784546657
Riso12694 DVSS_B.t250 DVSS_B.t277 261.886581705179
Riso12695 DVSS_B.t250 DVSS_B.t279 173.715177751818
Riso12696 DVSS_B.t250 DVSS_B.t281 471.598657962362
Riso12697 DVSS_B.t250 DVSS_B.t283 128.714943374255
Riso12698 DVSS_B.t250 DVSS_B.t285 56.1385988359652
Riso12699 DVSS_B.t250 DVSS_B.t287 48.0502522241637
Riso12700 DVSS_B.t250 DVSS_B.t288 10903.6832094396
Riso12701 DVSS_B.t250 DVSS_B.t289 74.3817418629053
Riso12702 DVSS_B.t250 DVSS_B.t291 479.661992024892
Riso12703 DVSS_B.t250 DVSS_B.t293 188.755979333325
Riso12704 DVSS_B.t250 DVSS_B.t295 116.099282644295
Riso12705 DVSS_B.t250 DVSS_B.t297 56.2174109034491
Riso12706 DVSS_B.t250 DVSS_B.t299 167.606173922606
Riso12707 DVSS_B.t250 DVSS_B.t301 458.232207163574
Riso12708 DVSS_B.t250 DVSS_B.t302 56105.2209865995
Riso12709 DVSS_B.t250 DVSS_B.t303 458.232207163574
Riso12710 DVSS_B.t250 DVSS_B.t305 65.063609472613
Riso12711 DVSS_B.t250 DVSS_B.t322 1322.24686845801
Riso12712 DVSS_B.t250 DVSS_B.t325 36088.0784306968
Riso12713 DVSS_B.t250 DVSS_B.t326 281.425793249431
Riso12714 DVSS_B.t250 DVSS_B.t329 338.095462056786
Riso12715 DVSS_B.t250 DVSS_B.t331 646.378918610669
Riso12716 DVSS_B.t250 DVSS_B.t333 617.978144417203
Riso12717 DVSS_B.t250 DVSS_B.t335 332.437294346508
Riso12718 DVSS_B.t250 DVSS_B.t337 292.260828597205
Riso12719 DVSS_B.t250 DVSS_B.t339 646.378918610669
Riso12720 DVSS_B.t250 DVSS_B.t341 617.978144417203
Riso12721 DVSS_B.t250 DVSS_B.t343 258.097882306523
Riso12722 DVSS_B.t250 DVSS_B.t345 120643.0346043
Riso12723 DVSS_B.t250 DVSS_B.t346 440.682581281736
Riso12724 DVSS_B.t250 DVSS_B.t348 40.7811341923897
Riso12725 DVSS_B.t250 DVSS_B.t35 133.755482870674
Riso12726 DVSS_B.t250 DVSS_B.t350 269.288762490318
Riso12727 DVSS_B.t250 DVSS_B.t352 283.038332471676
Riso12728 DVSS_B.t250 DVSS_B.t355 388889.89363102
Riso12729 DVSS_B.t250 DVSS_B.t356 603.242968524624
Riso12730 DVSS_B.t250 DVSS_B.t358 411.008229675483
Riso12731 DVSS_B.t250 DVSS_B.t36 61888.9252373647
Riso12732 DVSS_B.t250 DVSS_B.t360 240.379778812707
Riso12733 DVSS_B.t250 DVSS_B.t364 471.598657962362
Riso12734 DVSS_B.t250 DVSS_B.t366 480.217027940053
Riso12735 DVSS_B.t250 DVSS_B.t37 960.35609311862
Riso12736 DVSS_B.t250 DVSS_B.t509 480.217027940053
Riso12737 DVSS_B.t250 DVSS_B.t515 40.7942809461268
Riso12738 DVSS_B.t250 DVSS_B.t525 1114.29562103681
Riso12739 DVSS_B.t250 DVSS_B.t529 153.021161738706
Riso12740 DVSS_B.t250 DVSS_B.t531 40.7942809461268
Riso12741 DVSS_B.t250 DVSS_B.t59 12783.9267833552
Riso12742 DVSS_B.t250 DVSS_B.t60 64.9165199594325
Riso12743 DVSS_B.t250 DVSS_B.t66 48.0874934445253
Riso12744 DVSS_B.t250 DVSS_B.t68 167.606173922606
Riso12745 DVSS_B.t250 DVSS_B.t70 261.886581705179
Riso12746 DVSS_B.t250 DVSS_B.t72 436.134544023013
Riso12747 DVSS_B.t250 DVSS_B.t74 1322.24686845801
Riso12748 DVSS_B.t250 DVSS_B.t76 231.704403987765
Riso12749 DVSS_B.t250 DVSS_B.t80 210.377405142835
Riso12750 DVSS_B.t250 DVSS_B.t82 128.714943374255
Riso12751 DVSS_B.t250 DVSS_B.t84 1114.29562103681
Riso12752 DVSS_B.t250 DVSS_B.t89 36088.0784306968
Riso12753 DVSS_B.t250 DVSS_B.t90 352.291731781694
Riso12754 DVSS_B.t250 DVSS_B.t94 240.379778812707
Riso12755 DVSS_B.t250 DVSS_B.t96 382.64962631451
Riso12756 DVSS_B.t250 VSS_A 1165.1114871259
Riso12757 DVSS_B.t250 VSS_B 174.106920759966
Riso12758 DVSS_B.t251 DVSS_B.t79 66.3487
Riso12759 DVSS_B.t252 DVSS_B.t256 125.115105823218
Riso12760 DVSS_B.t252 DVSS_B.t258 490.932358035521
Riso12761 DVSS_B.t252 DVSS_B.t259 26668.9694226827
Riso12762 DVSS_B.t252 DVSS_B.t260 394.112820536507
Riso12763 DVSS_B.t252 DVSS_B.t264 1089.5544009286
Riso12764 DVSS_B.t252 DVSS_B.t266 1172.74346760215
Riso12765 DVSS_B.t252 DVSS_B.t267 9498.89595201959
Riso12766 DVSS_B.t252 DVSS_B.t268 56.4467987154344
Riso12767 DVSS_B.t252 DVSS_B.t271 50.6344603178186
Riso12768 DVSS_B.t252 DVSS_B.t273 234.664817520121
Riso12769 DVSS_B.t252 DVSS_B.t275 54.0715647470047
Riso12770 DVSS_B.t252 DVSS_B.t277 790.889610098672
Riso12771 DVSS_B.t252 DVSS_B.t279 595.459595398748
Riso12772 DVSS_B.t252 DVSS_B.t281 1193.41116178396
Riso12773 DVSS_B.t252 DVSS_B.t283 62.6162584880695
Riso12774 DVSS_B.t252 DVSS_B.t285 282.375294543756
Riso12775 DVSS_B.t252 DVSS_B.t287 258.995941993776
Riso12776 DVSS_B.t252 DVSS_B.t288 10533.5432811596
Riso12777 DVSS_B.t252 DVSS_B.t289 108.056845527655
Riso12778 DVSS_B.t252 DVSS_B.t291 1197.67097069084
Riso12779 DVSS_B.t252 DVSS_B.t293 39.2269431528519
Riso12780 DVSS_B.t252 DVSS_B.t295 441.231325333567
Riso12781 DVSS_B.t252 DVSS_B.t297 143.994896857435
Riso12782 DVSS_B.t252 DVSS_B.t299 46.2402028310833
Riso12783 DVSS_B.t252 DVSS_B.t301 1108.15541018533
Riso12784 DVSS_B.t252 DVSS_B.t302 132699.985724336
Riso12785 DVSS_B.t252 DVSS_B.t303 1108.15541018533
Riso12786 DVSS_B.t252 DVSS_B.t305 125.115105823218
Riso12787 DVSS_B.t252 DVSS_B.t322 265.144936279763
Riso12788 DVSS_B.t252 DVSS_B.t325 100013.43206676
Riso12789 DVSS_B.t252 DVSS_B.t326 826.213964054565
Riso12790 DVSS_B.t252 DVSS_B.t329 122.950187354063
Riso12791 DVSS_B.t252 DVSS_B.t331 222.730563767566
Riso12792 DVSS_B.t252 DVSS_B.t333 212.163855770821
Riso12793 DVSS_B.t252 DVSS_B.t335 119.252942659024
Riso12794 DVSS_B.t252 DVSS_B.t337 103.463138385398
Riso12795 DVSS_B.t252 DVSS_B.t339 222.730563767566
Riso12796 DVSS_B.t252 DVSS_B.t341 212.163855770821
Riso12797 DVSS_B.t252 DVSS_B.t343 89.0612903561792
Riso12798 DVSS_B.t252 DVSS_B.t345 38983.5604617086
Riso12799 DVSS_B.t252 DVSS_B.t346 149.167494396697
Riso12800 DVSS_B.t252 DVSS_B.t348 234.664817520121
Riso12801 DVSS_B.t252 DVSS_B.t35 490.932358035521
Riso12802 DVSS_B.t252 DVSS_B.t350 50.6344603178186
Riso12803 DVSS_B.t252 DVSS_B.t352 56.4467987154344
Riso12804 DVSS_B.t252 DVSS_B.t355 117285.871330619
Riso12805 DVSS_B.t252 DVSS_B.t356 148.981591536301
Riso12806 DVSS_B.t252 DVSS_B.t358 1089.5544009286
Riso12807 DVSS_B.t252 DVSS_B.t36 20703.4502103063
Riso12808 DVSS_B.t252 DVSS_B.t360 747.968929096234
Riso12809 DVSS_B.t252 DVSS_B.t364 1193.41116178396
Riso12810 DVSS_B.t252 DVSS_B.t366 1184.63869653332
Riso12811 DVSS_B.t252 DVSS_B.t37 320.747134139474
Riso12812 DVSS_B.t252 DVSS_B.t509 1184.63869653332
Riso12813 DVSS_B.t252 DVSS_B.t515 186.866860664628
Riso12814 DVSS_B.t252 DVSS_B.t525 238.807221358151
Riso12815 DVSS_B.t252 DVSS_B.t529 542.621503006612
Riso12816 DVSS_B.t252 DVSS_B.t531 186.866860664628
Riso12817 DVSS_B.t252 DVSS_B.t59 26668.9694226827
Riso12818 DVSS_B.t252 DVSS_B.t60 303.545622349064
Riso12819 DVSS_B.t252 DVSS_B.t66 164.634914885224
Riso12820 DVSS_B.t252 DVSS_B.t68 46.2402028310833
Riso12821 DVSS_B.t252 DVSS_B.t70 790.889610098672
Riso12822 DVSS_B.t252 DVSS_B.t72 1137.36767733672
Riso12823 DVSS_B.t252 DVSS_B.t74 265.144936279763
Riso12824 DVSS_B.t252 DVSS_B.t76 38.6229456499396
Riso12825 DVSS_B.t252 DVSS_B.t80 0.0669592846354836
Riso12826 DVSS_B.t252 DVSS_B.t82 62.6162584880695
Riso12827 DVSS_B.t252 DVSS_B.t84 238.807221358151
Riso12828 DVSS_B.t252 DVSS_B.t89 100013.43206676
Riso12829 DVSS_B.t252 DVSS_B.t90 966.987108626961
Riso12830 DVSS_B.t252 DVSS_B.t94 747.968929096234
Riso12831 DVSS_B.t252 DVSS_B.t96 1031.88028186083
Riso12832 DVSS_B.t252 VSS_A 429.865108958678
Riso12833 DVSS_B.t252 VSS_B 69.4576256166422
Riso12834 DVSS_B.t255 DVSS_B.t296 66.3487
Riso12835 DVSS_B.t255 DVSS_B.t304 66.3487
Riso12836 DVSS_B.t256 DVSS_B.t258 213.895881041146
Riso12837 DVSS_B.t256 DVSS_B.t259 16799.2268104228
Riso12838 DVSS_B.t256 DVSS_B.t260 164.72813396529
Riso12839 DVSS_B.t256 DVSS_B.t264 574.853962228456
Riso12840 DVSS_B.t256 DVSS_B.t266 630.687802164506
Riso12841 DVSS_B.t256 DVSS_B.t267 27177.4711803246
Riso12842 DVSS_B.t256 DVSS_B.t268 181.26430578774
Riso12843 DVSS_B.t256 DVSS_B.t271 169.422110220124
Riso12844 DVSS_B.t256 DVSS_B.t273 75.8262361345515
Riso12845 DVSS_B.t256 DVSS_B.t275 83.0088962623749
Riso12846 DVSS_B.t256 DVSS_B.t277 386.461557205248
Riso12847 DVSS_B.t256 DVSS_B.t279 270.089197572388
Riso12848 DVSS_B.t256 DVSS_B.t281 647.543901765201
Riso12849 DVSS_B.t256 DVSS_B.t283 71.2040975289504
Riso12850 DVSS_B.t256 DVSS_B.t285 100.245580682412
Riso12851 DVSS_B.t256 DVSS_B.t287 87.6236246275127
Riso12852 DVSS_B.t256 DVSS_B.t288 5859.79269866367
Riso12853 DVSS_B.t256 DVSS_B.t289 38.4890506767861
Riso12854 DVSS_B.t256 DVSS_B.t291 655.295069852987
Riso12855 DVSS_B.t256 DVSS_B.t293 110.172941514254
Riso12856 DVSS_B.t256 DVSS_B.t295 188.315236746854
Riso12857 DVSS_B.t256 DVSS_B.t297 39.5116216084411
Riso12858 DVSS_B.t256 DVSS_B.t299 96.0459988669639
Riso12859 DVSS_B.t256 DVSS_B.t301 618.935550300872
Riso12860 DVSS_B.t256 DVSS_B.t302 75244.7448141053
Riso12861 DVSS_B.t256 DVSS_B.t303 618.935550300872
Riso12862 DVSS_B.t256 DVSS_B.t305 0.0669595119233204
Riso12863 DVSS_B.t256 DVSS_B.t322 856.294821519518
Riso12864 DVSS_B.t256 DVSS_B.t325 51496.0097091273
Riso12865 DVSS_B.t256 DVSS_B.t326 410.56219728836
Riso12866 DVSS_B.t256 DVSS_B.t329 252.535341996905
Riso12867 DVSS_B.t256 DVSS_B.t331 478.125180111101
Riso12868 DVSS_B.t256 DVSS_B.t333 457.436127513841
Riso12869 DVSS_B.t256 DVSS_B.t335 248.228037445791
Riso12870 DVSS_B.t256 DVSS_B.t337 216.247289465065
Riso12871 DVSS_B.t256 DVSS_B.t339 478.125180111101
Riso12872 DVSS_B.t256 DVSS_B.t341 457.436127513841
Riso12873 DVSS_B.t256 DVSS_B.t343 189.955234227283
Riso12874 DVSS_B.t256 DVSS_B.t345 87235.4013792996
Riso12875 DVSS_B.t256 DVSS_B.t346 321.434044637572
Riso12876 DVSS_B.t256 DVSS_B.t348 75.8262361345515
Riso12877 DVSS_B.t256 DVSS_B.t35 213.895881041146
Riso12878 DVSS_B.t256 DVSS_B.t350 169.422110220124
Riso12879 DVSS_B.t256 DVSS_B.t352 181.26430578774
Riso12880 DVSS_B.t256 DVSS_B.t355 277422.814091252
Riso12881 DVSS_B.t256 DVSS_B.t356 411.977199784866
Riso12882 DVSS_B.t256 DVSS_B.t358 574.853962228456
Riso12883 DVSS_B.t256 DVSS_B.t36 44633.8049566657
Riso12884 DVSS_B.t256 DVSS_B.t360 359.093184310337
Riso12885 DVSS_B.t256 DVSS_B.t364 647.543901765201
Riso12886 DVSS_B.t256 DVSS_B.t366 653.14951834088
Riso12887 DVSS_B.t256 DVSS_B.t37 692.133423369118
Riso12888 DVSS_B.t256 DVSS_B.t509 653.14951834088
Riso12889 DVSS_B.t256 DVSS_B.t515 55.4268738276773
Riso12890 DVSS_B.t256 DVSS_B.t525 734.625406414423
Riso12891 DVSS_B.t256 DVSS_B.t529 241.267463887378
Riso12892 DVSS_B.t256 DVSS_B.t531 55.4268738276773
Riso12893 DVSS_B.t256 DVSS_B.t59 16799.2268104228
Riso12894 DVSS_B.t256 DVSS_B.t60 113.322506210338
Riso12895 DVSS_B.t256 DVSS_B.t66 46.924530296379
Riso12896 DVSS_B.t256 DVSS_B.t68 96.0459988669639
Riso12897 DVSS_B.t256 DVSS_B.t70 386.461557205248
Riso12898 DVSS_B.t256 DVSS_B.t72 605.957150482338
Riso12899 DVSS_B.t256 DVSS_B.t74 856.294821519518
Riso12900 DVSS_B.t256 DVSS_B.t76 140.429693489005
Riso12901 DVSS_B.t256 DVSS_B.t80 125.115105823218
Riso12902 DVSS_B.t256 DVSS_B.t82 71.2040975289504
Riso12903 DVSS_B.t256 DVSS_B.t84 734.625406414423
Riso12904 DVSS_B.t256 DVSS_B.t89 51496.0097091273
Riso12905 DVSS_B.t256 DVSS_B.t90 499.929882371037
Riso12906 DVSS_B.t256 DVSS_B.t94 359.093184310337
Riso12907 DVSS_B.t256 DVSS_B.t96 538.986454456892
Riso12908 DVSS_B.t256 VSS_A 874.331997492871
Riso12909 DVSS_B.t256 VSS_B 135.909882526728
Riso12910 DVSS_B.t257 DVSS_B.t34 66.3487
Riso12911 DVSS_B.t257 DVSS_B.t528 66.3487
Riso12912 DVSS_B.t258 DVSS_B.t259 10201.9878497633
Riso12913 DVSS_B.t258 DVSS_B.t260 46.5828304440546
Riso12914 DVSS_B.t258 DVSS_B.t264 165.05687821457
Riso12915 DVSS_B.t258 DVSS_B.t266 194.950282763221
Riso12916 DVSS_B.t258 DVSS_B.t267 75558.9510393105
Riso12917 DVSS_B.t258 DVSS_B.t268 575.256480447287
Riso12918 DVSS_B.t258 DVSS_B.t271 565.520738886817
Riso12919 DVSS_B.t258 DVSS_B.t273 116.441358192348
Riso12920 DVSS_B.t258 DVSS_B.t275 383.487176941639
Riso12921 DVSS_B.t258 DVSS_B.t277 84.6433276372939
Riso12922 DVSS_B.t258 DVSS_B.t279 47.4981958486241
Riso12923 DVSS_B.t258 DVSS_B.t281 207.055745157195
Riso12924 DVSS_B.t258 DVSS_B.t283 346.8996734152
Riso12925 DVSS_B.t258 DVSS_B.t285 86.5347879318451
Riso12926 DVSS_B.t258 DVSS_B.t287 100.688121339617
Riso12927 DVSS_B.t258 DVSS_B.t288 31032.3768517356
Riso12928 DVSS_B.t258 DVSS_B.t289 234.005959370114
Riso12929 DVSS_B.t258 DVSS_B.t291 216.175585679901
Riso12930 DVSS_B.t258 DVSS_B.t293 456.671337357699
Riso12931 DVSS_B.t258 DVSS_B.t295 39.9043964026663
Riso12932 DVSS_B.t258 DVSS_B.t297 193.08639546778
Riso12933 DVSS_B.t258 DVSS_B.t299 420.422602881445
Riso12934 DVSS_B.t258 DVSS_B.t301 219.746302310747
Riso12935 DVSS_B.t258 DVSS_B.t302 28071.4061226391
Riso12936 DVSS_B.t258 DVSS_B.t303 219.746302310747
Riso12937 DVSS_B.t258 DVSS_B.t305 213.895881041146
Riso12938 DVSS_B.t258 DVSS_B.t322 2577.19111973622
Riso12939 DVSS_B.t258 DVSS_B.t325 13296.5146737282
Riso12940 DVSS_B.t258 DVSS_B.t326 94.8612575334884
Riso12941 DVSS_B.t258 DVSS_B.t329 536.434704414419
Riso12942 DVSS_B.t258 DVSS_B.t331 1034.43457278892
Riso12943 DVSS_B.t258 DVSS_B.t333 982.147291630329
Riso12944 DVSS_B.t258 DVSS_B.t335 523.432443424868
Riso12945 DVSS_B.t258 DVSS_B.t337 473.759859080652
Riso12946 DVSS_B.t258 DVSS_B.t339 1034.43457278892
Riso12947 DVSS_B.t258 DVSS_B.t341 982.147291630329
Riso12948 DVSS_B.t258 DVSS_B.t343 420.424850930104
Riso12949 DVSS_B.t258 DVSS_B.t345 205786.529632381
Riso12950 DVSS_B.t258 DVSS_B.t346 744.788343077756
Riso12951 DVSS_B.t258 DVSS_B.t348 116.441358192348
Riso12952 DVSS_B.t258 DVSS_B.t35 0.0669625145527533
Riso12953 DVSS_B.t258 DVSS_B.t350 565.520738886817
Riso12954 DVSS_B.t258 DVSS_B.t352 575.256480447287
Riso12955 DVSS_B.t258 DVSS_B.t355 673168.83130837
Riso12956 DVSS_B.t258 DVSS_B.t356 1098.13624996016
Riso12957 DVSS_B.t258 DVSS_B.t358 165.05687821457
Riso12958 DVSS_B.t258 DVSS_B.t36 105610.277788843
Riso12959 DVSS_B.t258 DVSS_B.t360 74.4560423420983
Riso12960 DVSS_B.t258 DVSS_B.t364 207.055745157195
Riso12961 DVSS_B.t258 DVSS_B.t366 221.603620993408
Riso12962 DVSS_B.t258 DVSS_B.t37 1641.69978473303
Riso12963 DVSS_B.t258 DVSS_B.t509 221.603620993408
Riso12964 DVSS_B.t258 DVSS_B.t515 152.499054947194
Riso12965 DVSS_B.t258 DVSS_B.t525 2120.58256833233
Riso12966 DVSS_B.t258 DVSS_B.t529 40.2286339578654
Riso12967 DVSS_B.t258 DVSS_B.t531 152.499054947194
Riso12968 DVSS_B.t258 DVSS_B.t59 10201.9878497633
Riso12969 DVSS_B.t258 DVSS_B.t60 73.9548992981842
Riso12970 DVSS_B.t258 DVSS_B.t66 172.415494815057
Riso12971 DVSS_B.t258 DVSS_B.t68 420.422602881445
Riso12972 DVSS_B.t258 DVSS_B.t70 84.6433276372939
Riso12973 DVSS_B.t258 DVSS_B.t72 180.675893217245
Riso12974 DVSS_B.t258 DVSS_B.t74 2577.19111973622
Riso12975 DVSS_B.t258 DVSS_B.t76 521.655961169071
Riso12976 DVSS_B.t258 DVSS_B.t80 490.932358035521
Riso12977 DVSS_B.t258 DVSS_B.t82 346.8996734152
Riso12978 DVSS_B.t258 DVSS_B.t84 2120.58256833233
Riso12979 DVSS_B.t258 DVSS_B.t89 13296.5146737282
Riso12980 DVSS_B.t258 DVSS_B.t90 132.676898823758
Riso12981 DVSS_B.t258 DVSS_B.t94 74.4560423420983
Riso12982 DVSS_B.t258 DVSS_B.t96 148.846166999463
Riso12983 DVSS_B.t258 VSS_A 1830.44187256979
Riso12984 DVSS_B.t258 VSS_B 247.129388396584
Riso12985 DVSS_B.t259 DVSS_B.t260 8099.49376769584
Riso12986 DVSS_B.t259 DVSS_B.t264 18626.7956565481
Riso12987 DVSS_B.t259 DVSS_B.t266 19294.7038607015
Riso12988 DVSS_B.t259 DVSS_B.t267 3105637.68101459
Riso12989 DVSS_B.t259 DVSS_B.t268 26440.0307703077
Riso12990 DVSS_B.t259 DVSS_B.t271 27092.183250542
Riso12991 DVSS_B.t259 DVSS_B.t273 11589.2379347927
Riso12992 DVSS_B.t259 DVSS_B.t275 23342.1869750397
Riso12993 DVSS_B.t259 DVSS_B.t277 15274.2582871938
Riso12994 DVSS_B.t259 DVSS_B.t279 12305.1715296435
Riso12995 DVSS_B.t259 DVSS_B.t281 19228.8311613681
Riso12996 DVSS_B.t259 DVSS_B.t283 21845.838814795
Riso12997 DVSS_B.t259 DVSS_B.t285 9247.19366571672
Riso12998 DVSS_B.t259 DVSS_B.t287 10400.459422215
Riso12999 DVSS_B.t259 DVSS_B.t288 1970367.90354018
Riso13000 DVSS_B.t259 DVSS_B.t289 17376.9302411812
Riso13001 DVSS_B.t259 DVSS_B.t291 18890.2992751647
Riso13002 DVSS_B.t259 DVSS_B.t293 25814.7164644003
Riso13003 DVSS_B.t259 DVSS_B.t295 9135.45904244295
Riso13004 DVSS_B.t259 DVSS_B.t297 16003.8170839232
Riso13005 DVSS_B.t259 DVSS_B.t299 24685.4605453211
Riso13006 DVSS_B.t259 DVSS_B.t301 16450.1553130744
Riso13007 DVSS_B.t259 DVSS_B.t302 1865649.40620662
Riso13008 DVSS_B.t259 DVSS_B.t303 16450.1553130744
Riso13009 DVSS_B.t259 DVSS_B.t305 16799.2268104228
Riso13010 DVSS_B.t259 DVSS_B.t322 112261.842450539
Riso13011 DVSS_B.t259 DVSS_B.t325 1719133.72711855
Riso13012 DVSS_B.t259 DVSS_B.t326 15528.6834245137
Riso13013 DVSS_B.t259 DVSS_B.t329 19007.2798924397
Riso13014 DVSS_B.t259 DVSS_B.t331 36338.149174577
Riso13015 DVSS_B.t259 DVSS_B.t333 33451.8707530649
Riso13016 DVSS_B.t259 DVSS_B.t335 17885.2413759014
Riso13017 DVSS_B.t259 DVSS_B.t337 17437.0801305571
Riso13018 DVSS_B.t259 DVSS_B.t339 36338.149174577
Riso13019 DVSS_B.t259 DVSS_B.t341 33451.8707530649
Riso13020 DVSS_B.t259 DVSS_B.t343 15273.2745037165
Riso13021 DVSS_B.t259 DVSS_B.t345 8814186.32824554
Riso13022 DVSS_B.t259 DVSS_B.t346 31869.1975086765
Riso13023 DVSS_B.t259 DVSS_B.t348 11589.2379347927
Riso13024 DVSS_B.t259 DVSS_B.t35 10201.9878497633
Riso13025 DVSS_B.t259 DVSS_B.t350 27092.183250542
Riso13026 DVSS_B.t259 DVSS_B.t352 26440.0307703077
Riso13027 DVSS_B.t259 DVSS_B.t355 28880797.9865076
Riso13028 DVSS_B.t259 DVSS_B.t356 47408.0278772762
Riso13029 DVSS_B.t259 DVSS_B.t358 18626.7956565481
Riso13030 DVSS_B.t259 DVSS_B.t36 3873843.3784029
Riso13031 DVSS_B.t259 DVSS_B.t360 14791.1899397154
Riso13032 DVSS_B.t259 DVSS_B.t364 19228.8311613681
Riso13033 DVSS_B.t259 DVSS_B.t366 18293.5328957667
Riso13034 DVSS_B.t259 DVSS_B.t37 60408.8262950235
Riso13035 DVSS_B.t259 DVSS_B.t509 18293.5328957667
Riso13036 DVSS_B.t259 DVSS_B.t515 13947.6025917908
Riso13037 DVSS_B.t259 DVSS_B.t525 92075.82662429
Riso13038 DVSS_B.t259 DVSS_B.t529 11270.3326320032
Riso13039 DVSS_B.t259 DVSS_B.t531 13947.6025917908
Riso13040 DVSS_B.t259 DVSS_B.t59 181677.360619455
Riso13041 DVSS_B.t259 DVSS_B.t60 8151.72033113199
Riso13042 DVSS_B.t259 DVSS_B.t66 15036.8696187872
Riso13043 DVSS_B.t259 DVSS_B.t68 24685.4605453211
Riso13044 DVSS_B.t259 DVSS_B.t70 15274.2582871938
Riso13045 DVSS_B.t259 DVSS_B.t72 19088.8153689374
Riso13046 DVSS_B.t259 DVSS_B.t74 112261.842450539
Riso13047 DVSS_B.t259 DVSS_B.t76 27192.7006750482
Riso13048 DVSS_B.t259 DVSS_B.t80 26668.9694226827
Riso13049 DVSS_B.t259 DVSS_B.t82 21845.838814795
Riso13050 DVSS_B.t259 DVSS_B.t84 92075.82662429
Riso13051 DVSS_B.t259 DVSS_B.t89 1719133.72711855
Riso13052 DVSS_B.t259 DVSS_B.t90 17055.7207303611
Riso13053 DVSS_B.t259 DVSS_B.t94 14791.1899397154
Riso13054 DVSS_B.t259 DVSS_B.t96 17936.7292764332
Riso13055 DVSS_B.t259 VSS_A 63828.9047686067
Riso13056 DVSS_B.t259 VSS_B 7113.7792213636
Riso13057 DVSS_B.t260 DVSS_B.t264 197.484595998464
Riso13058 DVSS_B.t260 DVSS_B.t266 227.919609065341
Riso13059 DVSS_B.t260 DVSS_B.t267 61456.3722238013
Riso13060 DVSS_B.t260 DVSS_B.t268 466.281427698003
Riso13061 DVSS_B.t260 DVSS_B.t271 457.545651349372
Riso13062 DVSS_B.t260 DVSS_B.t273 86.5276290482057
Riso13063 DVSS_B.t260 DVSS_B.t275 304.525612104377
Riso13064 DVSS_B.t260 DVSS_B.t277 108.945647554175
Riso13065 DVSS_B.t260 DVSS_B.t279 64.0976883711976
Riso13066 DVSS_B.t260 DVSS_B.t281 239.358913603908
Riso13067 DVSS_B.t260 DVSS_B.t283 274.316364113753
Riso13068 DVSS_B.t260 DVSS_B.t285 63.3736811975
Riso13069 DVSS_B.t260 DVSS_B.t287 74.2739785645732
Riso13070 DVSS_B.t260 DVSS_B.t288 24330.4508558166
Riso13071 DVSS_B.t260 DVSS_B.t289 181.350375513102
Riso13072 DVSS_B.t260 DVSS_B.t291 247.218186126518
Riso13073 DVSS_B.t260 DVSS_B.t293 365.395880187529
Riso13074 DVSS_B.t260 DVSS_B.t295 39.3363380188871
Riso13075 DVSS_B.t260 DVSS_B.t297 147.70733470254
Riso13076 DVSS_B.t260 DVSS_B.t299 335.17142526444
Riso13077 DVSS_B.t260 DVSS_B.t301 244.536646397758
Riso13078 DVSS_B.t260 DVSS_B.t302 30603.702423867
Riso13079 DVSS_B.t260 DVSS_B.t303 244.536646397758
Riso13080 DVSS_B.t260 DVSS_B.t305 164.72813396529
Riso13081 DVSS_B.t260 DVSS_B.t322 2097.42989764622
Riso13082 DVSS_B.t260 DVSS_B.t325 16374.3886373088
Riso13083 DVSS_B.t260 DVSS_B.t326 120.490989435447
Riso13084 DVSS_B.t260 DVSS_B.t329 439.820902147983
Riso13085 DVSS_B.t260 DVSS_B.t331 846.537721515256
Riso13086 DVSS_B.t260 DVSS_B.t333 801.862597018927
Riso13087 DVSS_B.t260 DVSS_B.t335 427.995612653555
Riso13088 DVSS_B.t260 DVSS_B.t337 388.704732276006
Riso13089 DVSS_B.t260 DVSS_B.t339 846.537721515256
Riso13090 DVSS_B.t260 DVSS_B.t341 801.862597018927
Riso13091 DVSS_B.t260 DVSS_B.t343 344.24075721018
Riso13092 DVSS_B.t260 DVSS_B.t345 170086.44874765
Riso13093 DVSS_B.t260 DVSS_B.t346 616.205302988533
Riso13094 DVSS_B.t260 DVSS_B.t348 86.5276290482057
Riso13095 DVSS_B.t260 DVSS_B.t35 46.5828304440546
Riso13096 DVSS_B.t260 DVSS_B.t350 457.545651349372
Riso13097 DVSS_B.t260 DVSS_B.t352 466.281427698003
Riso13098 DVSS_B.t260 DVSS_B.t355 555484.471992351
Riso13099 DVSS_B.t260 DVSS_B.t356 901.0188186106
Riso13100 DVSS_B.t260 DVSS_B.t358 197.484595998464
Riso13101 DVSS_B.t260 DVSS_B.t36 85830.1975318064
Riso13102 DVSS_B.t260 DVSS_B.t360 97.070356338543
Riso13103 DVSS_B.t260 DVSS_B.t364 239.358913603908
Riso13104 DVSS_B.t260 DVSS_B.t366 250.881994515347
Riso13105 DVSS_B.t260 DVSS_B.t37 1334.25846881591
Riso13106 DVSS_B.t260 DVSS_B.t509 250.881994515347
Riso13107 DVSS_B.t260 DVSS_B.t515 115.005629985564
Riso13108 DVSS_B.t260 DVSS_B.t525 1730.84245231961
Riso13109 DVSS_B.t260 DVSS_B.t529 54.8323913091115
Riso13110 DVSS_B.t260 DVSS_B.t531 115.005629985564
Riso13111 DVSS_B.t260 DVSS_B.t59 8099.49376769584
Riso13112 DVSS_B.t260 DVSS_B.t60 53.7797988369364
Riso13113 DVSS_B.t260 DVSS_B.t66 130.970490568235
Riso13114 DVSS_B.t260 DVSS_B.t68 335.17142526444
Riso13115 DVSS_B.t260 DVSS_B.t70 108.945647554175
Riso13116 DVSS_B.t260 DVSS_B.t72 213.680598999414
Riso13117 DVSS_B.t260 DVSS_B.t74 2097.42989764622
Riso13118 DVSS_B.t260 DVSS_B.t76 420.022180714473
Riso13119 DVSS_B.t260 DVSS_B.t80 394.112820536507
Riso13120 DVSS_B.t260 DVSS_B.t82 274.316364113753
Riso13121 DVSS_B.t260 DVSS_B.t84 1730.84245231961
Riso13122 DVSS_B.t260 DVSS_B.t89 16374.3886373088
Riso13123 DVSS_B.t260 DVSS_B.t90 162.399697753047
Riso13124 DVSS_B.t260 DVSS_B.t94 97.070356338543
Riso13125 DVSS_B.t260 DVSS_B.t96 180.14837815302
Riso13126 DVSS_B.t260 VSS_A 1500.40905814864
Riso13127 DVSS_B.t260 VSS_B 200.928239272637
Riso13128 DVSS_B.t263 DVSS_B.t357 66.3487
Riso13129 DVSS_B.t264 DVSS_B.t266 41.4323828810664
Riso13130 DVSS_B.t264 DVSS_B.t267 152861.724464543
Riso13131 DVSS_B.t264 DVSS_B.t268 1202.4735978331
Riso13132 DVSS_B.t264 DVSS_B.t271 1198.30280881897
Riso13133 DVSS_B.t264 DVSS_B.t273 370.904646089043
Riso13134 DVSS_B.t264 DVSS_B.t275 896.718811409304
Riso13135 DVSS_B.t264 DVSS_B.t277 75.4966833770685
Riso13136 DVSS_B.t264 DVSS_B.t279 131.492176180475
Riso13137 DVSS_B.t264 DVSS_B.t281 46.7710700971552
Riso13138 DVSS_B.t264 DVSS_B.t283 826.319379644692
Riso13139 DVSS_B.t264 DVSS_B.t285 296.655670972611
Riso13140 DVSS_B.t264 DVSS_B.t287 332.6617452678
Riso13141 DVSS_B.t264 DVSS_B.t288 76066.3971647328
Riso13142 DVSS_B.t264 DVSS_B.t289 610.402445272832
Riso13143 DVSS_B.t264 DVSS_B.t291 51.8257131020259
Riso13144 DVSS_B.t264 DVSS_B.t293 1030.72588892974
Riso13145 DVSS_B.t264 DVSS_B.t295 181.799616718609
Riso13146 DVSS_B.t264 DVSS_B.t297 535.575649681531
Riso13147 DVSS_B.t264 DVSS_B.t299 965.580995493636
Riso13148 DVSS_B.t264 DVSS_B.t301 61.3101704014127
Riso13149 DVSS_B.t264 DVSS_B.t302 8729.58754922703
Riso13150 DVSS_B.t264 DVSS_B.t303 61.3101704014127
Riso13151 DVSS_B.t264 DVSS_B.t305 574.853962228456
Riso13152 DVSS_B.t264 DVSS_B.t322 5185.85534553092
Riso13153 DVSS_B.t264 DVSS_B.t325 6262.36927038814
Riso13154 DVSS_B.t264 DVSS_B.t326 64.6789904678678
Riso13155 DVSS_B.t264 DVSS_B.t329 1018.21902391489
Riso13156 DVSS_B.t264 DVSS_B.t331 1973.61236208347
Riso13157 DVSS_B.t264 DVSS_B.t333 1878.86505176903
Riso13158 DVSS_B.t264 DVSS_B.t335 995.964686972137
Riso13159 DVSS_B.t264 DVSS_B.t337 905.920169904085
Riso13160 DVSS_B.t264 DVSS_B.t339 1973.61236208347
Riso13161 DVSS_B.t264 DVSS_B.t341 1878.86505176903
Riso13162 DVSS_B.t264 DVSS_B.t343 808.949169307759
Riso13163 DVSS_B.t264 DVSS_B.t345 392929.446531404
Riso13164 DVSS_B.t264 DVSS_B.t346 1417.39723654349
Riso13165 DVSS_B.t264 DVSS_B.t348 370.904646089043
Riso13166 DVSS_B.t264 DVSS_B.t35 165.05687821457
Riso13167 DVSS_B.t264 DVSS_B.t350 1198.30280881897
Riso13168 DVSS_B.t264 DVSS_B.t352 1202.4735978331
Riso13169 DVSS_B.t264 DVSS_B.t355 1292235.3169633
Riso13170 DVSS_B.t264 DVSS_B.t356 2148.5023138235
Riso13171 DVSS_B.t264 DVSS_B.t358 0.0669507622208545
Riso13172 DVSS_B.t264 DVSS_B.t36 212899.680799305
Riso13173 DVSS_B.t264 DVSS_B.t360 87.6187198252492
Riso13174 DVSS_B.t264 DVSS_B.t364 46.7710700971552
Riso13175 DVSS_B.t264 DVSS_B.t366 56.2021818384737
Riso13176 DVSS_B.t264 DVSS_B.t37 3312.2307745694
Riso13177 DVSS_B.t264 DVSS_B.t509 56.2021818384737
Riso13178 DVSS_B.t264 DVSS_B.t515 452.405428141758
Riso13179 DVSS_B.t264 DVSS_B.t525 4224.04617910023
Riso13180 DVSS_B.t264 DVSS_B.t529 148.080806092254
Riso13181 DVSS_B.t264 DVSS_B.t531 452.405428141758
Riso13182 DVSS_B.t264 DVSS_B.t59 18626.7956565481
Riso13183 DVSS_B.t264 DVSS_B.t60 263.114464325832
Riso13184 DVSS_B.t264 DVSS_B.t66 494.290952997161
Riso13185 DVSS_B.t264 DVSS_B.t68 965.580995493636
Riso13186 DVSS_B.t264 DVSS_B.t70 75.4966833770685
Riso13187 DVSS_B.t264 DVSS_B.t72 36.1320071891723
Riso13188 DVSS_B.t264 DVSS_B.t74 5185.85534553092
Riso13189 DVSS_B.t264 DVSS_B.t76 1139.1324347422
Riso13190 DVSS_B.t264 DVSS_B.t80 1089.5544009286
Riso13191 DVSS_B.t264 DVSS_B.t82 826.319379644692
Riso13192 DVSS_B.t264 DVSS_B.t84 4224.04617910023
Riso13193 DVSS_B.t264 DVSS_B.t89 6262.36927038814
Riso13194 DVSS_B.t264 DVSS_B.t90 41.876057778947
Riso13195 DVSS_B.t264 DVSS_B.t94 87.6187198252492
Riso13196 DVSS_B.t264 DVSS_B.t96 36.3018354734837
Riso13197 DVSS_B.t264 VSS_A 3462.60763700354
Riso13198 DVSS_B.t264 VSS_B 457.042252325603
Riso13199 DVSS_B.t265 DVSS_B.t363 66.3487
Riso13200 DVSS_B.t266 DVSS_B.t267 162503.362388323
Riso13201 DVSS_B.t266 DVSS_B.t268 1284.48854080193
Riso13202 DVSS_B.t266 DVSS_B.t271 1282.41505295747
Riso13203 DVSS_B.t266 DVSS_B.t273 413.569554202947
Riso13204 DVSS_B.t266 DVSS_B.t275 970.549336675552
Riso13205 DVSS_B.t266 DVSS_B.t277 94.9167779741231
Riso13206 DVSS_B.t266 DVSS_B.t279 158.751118895686
Riso13207 DVSS_B.t266 DVSS_B.t281 34.3731374145579
Riso13208 DVSS_B.t266 DVSS_B.t283 895.948253129192
Riso13209 DVSS_B.t266 DVSS_B.t285 333.092877667317
Riso13210 DVSS_B.t266 DVSS_B.t287 372.208667222645
Riso13211 DVSS_B.t266 DVSS_B.t288 82611.4739982678
Riso13212 DVSS_B.t266 DVSS_B.t289 667.676121839881
Riso13213 DVSS_B.t266 DVSS_B.t291 38.4726731151985
Riso13214 DVSS_B.t266 DVSS_B.t293 1111.51376120472
Riso13215 DVSS_B.t266 DVSS_B.t295 212.287023272873
Riso13216 DVSS_B.t266 DVSS_B.t297 589.416945263892
Riso13217 DVSS_B.t266 DVSS_B.t299 1043.18869048351
Riso13218 DVSS_B.t266 DVSS_B.t301 46.780126226811
Riso13219 DVSS_B.t266 DVSS_B.t302 6800.24213876067
Riso13220 DVSS_B.t266 DVSS_B.t303 46.780126226811
Riso13221 DVSS_B.t266 DVSS_B.t305 630.687802164506
Riso13222 DVSS_B.t266 DVSS_B.t322 5508.91057242201
Riso13223 DVSS_B.t266 DVSS_B.t325 8002.91344454062
Riso13224 DVSS_B.t266 DVSS_B.t326 82.0885388395866
Riso13225 DVSS_B.t266 DVSS_B.t329 1073.21585286728
Riso13226 DVSS_B.t266 DVSS_B.t331 2080.59450478278
Riso13227 DVSS_B.t266 DVSS_B.t333 1979.79905726273
Riso13228 DVSS_B.t266 DVSS_B.t335 1049.08570413196
Riso13229 DVSS_B.t266 DVSS_B.t337 956.393960265213
Riso13230 DVSS_B.t266 DVSS_B.t339 2080.59450478278
Riso13231 DVSS_B.t266 DVSS_B.t341 1979.79905726273
Riso13232 DVSS_B.t266 DVSS_B.t343 854.286782911363
Riso13233 DVSS_B.t266 DVSS_B.t345 415933.579486965
Riso13234 DVSS_B.t266 DVSS_B.t346 1500.05408974299
Riso13235 DVSS_B.t266 DVSS_B.t348 413.569554202947
Riso13236 DVSS_B.t266 DVSS_B.t35 194.950282763221
Riso13237 DVSS_B.t266 DVSS_B.t350 1282.41505295747
Riso13238 DVSS_B.t266 DVSS_B.t352 1284.48854080193
Riso13239 DVSS_B.t266 DVSS_B.t355 1368369.85280467
Riso13240 DVSS_B.t266 DVSS_B.t356 2277.97077852301
Riso13241 DVSS_B.t266 DVSS_B.t358 41.4323828810664
Riso13242 DVSS_B.t266 DVSS_B.t36 226077.977707052
Riso13243 DVSS_B.t266 DVSS_B.t360 109.090438368552
Riso13244 DVSS_B.t266 DVSS_B.t364 34.3731374145579
Riso13245 DVSS_B.t266 DVSS_B.t366 42.1368545735411
Riso13246 DVSS_B.t266 DVSS_B.t37 3517.84507675175
Riso13247 DVSS_B.t266 DVSS_B.t509 42.1368545735411
Riso13248 DVSS_B.t266 DVSS_B.t515 501.086289805427
Riso13249 DVSS_B.t266 DVSS_B.t525 4484.05060352092
Riso13250 DVSS_B.t266 DVSS_B.t529 176.854954431604
Riso13251 DVSS_B.t266 DVSS_B.t531 501.086289805427
Riso13252 DVSS_B.t266 DVSS_B.t59 19294.7038607015
Riso13253 DVSS_B.t266 DVSS_B.t60 296.495015805917
Riso13254 DVSS_B.t266 DVSS_B.t66 545.709058089536
Riso13255 DVSS_B.t266 DVSS_B.t68 1043.18869048351
Riso13256 DVSS_B.t266 DVSS_B.t70 94.9167779741231
Riso13257 DVSS_B.t266 DVSS_B.t72 35.4891836806249
Riso13258 DVSS_B.t266 DVSS_B.t74 5508.91057242201
Riso13259 DVSS_B.t266 DVSS_B.t76 1223.76750438314
Riso13260 DVSS_B.t266 DVSS_B.t80 1172.74346760215
Riso13261 DVSS_B.t266 DVSS_B.t82 895.948253129192
Riso13262 DVSS_B.t266 DVSS_B.t84 4484.05060352092
Riso13263 DVSS_B.t266 DVSS_B.t89 8002.91344454062
Riso13264 DVSS_B.t266 DVSS_B.t90 54.7087004546916
Riso13265 DVSS_B.t266 DVSS_B.t94 109.090438368552
Riso13266 DVSS_B.t266 DVSS_B.t96 47.8963494175188
Riso13267 DVSS_B.t266 VSS_A 3647.05326907738
Riso13268 DVSS_B.t266 VSS_B 477.964857302939
Riso13269 DVSS_B.t267 DVSS_B.t268 5058.48080454888
Riso13270 DVSS_B.t267 DVSS_B.t271 5970.94827716488
Riso13271 DVSS_B.t267 DVSS_B.t273 43692.049877249
Riso13272 DVSS_B.t267 DVSS_B.t275 14162.0080117691
Riso13273 DVSS_B.t267 DVSS_B.t277 115873.973485967
Riso13274 DVSS_B.t267 DVSS_B.t279 90314.0663627717
Riso13275 DVSS_B.t267 DVSS_B.t281 164313.772342016
Riso13276 DVSS_B.t267 DVSS_B.t283 15867.193088301
Riso13277 DVSS_B.t267 DVSS_B.t285 48978.470842794
Riso13278 DVSS_B.t267 DVSS_B.t287 46579.9448017665
Riso13279 DVSS_B.t267 DVSS_B.t288 2367726.02309182
Riso13280 DVSS_B.t267 DVSS_B.t289 24140.9189869209
Riso13281 DVSS_B.t267 DVSS_B.t291 163855.22726995
Riso13282 DVSS_B.t267 DVSS_B.t293 10943.2821036243
Riso13283 DVSS_B.t267 DVSS_B.t295 68367.2578632711
Riso13284 DVSS_B.t267 DVSS_B.t297 30389.4490518181
Riso13285 DVSS_B.t267 DVSS_B.t299 12506.4352051707
Riso13286 DVSS_B.t267 DVSS_B.t301 148978.229932331
Riso13287 DVSS_B.t267 DVSS_B.t302 17576266.2533824
Riso13288 DVSS_B.t267 DVSS_B.t303 148978.229932331
Riso13289 DVSS_B.t267 DVSS_B.t305 27177.4711803246
Riso13290 DVSS_B.t267 DVSS_B.t322 14762.400478494
Riso13291 DVSS_B.t267 DVSS_B.t325 14152804.1978244
Riso13292 DVSS_B.t267 DVSS_B.t326 119899.559659017
Riso13293 DVSS_B.t267 DVSS_B.t329 8671.87692698491
Riso13294 DVSS_B.t267 DVSS_B.t331 15229.157509769
Riso13295 DVSS_B.t267 DVSS_B.t333 14453.7206739
Riso13296 DVSS_B.t267 DVSS_B.t335 8310.55486276844
Riso13297 DVSS_B.t267 DVSS_B.t337 7272.95754713929
Riso13298 DVSS_B.t267 DVSS_B.t339 15229.157509769
Riso13299 DVSS_B.t267 DVSS_B.t341 14453.7206739
Riso13300 DVSS_B.t267 DVSS_B.t343 6187.63947026764
Riso13301 DVSS_B.t267 DVSS_B.t345 2621822.29853915
Riso13302 DVSS_B.t267 DVSS_B.t346 10300.2914364353
Riso13303 DVSS_B.t267 DVSS_B.t348 43692.049877249
Riso13304 DVSS_B.t267 DVSS_B.t35 75558.9510393105
Riso13305 DVSS_B.t267 DVSS_B.t350 5970.94827716488
Riso13306 DVSS_B.t267 DVSS_B.t351 66.3487
Riso13307 DVSS_B.t267 DVSS_B.t352 5058.48080454888
Riso13308 DVSS_B.t267 DVSS_B.t355 7610132.60040092
Riso13309 DVSS_B.t267 DVSS_B.t356 8873.4418904114
Riso13310 DVSS_B.t267 DVSS_B.t358 152861.724464543
Riso13311 DVSS_B.t267 DVSS_B.t36 1484945.72263647
Riso13312 DVSS_B.t267 DVSS_B.t360 110606.736119002
Riso13313 DVSS_B.t267 DVSS_B.t364 164313.772342016
Riso13314 DVSS_B.t267 DVSS_B.t366 161072.519727831
Riso13315 DVSS_B.t267 DVSS_B.t37 23006.2204247602
Riso13316 DVSS_B.t267 DVSS_B.t509 161072.519727831
Riso13317 DVSS_B.t267 DVSS_B.t515 37128.2325259869
Riso13318 DVSS_B.t267 DVSS_B.t525 13558.4609670286
Riso13319 DVSS_B.t267 DVSS_B.t529 82922.7293864509
Riso13320 DVSS_B.t267 DVSS_B.t531 37128.2325259869
Riso13321 DVSS_B.t267 DVSS_B.t59 3105637.68101459
Riso13322 DVSS_B.t267 DVSS_B.t60 50702.6789070936
Riso13323 DVSS_B.t267 DVSS_B.t66 33729.4466371033
Riso13324 DVSS_B.t267 DVSS_B.t68 12506.4352051707
Riso13325 DVSS_B.t267 DVSS_B.t70 115873.973485967
Riso13326 DVSS_B.t267 DVSS_B.t72 158597.655187022
Riso13327 DVSS_B.t267 DVSS_B.t74 14762.400478494
Riso13328 DVSS_B.t267 DVSS_B.t76 8186.90117207112
Riso13329 DVSS_B.t267 DVSS_B.t80 9498.89595201959
Riso13330 DVSS_B.t267 DVSS_B.t82 15867.193088301
Riso13331 DVSS_B.t267 DVSS_B.t84 13558.4609670286
Riso13332 DVSS_B.t267 DVSS_B.t89 14152804.1978244
Riso13333 DVSS_B.t267 DVSS_B.t90 137218.323477462
Riso13334 DVSS_B.t267 DVSS_B.t94 110606.736119002
Riso13335 DVSS_B.t267 DVSS_B.t96 145619.002563196
Riso13336 DVSS_B.t267 VSS_A 30404.5597891915
Riso13337 DVSS_B.t267 VSS_B 4796.83910509682
Riso13338 DVSS_B.t268 DVSS_B.t271 34.2734680544342
Riso13339 DVSS_B.t268 DVSS_B.t273 309.421207980297
Riso13340 DVSS_B.t268 DVSS_B.t275 87.5341738555542
Riso13341 DVSS_B.t268 DVSS_B.t277 896.825171554606
Riso13342 DVSS_B.t268 DVSS_B.t279 690.627690878538
Riso13343 DVSS_B.t268 DVSS_B.t281 1302.09880446329
Riso13344 DVSS_B.t268 DVSS_B.t283 99.4418048016921
Riso13345 DVSS_B.t268 DVSS_B.t285 356.734886748779
Riso13346 DVSS_B.t268 DVSS_B.t287 334.420645368493
Riso13347 DVSS_B.t268 DVSS_B.t288 15683.044694889
Riso13348 DVSS_B.t268 DVSS_B.t289 159.27238581442
Riso13349 DVSS_B.t268 DVSS_B.t291 1301.78926433233
Riso13350 DVSS_B.t268 DVSS_B.t293 65.8582834743072
Riso13351 DVSS_B.t268 DVSS_B.t295 519.551757694373
Riso13352 DVSS_B.t268 DVSS_B.t297 204.957454616503
Riso13353 DVSS_B.t268 DVSS_B.t299 76.2609636557803
Riso13354 DVSS_B.t268 DVSS_B.t301 1192.12601487491
Riso13355 DVSS_B.t268 DVSS_B.t302 141531.358166789
Riso13356 DVSS_B.t268 DVSS_B.t303 1192.12601487491
Riso13357 DVSS_B.t268 DVSS_B.t305 181.26430578774
Riso13358 DVSS_B.t268 DVSS_B.t322 132.934950589459
Riso13359 DVSS_B.t268 DVSS_B.t325 111048.527284968
Riso13360 DVSS_B.t268 DVSS_B.t326 931.322282719418
Riso13361 DVSS_B.t268 DVSS_B.t329 77.9984216105572
Riso13362 DVSS_B.t268 DVSS_B.t331 137.161571567287
Riso13363 DVSS_B.t268 DVSS_B.t333 130.43700253692
Riso13364 DVSS_B.t268 DVSS_B.t335 74.9458312857548
Riso13365 DVSS_B.t268 DVSS_B.t337 65.2958897755434
Riso13366 DVSS_B.t268 DVSS_B.t339 137.161571567287
Riso13367 DVSS_B.t268 DVSS_B.t341 130.43700253692
Riso13368 DVSS_B.t268 DVSS_B.t343 55.6238156125087
Riso13369 DVSS_B.t268 DVSS_B.t345 23409.7491879177
Riso13370 DVSS_B.t268 DVSS_B.t346 91.8482126075223
Riso13371 DVSS_B.t268 DVSS_B.t348 309.421207980297
Riso13372 DVSS_B.t268 DVSS_B.t35 575.256480447287
Riso13373 DVSS_B.t268 DVSS_B.t350 34.2734680544342
Riso13374 DVSS_B.t268 DVSS_B.t352 0.0669389029112396
Riso13375 DVSS_B.t268 DVSS_B.t355 68067.497784545
Riso13376 DVSS_B.t268 DVSS_B.t356 79.6770962622026
Riso13377 DVSS_B.t268 DVSS_B.t358 1202.4735978331
Riso13378 DVSS_B.t268 DVSS_B.t36 13356.8418924837
Riso13379 DVSS_B.t268 DVSS_B.t360 853.153149722079
Riso13380 DVSS_B.t268 DVSS_B.t364 1302.09880446329
Riso13381 DVSS_B.t268 DVSS_B.t366 1282.90511942567
Riso13382 DVSS_B.t268 DVSS_B.t37 206.908701947177
Riso13383 DVSS_B.t268 DVSS_B.t509 1282.90511942567
Riso13384 DVSS_B.t268 DVSS_B.t515 256.331672081193
Riso13385 DVSS_B.t268 DVSS_B.t525 121.994744055913
Riso13386 DVSS_B.t268 DVSS_B.t529 632.628943934657
Riso13387 DVSS_B.t268 DVSS_B.t531 256.331672081193
Riso13388 DVSS_B.t268 DVSS_B.t59 26440.0307703077
Riso13389 DVSS_B.t268 DVSS_B.t60 374.8815524328
Riso13390 DVSS_B.t268 DVSS_B.t66 230.110613906647
Riso13391 DVSS_B.t268 DVSS_B.t68 76.2609636557803
Riso13392 DVSS_B.t268 DVSS_B.t70 896.825171554606
Riso13393 DVSS_B.t268 DVSS_B.t72 1250.52965467099
Riso13394 DVSS_B.t268 DVSS_B.t74 132.934950589459
Riso13395 DVSS_B.t268 DVSS_B.t76 48.0639797405734
Riso13396 DVSS_B.t268 DVSS_B.t80 56.4467987154344
Riso13397 DVSS_B.t268 DVSS_B.t82 99.4418048016921
Riso13398 DVSS_B.t268 DVSS_B.t84 121.994744055913
Riso13399 DVSS_B.t268 DVSS_B.t89 111048.527284968
Riso13400 DVSS_B.t268 DVSS_B.t90 1074.85151390555
Riso13401 DVSS_B.t268 DVSS_B.t94 853.153149722079
Riso13402 DVSS_B.t268 DVSS_B.t96 1142.9792332114
Riso13403 DVSS_B.t268 VSS_A 273.696233166198
Riso13404 DVSS_B.t268 VSS_B 43.864266765509
Riso13405 DVSS_B.t270 DVSS_B.t349 66.3487
Riso13406 DVSS_B.t271 DVSS_B.t273 295.826130987216
Riso13407 DVSS_B.t271 DVSS_B.t275 79.5988515013726
Riso13408 DVSS_B.t271 DVSS_B.t277 887.9834946928
Riso13409 DVSS_B.t271 DVSS_B.t279 680.365763172506
Riso13410 DVSS_B.t271 DVSS_B.t281 1301.24581323202
Riso13411 DVSS_B.t271 DVSS_B.t283 90.8665015225452
Riso13412 DVSS_B.t271 DVSS_B.t285 344.631031888299
Riso13413 DVSS_B.t271 DVSS_B.t287 321.358416056588
Riso13414 DVSS_B.t271 DVSS_B.t288 14568.7896683985
Riso13415 DVSS_B.t271 DVSS_B.t289 148.252747570981
Riso13416 DVSS_B.t271 DVSS_B.t291 1302.18187956251
Riso13417 DVSS_B.t271 DVSS_B.t293 59.3348568916052
Riso13418 DVSS_B.t271 DVSS_B.t295 510.273436099135
Riso13419 DVSS_B.t271 DVSS_B.t297 192.38103102842
Riso13420 DVSS_B.t271 DVSS_B.t299 69.0208083006028
Riso13421 DVSS_B.t271 DVSS_B.t301 1195.63814913661
Riso13422 DVSS_B.t271 DVSS_B.t302 142267.778764012
Riso13423 DVSS_B.t271 DVSS_B.t303 1195.63814913661
Riso13424 DVSS_B.t271 DVSS_B.t305 169.422110220124
Riso13425 DVSS_B.t271 DVSS_B.t322 159.201829390236
Riso13426 DVSS_B.t271 DVSS_B.t325 110523.807786383
Riso13427 DVSS_B.t271 DVSS_B.t326 923.444701167119
Riso13428 DVSS_B.t271 DVSS_B.t329 88.1537175486034
Riso13429 DVSS_B.t271 DVSS_B.t331 156.226900884813
Riso13430 DVSS_B.t271 DVSS_B.t333 148.606010602241
Riso13431 DVSS_B.t271 DVSS_B.t335 84.9030550163693
Riso13432 DVSS_B.t271 DVSS_B.t337 73.8816687694812
Riso13433 DVSS_B.t271 DVSS_B.t339 156.226900884813
Riso13434 DVSS_B.t271 DVSS_B.t341 148.606010602241
Riso13435 DVSS_B.t271 DVSS_B.t343 63.0969121861213
Riso13436 DVSS_B.t271 DVSS_B.t345 26850.1433130199
Riso13437 DVSS_B.t271 DVSS_B.t346 104.666759906442
Riso13438 DVSS_B.t271 DVSS_B.t348 295.826130987216
Riso13439 DVSS_B.t271 DVSS_B.t35 565.520738886817
Riso13440 DVSS_B.t271 DVSS_B.t350 0.0669473663640879
Riso13441 DVSS_B.t271 DVSS_B.t352 34.2734680544342
Riso13442 DVSS_B.t271 DVSS_B.t355 78747.452776825
Riso13443 DVSS_B.t271 DVSS_B.t356 94.0205516073085
Riso13444 DVSS_B.t271 DVSS_B.t358 1198.30280881897
Riso13445 DVSS_B.t271 DVSS_B.t36 14989.6634295741
Riso13446 DVSS_B.t271 DVSS_B.t360 843.587769387361
Riso13447 DVSS_B.t271 DVSS_B.t364 1301.24581323202
Riso13448 DVSS_B.t271 DVSS_B.t366 1284.48928967806
Riso13449 DVSS_B.t271 DVSS_B.t37 232.204689527914
Riso13450 DVSS_B.t271 DVSS_B.t509 1284.48928967806
Riso13451 DVSS_B.t271 DVSS_B.t515 242.74353177782
Riso13452 DVSS_B.t271 DVSS_B.t525 145.485618953261
Riso13453 DVSS_B.t271 DVSS_B.t529 622.553521818353
Riso13454 DVSS_B.t271 DVSS_B.t531 242.74353177782
Riso13455 DVSS_B.t271 DVSS_B.t59 27092.183250542
Riso13456 DVSS_B.t271 DVSS_B.t60 364.177203165801
Riso13457 DVSS_B.t271 DVSS_B.t66 216.934107735306
Riso13458 DVSS_B.t271 DVSS_B.t68 69.0208083006028
Riso13459 DVSS_B.t271 DVSS_B.t70 887.9834946928
Riso13460 DVSS_B.t271 DVSS_B.t72 1247.33184652899
Riso13461 DVSS_B.t271 DVSS_B.t74 159.201829390236
Riso13462 DVSS_B.t271 DVSS_B.t76 42.9365947198253
Riso13463 DVSS_B.t271 DVSS_B.t80 50.6344603178186
Riso13464 DVSS_B.t271 DVSS_B.t82 90.8665015225452
Riso13465 DVSS_B.t271 DVSS_B.t84 145.485618953261
Riso13466 DVSS_B.t271 DVSS_B.t89 110523.807786383
Riso13467 DVSS_B.t271 DVSS_B.t90 1069.31055322979
Riso13468 DVSS_B.t271 DVSS_B.t94 843.587769387361
Riso13469 DVSS_B.t271 DVSS_B.t96 1138.02219923121
Riso13470 DVSS_B.t271 VSS_A 309.067001248773
Riso13471 DVSS_B.t271 VSS_B 49.6856131888311
Riso13472 DVSS_B.t272 DVSS_B.t286 66.3487
Riso13473 DVSS_B.t272 DVSS_B.t347 66.3487
Riso13474 DVSS_B.t273 DVSS_B.t275 166.975895614226
Riso13475 DVSS_B.t273 DVSS_B.t277 232.937979675356
Riso13476 DVSS_B.t273 DVSS_B.t279 152.362531404108
Riso13477 DVSS_B.t273 DVSS_B.t281 427.631561340154
Riso13478 DVSS_B.t273 DVSS_B.t283 146.431348427716
Riso13479 DVSS_B.t273 DVSS_B.t285 47.617886767889
Riso13480 DVSS_B.t273 DVSS_B.t287 40.5736441198819
Riso13481 DVSS_B.t273 DVSS_B.t288 12497.2493486506
Riso13482 DVSS_B.t273 DVSS_B.t289 86.2531813066918
Riso13483 DVSS_B.t273 DVSS_B.t291 435.4814869732
Riso13484 DVSS_B.t273 DVSS_B.t293 211.617833773057
Riso13485 DVSS_B.t273 DVSS_B.t295 100.695385436343
Riso13486 DVSS_B.t273 DVSS_B.t297 65.8351296657675
Riso13487 DVSS_B.t273 DVSS_B.t299 188.846313871172
Riso13488 DVSS_B.t273 DVSS_B.t301 417.088687467171
Riso13489 DVSS_B.t273 DVSS_B.t302 51133.9026799483
Riso13490 DVSS_B.t273 DVSS_B.t303 417.088687467171
Riso13491 DVSS_B.t273 DVSS_B.t305 75.8262361345515
Riso13492 DVSS_B.t273 DVSS_B.t322 1438.63959056653
Riso13493 DVSS_B.t273 DVSS_B.t325 32376.6901515752
Riso13494 DVSS_B.t273 DVSS_B.t326 251.082048960639
Riso13495 DVSS_B.t273 DVSS_B.t329 355.118492416369
Riso13496 DVSS_B.t273 DVSS_B.t331 680.068236140363
Riso13497 DVSS_B.t273 DVSS_B.t333 649.478458257071
Riso13498 DVSS_B.t273 DVSS_B.t335 348.785720946574
Riso13499 DVSS_B.t273 DVSS_B.t337 307.999082014781
Riso13500 DVSS_B.t273 DVSS_B.t339 680.068236140363
Riso13501 DVSS_B.t273 DVSS_B.t341 649.478458257071
Riso13502 DVSS_B.t273 DVSS_B.t343 272.220887797599
Riso13503 DVSS_B.t273 DVSS_B.t345 128216.634350057
Riso13504 DVSS_B.t273 DVSS_B.t346 467.542035500499
Riso13505 DVSS_B.t273 DVSS_B.t348 0.0669641777164577
Riso13506 DVSS_B.t273 DVSS_B.t35 116.441358192348
Riso13507 DVSS_B.t273 DVSS_B.t350 295.826130987216
Riso13508 DVSS_B.t273 DVSS_B.t352 309.421207980297
Riso13509 DVSS_B.t273 DVSS_B.t355 414426.676197562
Riso13510 DVSS_B.t273 DVSS_B.t356 648.706036203282
Riso13511 DVSS_B.t273 DVSS_B.t358 370.904646089043
Riso13512 DVSS_B.t273 DVSS_B.t36 65676.8406030758
Riso13513 DVSS_B.t273 DVSS_B.t360 213.108255668795
Riso13514 DVSS_B.t273 DVSS_B.t364 427.631561340154
Riso13515 DVSS_B.t273 DVSS_B.t366 436.44000586396
Riso13516 DVSS_B.t273 DVSS_B.t37 1019.39484448801
Riso13517 DVSS_B.t273 DVSS_B.t509 436.44000586396
Riso13518 DVSS_B.t273 DVSS_B.t515 48.2052231232574
Riso13519 DVSS_B.t273 DVSS_B.t525 1207.51937440318
Riso13520 DVSS_B.t273 DVSS_B.t529 133.712532345989
Riso13521 DVSS_B.t273 DVSS_B.t531 48.2052231232574
Riso13522 DVSS_B.t273 DVSS_B.t59 11589.2379347927
Riso13523 DVSS_B.t273 DVSS_B.t60 55.3336109699856
Riso13524 DVSS_B.t273 DVSS_B.t66 56.5755788823354
Riso13525 DVSS_B.t273 DVSS_B.t68 188.846313871172
Riso13526 DVSS_B.t273 DVSS_B.t70 232.937979675356
Riso13527 DVSS_B.t273 DVSS_B.t72 394.276591577843
Riso13528 DVSS_B.t273 DVSS_B.t74 1438.63959056653
Riso13529 DVSS_B.t273 DVSS_B.t76 257.134515417272
Riso13530 DVSS_B.t273 DVSS_B.t80 234.664817520121
Riso13531 DVSS_B.t273 DVSS_B.t82 146.431348427716
Riso13532 DVSS_B.t273 DVSS_B.t84 1207.51937440318
Riso13533 DVSS_B.t273 DVSS_B.t89 32376.6901515752
Riso13534 DVSS_B.t273 DVSS_B.t90 316.659018362866
Riso13535 DVSS_B.t273 DVSS_B.t94 213.108255668795
Riso13536 DVSS_B.t273 DVSS_B.t96 344.651394398038
Riso13537 DVSS_B.t273 VSS_A 1221.86032302526
Riso13538 DVSS_B.t273 VSS_B 179.61359755908
Riso13539 DVSS_B.t274 DVSS_B.t282 66.3487
Riso13540 DVSS_B.t275 DVSS_B.t277 637.102543600184
Riso13541 DVSS_B.t275 DVSS_B.t279 470.094852276946
Riso13542 DVSS_B.t275 DVSS_B.t281 990.287931312109
Riso13543 DVSS_B.t275 DVSS_B.t283 38.9922172064633
Riso13544 DVSS_B.t275 DVSS_B.t285 207.345480322493
Riso13545 DVSS_B.t275 DVSS_B.t287 187.160613669425
Riso13546 DVSS_B.t275 DVSS_B.t288 6836.61190771296
Riso13547 DVSS_B.t275 DVSS_B.t289 70.7923747934473
Riso13548 DVSS_B.t275 DVSS_B.t291 996.354394714662
Riso13549 DVSS_B.t275 DVSS_B.t293 46.3695435855487
Riso13550 DVSS_B.t275 DVSS_B.t295 342.804669472169
Riso13551 DVSS_B.t275 DVSS_B.t297 96.7923944972666
Riso13552 DVSS_B.t275 DVSS_B.t299 39.4136326458607
Riso13553 DVSS_B.t275 DVSS_B.t301 927.927259398487
Riso13554 DVSS_B.t275 DVSS_B.t302 111680.887757071
Riso13555 DVSS_B.t275 DVSS_B.t303 927.927259398487
Riso13556 DVSS_B.t275 DVSS_B.t305 83.0088962623749
Riso13557 DVSS_B.t275 DVSS_B.t322 414.173813857573
Riso13558 DVSS_B.t275 DVSS_B.t325 81808.2106978936
Riso13559 DVSS_B.t275 DVSS_B.t326 668.708267486351
Riso13560 DVSS_B.t275 DVSS_B.t329 161.258783367274
Riso13561 DVSS_B.t275 DVSS_B.t331 297.73501043599
Riso13562 DVSS_B.t275 DVSS_B.t333 284.118742144659
Riso13563 DVSS_B.t275 DVSS_B.t335 157.373968703747
Riso13564 DVSS_B.t275 DVSS_B.t337 136.43114210163
Riso13565 DVSS_B.t275 DVSS_B.t339 297.73501043599
Riso13566 DVSS_B.t275 DVSS_B.t341 284.118742144659
Riso13567 DVSS_B.t275 DVSS_B.t343 118.369845701119
Riso13568 DVSS_B.t275 DVSS_B.t345 52938.6052543182
Riso13569 DVSS_B.t275 DVSS_B.t346 199.304738309426
Riso13570 DVSS_B.t275 DVSS_B.t348 166.975895614226
Riso13571 DVSS_B.t275 DVSS_B.t35 383.487176941639
Riso13572 DVSS_B.t275 DVSS_B.t350 79.5988515013726
Riso13573 DVSS_B.t275 DVSS_B.t352 87.5341738555542
Riso13574 DVSS_B.t275 DVSS_B.t355 163011.656287004
Riso13575 DVSS_B.t275 DVSS_B.t356 220.183962218783
Riso13576 DVSS_B.t275 DVSS_B.t358 896.718811409304
Riso13577 DVSS_B.t275 DVSS_B.t36 27345.4276969314
Riso13578 DVSS_B.t275 DVSS_B.t360 599.593838189234
Riso13579 DVSS_B.t275 DVSS_B.t364 990.287931312109
Riso13580 DVSS_B.t275 DVSS_B.t366 987.866371451613
Riso13581 DVSS_B.t275 DVSS_B.t37 423.743903210092
Riso13582 DVSS_B.t275 DVSS_B.t509 987.866371451613
Riso13583 DVSS_B.t275 DVSS_B.t515 129.113764989152
Riso13584 DVSS_B.t275 DVSS_B.t525 366.833217981355
Riso13585 DVSS_B.t275 DVSS_B.t529 426.132133170982
Riso13586 DVSS_B.t275 DVSS_B.t531 129.113764989152
Riso13587 DVSS_B.t275 DVSS_B.t59 23342.1869750397
Riso13588 DVSS_B.t275 DVSS_B.t60 226.599250324412
Riso13589 DVSS_B.t275 DVSS_B.t66 112.173590416118
Riso13590 DVSS_B.t275 DVSS_B.t68 39.4136326458607
Riso13591 DVSS_B.t275 DVSS_B.t70 637.102543600184
Riso13592 DVSS_B.t275 DVSS_B.t72 938.691424580031
Riso13593 DVSS_B.t275 DVSS_B.t74 414.173813857573
Riso13594 DVSS_B.t275 DVSS_B.t76 62.3777961031311
Riso13595 DVSS_B.t275 DVSS_B.t80 54.0715647470047
Riso13596 DVSS_B.t275 DVSS_B.t82 38.9922172064633
Riso13597 DVSS_B.t275 DVSS_B.t84 366.833217981355
Riso13598 DVSS_B.t275 DVSS_B.t89 81808.2106978936
Riso13599 DVSS_B.t275 DVSS_B.t90 791.360055108464
Riso13600 DVSS_B.t275 DVSS_B.t94 599.593838189234
Riso13601 DVSS_B.t275 DVSS_B.t96 846.859036807886
Riso13602 DVSS_B.t275 VSS_A 561.969757266806
Riso13603 DVSS_B.t275 VSS_B 90.3235328205559
Riso13604 DVSS_B.t276 DVSS_B.t69 66.3487
Riso13605 DVSS_B.t277 DVSS_B.t279 63.121539742705
Riso13606 DVSS_B.t277 DVSS_B.t281 103.960969003975
Riso13607 DVSS_B.t277 DVSS_B.t283 582.836873695418
Riso13608 DVSS_B.t277 DVSS_B.t285 180.807142718108
Riso13609 DVSS_B.t277 DVSS_B.t287 205.845575114945
Riso13610 DVSS_B.t277 DVSS_B.t288 53163.9183626096
Riso13611 DVSS_B.t277 DVSS_B.t289 415.356226692483
Riso13612 DVSS_B.t277 DVSS_B.t291 111.793240106292
Riso13613 DVSS_B.t277 DVSS_B.t293 742.895490213834
Riso13614 DVSS_B.t277 DVSS_B.t295 96.6110501893887
Riso13615 DVSS_B.t277 DVSS_B.t297 355.517133955106
Riso13616 DVSS_B.t277 DVSS_B.t299 690.984813867472
Riso13617 DVSS_B.t277 DVSS_B.t301 122.312240984451
Riso13618 DVSS_B.t277 DVSS_B.t302 16458.1045320414
Riso13619 DVSS_B.t277 DVSS_B.t303 122.312240984451
Riso13620 DVSS_B.t277 DVSS_B.t305 386.461557205248
Riso13621 DVSS_B.t277 DVSS_B.t322 3942.15408437973
Riso13622 DVSS_B.t277 DVSS_B.t325 5600.62187897058
Riso13623 DVSS_B.t277 DVSS_B.t326 37.3646039190236
Riso13624 DVSS_B.t277 DVSS_B.t329 795.532020126372
Riso13625 DVSS_B.t277 DVSS_B.t331 1539.80077763858
Riso13626 DVSS_B.t277 DVSS_B.t333 1466.44265777539
Riso13627 DVSS_B.t277 DVSS_B.t335 778.779497698561
Riso13628 DVSS_B.t277 DVSS_B.t337 704.389757151159
Riso13629 DVSS_B.t277 DVSS_B.t339 1539.80077763858
Riso13630 DVSS_B.t277 DVSS_B.t341 1466.44265777539
Riso13631 DVSS_B.t277 DVSS_B.t343 627.784245273726
Riso13632 DVSS_B.t277 DVSS_B.t345 303980.415548699
Riso13633 DVSS_B.t277 DVSS_B.t346 1097.72843183081
Riso13634 DVSS_B.t277 DVSS_B.t348 232.937979675356
Riso13635 DVSS_B.t277 DVSS_B.t35 84.6433276372939
Riso13636 DVSS_B.t277 DVSS_B.t350 887.9834946928
Riso13637 DVSS_B.t277 DVSS_B.t352 896.825171554606
Riso13638 DVSS_B.t277 DVSS_B.t355 997950.048260664
Riso13639 DVSS_B.t277 DVSS_B.t356 1648.77196709835
Riso13640 DVSS_B.t277 DVSS_B.t358 75.4966833770685
Riso13641 DVSS_B.t277 DVSS_B.t36 161791.825895425
Riso13642 DVSS_B.t277 DVSS_B.t360 38.5500258386075
Riso13643 DVSS_B.t277 DVSS_B.t364 103.960969003975
Riso13644 DVSS_B.t277 DVSS_B.t366 117.796760082434
Riso13645 DVSS_B.t277 DVSS_B.t37 2515.83137630572
Riso13646 DVSS_B.t277 DVSS_B.t509 117.796760082434
Riso13647 DVSS_B.t277 DVSS_B.t515 292.351600409876
Riso13648 DVSS_B.t277 DVSS_B.t525 3222.0654236969
Riso13649 DVSS_B.t277 DVSS_B.t529 73.4089355661665
Riso13650 DVSS_B.t277 DVSS_B.t531 292.351600409876
Riso13651 DVSS_B.t277 DVSS_B.t59 15274.2582871938
Riso13652 DVSS_B.t277 DVSS_B.t60 157.913156982994
Riso13653 DVSS_B.t277 DVSS_B.t66 323.810839270678
Riso13654 DVSS_B.t277 DVSS_B.t68 690.984813867472
Riso13655 DVSS_B.t277 DVSS_B.t70 0.0669563679123703
Riso13656 DVSS_B.t277 DVSS_B.t72 85.2576162047381
Riso13657 DVSS_B.t277 DVSS_B.t74 3942.15408437973
Riso13658 DVSS_B.t277 DVSS_B.t76 832.707678112477
Riso13659 DVSS_B.t277 DVSS_B.t80 790.889610098672
Riso13660 DVSS_B.t277 DVSS_B.t82 582.836873695418
Riso13661 DVSS_B.t277 DVSS_B.t84 3222.0654236969
Riso13662 DVSS_B.t277 DVSS_B.t89 5600.62187897058
Riso13663 DVSS_B.t277 DVSS_B.t90 57.1423886815744
Riso13664 DVSS_B.t277 DVSS_B.t94 38.5500258386075
Riso13665 DVSS_B.t277 DVSS_B.t96 66.0321050096979
Riso13666 DVSS_B.t277 VSS_A 2711.14957372619
Riso13667 DVSS_B.t277 VSS_B 364.90704080938
Riso13668 DVSS_B.t279 DVSS_B.t281 170.426344560564
Riso13669 DVSS_B.t279 DVSS_B.t283 426.951441478237
Riso13670 DVSS_B.t279 DVSS_B.t285 114.937243831437
Riso13671 DVSS_B.t279 DVSS_B.t287 132.741397694769
Riso13672 DVSS_B.t279 DVSS_B.t288 38487.7136174266
Riso13673 DVSS_B.t279 DVSS_B.t289 293.661858064571
Riso13674 DVSS_B.t279 DVSS_B.t291 179.768104098423
Riso13675 DVSS_B.t279 DVSS_B.t293 555.724566746506
Riso13676 DVSS_B.t279 DVSS_B.t295 55.4607577805091
Riso13677 DVSS_B.t279 DVSS_B.t297 245.430468611619
Riso13678 DVSS_B.t279 DVSS_B.t299 513.427141558949
Riso13679 DVSS_B.t279 DVSS_B.t301 187.489631184087
Riso13680 DVSS_B.t279 DVSS_B.t302 24402.562176266
Riso13681 DVSS_B.t279 DVSS_B.t303 187.489631184087
Riso13682 DVSS_B.t279 DVSS_B.t305 270.089197572388
Riso13683 DVSS_B.t279 DVSS_B.t322 3077.28539325724
Riso13684 DVSS_B.t279 DVSS_B.t325 10294.4503625885
Riso13685 DVSS_B.t279 DVSS_B.t326 71.5543709276809
Riso13686 DVSS_B.t279 DVSS_B.t329 635.017204831869
Riso13687 DVSS_B.t279 DVSS_B.t331 1226.54467158065
Riso13688 DVSS_B.t279 DVSS_B.t333 1166.67508274692
Riso13689 DVSS_B.t279 DVSS_B.t335 620.89887488105
Riso13690 DVSS_B.t279 DVSS_B.t337 560.846374407703
Riso13691 DVSS_B.t279 DVSS_B.t339 1226.54467158065
Riso13692 DVSS_B.t279 DVSS_B.t341 1166.67508274692
Riso13693 DVSS_B.t279 DVSS_B.t343 498.627975749426
Riso13694 DVSS_B.t279 DVSS_B.t345 242344.249646951
Riso13695 DVSS_B.t279 DVSS_B.t346 876.316776312441
Riso13696 DVSS_B.t279 DVSS_B.t348 152.362531404108
Riso13697 DVSS_B.t279 DVSS_B.t35 47.4981958486241
Riso13698 DVSS_B.t279 DVSS_B.t350 680.365763172506
Riso13699 DVSS_B.t279 DVSS_B.t352 690.627690878538
Riso13700 DVSS_B.t279 DVSS_B.t355 793893.647711296
Riso13701 DVSS_B.t279 DVSS_B.t356 1301.64033941102
Riso13702 DVSS_B.t279 DVSS_B.t358 131.492176180475
Riso13703 DVSS_B.t279 DVSS_B.t36 126324.967122298
Riso13704 DVSS_B.t279 DVSS_B.t360 54.9159904850838
Riso13705 DVSS_B.t279 DVSS_B.t364 170.426344560564
Riso13706 DVSS_B.t279 DVSS_B.t366 186.051842169747
Riso13707 DVSS_B.t279 DVSS_B.t37 1963.77827422438
Riso13708 DVSS_B.t279 DVSS_B.t509 186.051842169747
Riso13709 DVSS_B.t279 DVSS_B.t515 196.603341877455
Riso13710 DVSS_B.t279 DVSS_B.t525 2525.42304704974
Riso13711 DVSS_B.t279 DVSS_B.t529 40.337814292832
Riso13712 DVSS_B.t279 DVSS_B.t531 196.603341877455
Riso13713 DVSS_B.t279 DVSS_B.t59 12305.1715296435
Riso13714 DVSS_B.t279 DVSS_B.t60 98.9549925743394
Riso13715 DVSS_B.t279 DVSS_B.t66 220.684588107135
Riso13716 DVSS_B.t279 DVSS_B.t68 513.427141558949
Riso13717 DVSS_B.t279 DVSS_B.t70 63.121539742705
Riso13718 DVSS_B.t279 DVSS_B.t72 145.524585147351
Riso13719 DVSS_B.t279 DVSS_B.t74 3077.28539325724
Riso13720 DVSS_B.t279 DVSS_B.t76 630.823983892936
Riso13721 DVSS_B.t279 DVSS_B.t80 595.459595398748
Riso13722 DVSS_B.t279 DVSS_B.t82 426.951441478237
Riso13723 DVSS_B.t279 DVSS_B.t84 2525.42304704974
Riso13724 DVSS_B.t279 DVSS_B.t89 10294.4503625885
Riso13725 DVSS_B.t279 DVSS_B.t90 103.455109941924
Riso13726 DVSS_B.t279 DVSS_B.t94 54.9159904850838
Riso13727 DVSS_B.t279 DVSS_B.t96 117.298463198008
Riso13728 DVSS_B.t279 VSS_A 2166.67139250205
Riso13729 DVSS_B.t279 VSS_B 293.703719473628
Riso13730 DVSS_B.t280 DVSS_B.t290 66.3487
Riso13731 DVSS_B.t280 DVSS_B.t363 66.3487
Riso13732 DVSS_B.t281 DVSS_B.t283 914.923035428985
Riso13733 DVSS_B.t281 DVSS_B.t285 345.416223989459
Riso13734 DVSS_B.t281 DVSS_B.t287 385.418442089825
Riso13735 DVSS_B.t281 DVSS_B.t288 84407.412709954
Riso13736 DVSS_B.t281 DVSS_B.t289 684.570816833709
Riso13737 DVSS_B.t281 DVSS_B.t291 32.7677916466635
Riso13738 DVSS_B.t281 DVSS_B.t293 1132.144430239
Riso13739 DVSS_B.t281 DVSS_B.t295 224.216722212325
Riso13740 DVSS_B.t281 DVSS_B.t297 606.017590930004
Riso13741 DVSS_B.t281 DVSS_B.t299 1063.49516890581
Riso13742 DVSS_B.t281 DVSS_B.t301 40.3684433969124
Riso13743 DVSS_B.t281 DVSS_B.t302 5927.25136330284
Riso13744 DVSS_B.t281 DVSS_B.t303 40.3684433969124
Riso13745 DVSS_B.t281 DVSS_B.t305 647.543901765201
Riso13746 DVSS_B.t281 DVSS_B.t322 5570.80773509555
Riso13747 DVSS_B.t281 DVSS_B.t325 8836.02887893756
Riso13748 DVSS_B.t281 DVSS_B.t326 90.3392273743521
Riso13749 DVSS_B.t281 DVSS_B.t329 1080.57113572232
Riso13750 DVSS_B.t281 DVSS_B.t331 2094.75883260541
Riso13751 DVSS_B.t281 DVSS_B.t333 1992.31558411108
Riso13752 DVSS_B.t281 DVSS_B.t335 1055.64176248748
Riso13753 DVSS_B.t281 DVSS_B.t337 963.840339514965
Riso13754 DVSS_B.t281 DVSS_B.t339 2094.75883260541
Riso13755 DVSS_B.t281 DVSS_B.t341 1992.31558411108
Riso13756 DVSS_B.t281 DVSS_B.t343 860.911676491454
Riso13757 DVSS_B.t281 DVSS_B.t345 420126.322950284
Riso13758 DVSS_B.t281 DVSS_B.t346 1515.07031830769
Riso13759 DVSS_B.t281 DVSS_B.t348 427.631561340154
Riso13760 DVSS_B.t281 DVSS_B.t35 207.055745157195
Riso13761 DVSS_B.t281 DVSS_B.t350 1301.24581323202
Riso13762 DVSS_B.t281 DVSS_B.t352 1302.09880446329
Riso13763 DVSS_B.t281 DVSS_B.t355 1382319.2255096
Riso13764 DVSS_B.t281 DVSS_B.t356 2302.1360830073
Riso13765 DVSS_B.t281 DVSS_B.t358 46.7710700971552
Riso13766 DVSS_B.t281 DVSS_B.t36 228288.655845545
Riso13767 DVSS_B.t281 DVSS_B.t360 118.905914238777
Riso13768 DVSS_B.t281 DVSS_B.t364 0.06694105424611
Riso13769 DVSS_B.t281 DVSS_B.t366 36.05738462325
Riso13770 DVSS_B.t281 DVSS_B.t37 3552.56647874686
Riso13771 DVSS_B.t281 DVSS_B.t509 36.05738462325
Riso13772 DVSS_B.t281 DVSS_B.t515 516.652685671715
Riso13773 DVSS_B.t281 DVSS_B.t525 4533.40638416502
Riso13774 DVSS_B.t281 DVSS_B.t529 188.859226814104
Riso13775 DVSS_B.t281 DVSS_B.t531 516.652685671715
Riso13776 DVSS_B.t281 DVSS_B.t59 19228.8311613681
Riso13777 DVSS_B.t281 DVSS_B.t60 307.916852757511
Riso13778 DVSS_B.t281 DVSS_B.t66 561.868239519592
Riso13779 DVSS_B.t281 DVSS_B.t68 1063.49516890581
Riso13780 DVSS_B.t281 DVSS_B.t70 103.960969003975
Riso13781 DVSS_B.t281 DVSS_B.t72 40.2636662390059
Riso13782 DVSS_B.t281 DVSS_B.t74 5570.80773509555
Riso13783 DVSS_B.t281 DVSS_B.t76 1244.15260662965
Riso13784 DVSS_B.t281 DVSS_B.t80 1193.41116178396
Riso13785 DVSS_B.t281 DVSS_B.t82 914.923035428985
Riso13786 DVSS_B.t281 DVSS_B.t84 4533.40638416502
Riso13787 DVSS_B.t281 DVSS_B.t89 8836.02887893756
Riso13788 DVSS_B.t281 DVSS_B.t90 61.1176455433427
Riso13789 DVSS_B.t281 DVSS_B.t94 118.905914238777
Riso13790 DVSS_B.t281 DVSS_B.t96 53.7888658786224
Riso13791 DVSS_B.t281 VSS_A 3670.58080600807
Riso13792 DVSS_B.t281 VSS_B 478.887800679363
Riso13793 DVSS_B.t282 DVSS_B.t81 66.3487
Riso13794 DVSS_B.t283 DVSS_B.t285 183.66472013091
Riso13795 DVSS_B.t283 DVSS_B.t287 164.943130981174
Riso13796 DVSS_B.t283 DVSS_B.t288 5823.39683040378
Riso13797 DVSS_B.t283 DVSS_B.t289 60.4880974028925
Riso13798 DVSS_B.t283 DVSS_B.t291 921.234359567808
Riso13799 DVSS_B.t283 DVSS_B.t293 53.9339739343007
Riso13800 DVSS_B.t283 DVSS_B.t295 309.454282783292
Riso13801 DVSS_B.t283 DVSS_B.t297 83.3670983464817
Riso13802 DVSS_B.t283 DVSS_B.t299 46.0335200823345
Riso13803 DVSS_B.t283 DVSS_B.t301 859.578396062478
Riso13804 DVSS_B.t283 DVSS_B.t302 103594.466138459
Riso13805 DVSS_B.t283 DVSS_B.t303 859.578396062478
Riso13806 DVSS_B.t283 DVSS_B.t305 71.2040975289504
Riso13807 DVSS_B.t283 DVSS_B.t322 470.998467091223
Riso13808 DVSS_B.t283 DVSS_B.t325 75210.3716403229
Riso13809 DVSS_B.t283 DVSS_B.t326 612.731860276877
Riso13810 DVSS_B.t283 DVSS_B.t329 173.486018837318
Riso13811 DVSS_B.t283 DVSS_B.t331 322.067302138741
Riso13812 DVSS_B.t283 DVSS_B.t333 307.494106521785
Riso13813 DVSS_B.t283 DVSS_B.t335 169.581301983366
Riso13814 DVSS_B.t283 DVSS_B.t337 147.093615238496
Riso13815 DVSS_B.t283 DVSS_B.t339 322.067302138741
Riso13816 DVSS_B.t283 DVSS_B.t341 307.494106521785
Riso13817 DVSS_B.t283 DVSS_B.t343 127.937364671767
Riso13818 DVSS_B.t283 DVSS_B.t345 57568.1211613182
Riso13819 DVSS_B.t283 DVSS_B.t346 215.722953344064
Riso13820 DVSS_B.t283 DVSS_B.t348 146.431348427716
Riso13821 DVSS_B.t283 DVSS_B.t35 346.8996734152
Riso13822 DVSS_B.t283 DVSS_B.t350 90.8665015225452
Riso13823 DVSS_B.t283 DVSS_B.t352 99.4418048016921
Riso13824 DVSS_B.t283 DVSS_B.t355 178487.583023573
Riso13825 DVSS_B.t283 DVSS_B.t356 245.758211211648
Riso13826 DVSS_B.t283 DVSS_B.t358 826.319379644692
Riso13827 DVSS_B.t283 DVSS_B.t36 29587.8963179723
Riso13828 DVSS_B.t283 DVSS_B.t360 547.593204201229
Riso13829 DVSS_B.t283 DVSS_B.t364 914.923035428985
Riso13830 DVSS_B.t283 DVSS_B.t366 914.027345142295
Riso13831 DVSS_B.t283 DVSS_B.t37 458.545066819516
Riso13832 DVSS_B.t283 DVSS_B.t509 914.027345142295
Riso13833 DVSS_B.t283 DVSS_B.t515 112.174372491623
Riso13834 DVSS_B.t283 DVSS_B.t525 414.749328376468
Riso13835 DVSS_B.t283 DVSS_B.t529 386.259520063712
Riso13836 DVSS_B.t283 DVSS_B.t531 112.174372491623
Riso13837 DVSS_B.t283 DVSS_B.t59 21845.838814795
Riso13838 DVSS_B.t283 DVSS_B.t60 201.774937638429
Riso13839 DVSS_B.t283 DVSS_B.t66 97.0267297455866
Riso13840 DVSS_B.t283 DVSS_B.t68 46.0335200823345
Riso13841 DVSS_B.t283 DVSS_B.t70 582.836873695418
Riso13842 DVSS_B.t283 DVSS_B.t72 865.784496571427
Riso13843 DVSS_B.t283 DVSS_B.t74 470.998467091223
Riso13844 DVSS_B.t283 DVSS_B.t76 71.9013531347615
Riso13845 DVSS_B.t283 DVSS_B.t80 62.6162584880695
Riso13846 DVSS_B.t283 DVSS_B.t82 0.0669582969444927
Riso13847 DVSS_B.t283 DVSS_B.t84 414.749328376468
Riso13848 DVSS_B.t283 DVSS_B.t89 75210.3716403229
Riso13849 DVSS_B.t283 DVSS_B.t90 727.840655660984
Riso13850 DVSS_B.t283 DVSS_B.t94 547.593204201229
Riso13851 DVSS_B.t283 DVSS_B.t96 779.639221331199
Riso13852 DVSS_B.t283 VSS_A 603.845090934047
Riso13853 DVSS_B.t283 VSS_B 96.5726291751972
Riso13854 DVSS_B.t285 DVSS_B.t287 40.1585431710517
Riso13855 DVSS_B.t285 DVSS_B.t288 15905.9367405996
Riso13856 DVSS_B.t285 DVSS_B.t289 112.759210419962
Riso13857 DVSS_B.t285 DVSS_B.t291 352.625416284088
Riso13858 DVSS_B.t285 DVSS_B.t293 257.378732740072
Riso13859 DVSS_B.t285 DVSS_B.t295 74.283680451705
Riso13860 DVSS_B.t285 DVSS_B.t297 87.9890919899137
Riso13861 DVSS_B.t285 DVSS_B.t299 232.107194161184
Riso13862 DVSS_B.t285 DVSS_B.t301 339.370178822237
Riso13863 DVSS_B.t285 DVSS_B.t302 41693.539873366
Riso13864 DVSS_B.t285 DVSS_B.t303 339.370178822237
Riso13865 DVSS_B.t285 DVSS_B.t305 100.245580682412
Riso13866 DVSS_B.t285 DVSS_B.t322 1638.88913622679
Riso13867 DVSS_B.t285 DVSS_B.t325 25572.0291075968
Riso13868 DVSS_B.t285 DVSS_B.t326 196.111484467771
Riso13869 DVSS_B.t285 DVSS_B.t329 376.983636577133
Riso13870 DVSS_B.t285 DVSS_B.t331 723.652506594616
Riso13871 DVSS_B.t285 DVSS_B.t333 688.672581517741
Riso13872 DVSS_B.t285 DVSS_B.t335 368.814412996328
Riso13873 DVSS_B.t285 DVSS_B.t337 329.563549775364
Riso13874 DVSS_B.t285 DVSS_B.t339 723.652506594616
Riso13875 DVSS_B.t285 DVSS_B.t341 688.672581517741
Riso13876 DVSS_B.t285 DVSS_B.t343 291.530005651084
Riso13877 DVSS_B.t285 DVSS_B.t345 140153.875672794
Riso13878 DVSS_B.t285 DVSS_B.t346 509.580619882658
Riso13879 DVSS_B.t285 DVSS_B.t348 47.617886767889
Riso13880 DVSS_B.t285 DVSS_B.t35 86.5347879318451
Riso13881 DVSS_B.t285 DVSS_B.t350 344.631031888299
Riso13882 DVSS_B.t285 DVSS_B.t352 356.734886748779
Riso13883 DVSS_B.t285 DVSS_B.t355 455116.42299845
Riso13884 DVSS_B.t285 DVSS_B.t356 723.698976530425
Riso13885 DVSS_B.t285 DVSS_B.t358 296.655670972611
Riso13886 DVSS_B.t285 DVSS_B.t36 71237.3414697744
Riso13887 DVSS_B.t285 DVSS_B.t360 164.30830648759
Riso13888 DVSS_B.t285 DVSS_B.t364 345.416223989459
Riso13889 DVSS_B.t285 DVSS_B.t366 354.120238141409
Riso13890 DVSS_B.t285 DVSS_B.t37 1106.39558484302
Riso13891 DVSS_B.t285 DVSS_B.t509 354.120238141409
Riso13892 DVSS_B.t285 DVSS_B.t515 65.7461239818154
Riso13893 DVSS_B.t285 DVSS_B.t525 1365.64394268229
Riso13894 DVSS_B.t285 DVSS_B.t529 100.11488522429
Riso13895 DVSS_B.t285 DVSS_B.t531 65.7461239818154
Riso13896 DVSS_B.t285 DVSS_B.t59 9247.19366571672
Riso13897 DVSS_B.t285 DVSS_B.t60 39.5043755607894
Riso13898 DVSS_B.t285 DVSS_B.t66 76.4050427211984
Riso13899 DVSS_B.t285 DVSS_B.t68 232.107194161184
Riso13900 DVSS_B.t285 DVSS_B.t70 180.807142718108
Riso13901 DVSS_B.t285 DVSS_B.t72 316.508671000859
Riso13902 DVSS_B.t285 DVSS_B.t74 1638.88913622679
Riso13903 DVSS_B.t285 DVSS_B.t76 306.085629818805
Riso13904 DVSS_B.t285 DVSS_B.t80 282.375294543756
Riso13905 DVSS_B.t285 DVSS_B.t82 183.66472013091
Riso13906 DVSS_B.t285 DVSS_B.t84 1365.64394268229
Riso13907 DVSS_B.t285 DVSS_B.t89 25572.0291075968
Riso13908 DVSS_B.t285 DVSS_B.t90 251.176031268153
Riso13909 DVSS_B.t285 DVSS_B.t94 164.30830648759
Riso13910 DVSS_B.t285 DVSS_B.t96 274.556206497031
Riso13911 DVSS_B.t285 VSS_A 1292.37936228406
Riso13912 DVSS_B.t285 VSS_B 182.418485779323
Riso13913 DVSS_B.t287 DVSS_B.t288 14181.5819936387
Riso13914 DVSS_B.t287 DVSS_B.t289 99.136606089643
Riso13915 DVSS_B.t287 DVSS_B.t291 392.977710119948
Riso13916 DVSS_B.t287 DVSS_B.t293 234.788916088336
Riso13917 DVSS_B.t287 DVSS_B.t295 86.7502214305712
Riso13918 DVSS_B.t287 DVSS_B.t297 76.4772668349339
Riso13919 DVSS_B.t287 DVSS_B.t299 210.608303480258
Riso13920 DVSS_B.t287 DVSS_B.t301 377.306590246691
Riso13921 DVSS_B.t287 DVSS_B.t302 46308.9518006876
Riso13922 DVSS_B.t287 DVSS_B.t303 377.306590246691
Riso13923 DVSS_B.t287 DVSS_B.t305 87.6236246275127
Riso13924 DVSS_B.t287 DVSS_B.t322 1546.21827101092
Riso13925 DVSS_B.t287 DVSS_B.t325 28860.394216829
Riso13926 DVSS_B.t287 DVSS_B.t326 222.568773448401
Riso13927 DVSS_B.t287 DVSS_B.t329 368.441579884516
Riso13928 DVSS_B.t287 DVSS_B.t331 706.537390827892
Riso13929 DVSS_B.t287 DVSS_B.t333 673.720797197605
Riso13930 DVSS_B.t287 DVSS_B.t335 361.264492816181
Riso13931 DVSS_B.t287 DVSS_B.t337 320.756942452822
Riso13932 DVSS_B.t287 DVSS_B.t339 706.537390827892
Riso13933 DVSS_B.t287 DVSS_B.t341 673.720797197605
Riso13934 DVSS_B.t287 DVSS_B.t343 283.657168782409
Riso13935 DVSS_B.t287 DVSS_B.t345 134856.114742898
Riso13936 DVSS_B.t287 DVSS_B.t346 490.99314728297
Riso13937 DVSS_B.t287 DVSS_B.t348 40.5736441198819
Riso13938 DVSS_B.t287 DVSS_B.t35 100.688121339617
Riso13939 DVSS_B.t287 DVSS_B.t350 321.358416056588
Riso13940 DVSS_B.t287 DVSS_B.t352 334.420645368493
Riso13941 DVSS_B.t287 DVSS_B.t355 436956.347726649
Riso13942 DVSS_B.t287 DVSS_B.t356 689.653900104367
Riso13943 DVSS_B.t287 DVSS_B.t358 332.6617452678
Riso13944 DVSS_B.t287 DVSS_B.t36 68870.8886662303
Riso13945 DVSS_B.t287 DVSS_B.t360 187.694774537035
Riso13946 DVSS_B.t287 DVSS_B.t364 385.418442089825
Riso13947 DVSS_B.t287 DVSS_B.t366 394.245788265761
Riso13948 DVSS_B.t287 DVSS_B.t37 1069.28575457998
Riso13949 DVSS_B.t287 DVSS_B.t509 394.245788265761
Riso13950 DVSS_B.t287 DVSS_B.t515 56.5456454577286
Riso13951 DVSS_B.t287 DVSS_B.t525 1292.92884016145
Riso13952 DVSS_B.t287 DVSS_B.t529 116.056780885282
Riso13953 DVSS_B.t287 DVSS_B.t531 56.5456454577286
Riso13954 DVSS_B.t287 DVSS_B.t59 10400.459422215
Riso13955 DVSS_B.t287 DVSS_B.t60 46.8793194804254
Riso13956 DVSS_B.t287 DVSS_B.t66 66.0506712423182
Riso13957 DVSS_B.t287 DVSS_B.t68 210.608303480258
Riso13958 DVSS_B.t287 DVSS_B.t70 205.845575114945
Riso13959 DVSS_B.t287 DVSS_B.t72 354.265870681961
Riso13960 DVSS_B.t287 DVSS_B.t74 1546.21827101092
Riso13961 DVSS_B.t287 DVSS_B.t76 282.293306706015
Riso13962 DVSS_B.t287 DVSS_B.t80 258.995941993776
Riso13963 DVSS_B.t287 DVSS_B.t82 164.943130981174
Riso13964 DVSS_B.t287 DVSS_B.t84 1292.92884016145
Riso13965 DVSS_B.t287 DVSS_B.t89 28860.394216829
Riso13966 DVSS_B.t287 DVSS_B.t90 282.849813709337
Riso13967 DVSS_B.t287 DVSS_B.t94 187.694774537035
Riso13968 DVSS_B.t287 DVSS_B.t96 308.50546699101
Riso13969 DVSS_B.t287 VSS_A 1265.49853916147
Riso13970 DVSS_B.t287 VSS_B 182.507969883354
Riso13971 DVSS_B.t288 DVSS_B.t289 4944.50053369684
Riso13972 DVSS_B.t288 DVSS_B.t291 85021.6703476705
Riso13973 DVSS_B.t288 DVSS_B.t293 9207.12333381897
Riso13974 DVSS_B.t288 DVSS_B.t295 27567.1410655379
Riso13975 DVSS_B.t288 DVSS_B.t297 6908.82637391204
Riso13976 DVSS_B.t288 DVSS_B.t299 7967.68053225433
Riso13977 DVSS_B.t288 DVSS_B.t301 79351.4366846994
Riso13978 DVSS_B.t288 DVSS_B.t302 9557037.37683869
Riso13979 DVSS_B.t288 DVSS_B.t303 79351.4366846994
Riso13980 DVSS_B.t288 DVSS_B.t305 5859.79269866367
Riso13981 DVSS_B.t288 DVSS_B.t322 73977.476734458
Riso13982 DVSS_B.t288 DVSS_B.t325 6893584.12037005
Riso13983 DVSS_B.t288 DVSS_B.t326 56007.4325108503
Riso13984 DVSS_B.t288 DVSS_B.t329 23193.515088944
Riso13985 DVSS_B.t288 DVSS_B.t331 43629.8766824788
Riso13986 DVSS_B.t288 DVSS_B.t333 41619.2692615585
Riso13987 DVSS_B.t288 DVSS_B.t335 22698.7901115978
Riso13988 DVSS_B.t288 DVSS_B.t337 19850.2577833588
Riso13989 DVSS_B.t288 DVSS_B.t339 43629.8766824788
Riso13990 DVSS_B.t288 DVSS_B.t341 41619.2692615585
Riso13991 DVSS_B.t288 DVSS_B.t343 17367.359998879
Riso13992 DVSS_B.t288 DVSS_B.t345 8006205.86947276
Riso13993 DVSS_B.t288 DVSS_B.t346 29654.9898349209
Riso13994 DVSS_B.t288 DVSS_B.t348 12497.2493486506
Riso13995 DVSS_B.t288 DVSS_B.t35 31032.3768517356
Riso13996 DVSS_B.t288 DVSS_B.t350 14568.7896683985
Riso13997 DVSS_B.t288 DVSS_B.t352 15683.044694889
Riso13998 DVSS_B.t288 DVSS_B.t355 25258318.2007129
Riso13999 DVSS_B.t288 DVSS_B.t356 36596.7748805698
Riso14000 DVSS_B.t288 DVSS_B.t358 76066.3971647328
Riso14001 DVSS_B.t288 DVSS_B.t36 4057447.81048613
Riso14002 DVSS_B.t288 DVSS_B.t360 49827.0133224777
Riso14003 DVSS_B.t288 DVSS_B.t364 84407.412709954
Riso14004 DVSS_B.t288 DVSS_B.t366 84374.8210822581
Riso14005 DVSS_B.t288 DVSS_B.t37 62918.0646509061
Riso14006 DVSS_B.t288 DVSS_B.t509 84374.8210822581
Riso14007 DVSS_B.t288 DVSS_B.t515 9432.15897420093
Riso14008 DVSS_B.t288 DVSS_B.t525 64046.9738052015
Riso14009 DVSS_B.t288 DVSS_B.t529 34690.5328322013
Riso14010 DVSS_B.t288 DVSS_B.t531 9432.15897420093
Riso14011 DVSS_B.t288 DVSS_B.t59 1970367.90354018
Riso14012 DVSS_B.t288 DVSS_B.t60 17596.6421664006
Riso14013 DVSS_B.t288 DVSS_B.t66 8098.82253532833
Riso14014 DVSS_B.t288 DVSS_B.t68 7967.68053225433
Riso14015 DVSS_B.t288 DVSS_B.t70 53163.9183626096
Riso14016 DVSS_B.t288 DVSS_B.t72 79771.9891130797
Riso14017 DVSS_B.t288 DVSS_B.t74 73977.476734458
Riso14018 DVSS_B.t288 DVSS_B.t76 11909.8739342248
Riso14019 DVSS_B.t288 DVSS_B.t80 10533.5432811596
Riso14020 DVSS_B.t288 DVSS_B.t82 5823.39683040378
Riso14021 DVSS_B.t288 DVSS_B.t84 64046.9738052015
Riso14022 DVSS_B.t288 DVSS_B.t89 6893584.12037005
Riso14023 DVSS_B.t288 DVSS_B.t90 66843.7815089632
Riso14024 DVSS_B.t288 DVSS_B.t94 49827.0133224777
Riso14025 DVSS_B.t288 DVSS_B.t96 71691.1467683795
Riso14026 DVSS_B.t288 VSS_A 80339.221837661
Riso14027 DVSS_B.t288 VSS_B 12375.04865508
Riso14028 DVSS_B.t289 DVSS_B.t291 691.873322947754
Riso14029 DVSS_B.t289 DVSS_B.t293 94.740972712739
Riso14030 DVSS_B.t289 DVSS_B.t295 206.666984905013
Riso14031 DVSS_B.t289 DVSS_B.t297 45.7588345540327
Riso14032 DVSS_B.t289 DVSS_B.t299 82.245187014794
Riso14033 DVSS_B.t289 DVSS_B.t301 651.43860095945
Riso14034 DVSS_B.t289 DVSS_B.t302 79017.582081604
Riso14035 DVSS_B.t289 DVSS_B.t303 651.43860095945
Riso14036 DVSS_B.t289 DVSS_B.t305 38.4890506767861
Riso14037 DVSS_B.t289 DVSS_B.t322 753.166959651821
Riso14038 DVSS_B.t289 DVSS_B.t325 54902.736047811
Riso14039 DVSS_B.t289 DVSS_B.t326 440.107046991465
Riso14040 DVSS_B.t289 DVSS_B.t329 230.448600219772
Riso14041 DVSS_B.t289 DVSS_B.t331 434.964359487285
Riso14042 DVSS_B.t289 DVSS_B.t333 415.950577477514
Riso14043 DVSS_B.t289 DVSS_B.t335 226.296395459279
Riso14044 DVSS_B.t289 DVSS_B.t337 197.019287184486
Riso14045 DVSS_B.t289 DVSS_B.t339 434.964359487285
Riso14046 DVSS_B.t289 DVSS_B.t341 415.950577477514
Riso14047 DVSS_B.t289 DVSS_B.t343 172.774678807058
Riso14048 DVSS_B.t289 DVSS_B.t345 79144.2747388014
Riso14049 DVSS_B.t289 DVSS_B.t346 292.39068860095
Riso14050 DVSS_B.t289 DVSS_B.t348 86.2531813066918
Riso14051 DVSS_B.t289 DVSS_B.t35 234.005959370114
Riso14052 DVSS_B.t289 DVSS_B.t350 148.252747570981
Riso14053 DVSS_B.t289 DVSS_B.t352 159.27238581442
Riso14054 DVSS_B.t289 DVSS_B.t355 250676.099857889
Riso14055 DVSS_B.t289 DVSS_B.t356 367.611513524965
Riso14056 DVSS_B.t289 DVSS_B.t358 610.402445272832
Riso14057 DVSS_B.t289 DVSS_B.t36 40451.6800873232
Riso14058 DVSS_B.t289 DVSS_B.t360 387.004240446117
Riso14059 DVSS_B.t289 DVSS_B.t364 684.570816833709
Riso14060 DVSS_B.t289 DVSS_B.t366 688.798245257702
Riso14061 DVSS_B.t289 DVSS_B.t37 627.21801896889
Riso14062 DVSS_B.t289 DVSS_B.t509 688.798245257702
Riso14063 DVSS_B.t289 DVSS_B.t515 63.6596384219644
Riso14064 DVSS_B.t289 DVSS_B.t525 649.213023500142
Riso14065 DVSS_B.t289 DVSS_B.t529 263.131400120466
Riso14066 DVSS_B.t289 DVSS_B.t531 63.6596384219644
Riso14067 DVSS_B.t289 DVSS_B.t59 17376.9302411812
Riso14068 DVSS_B.t289 DVSS_B.t60 126.672952128409
Riso14069 DVSS_B.t289 DVSS_B.t66 54.1270416819037
Riso14070 DVSS_B.t289 DVSS_B.t68 82.245187014794
Riso14071 DVSS_B.t289 DVSS_B.t70 415.356226692483
Riso14072 DVSS_B.t289 DVSS_B.t72 642.438944358431
Riso14073 DVSS_B.t289 DVSS_B.t74 753.166959651821
Riso14074 DVSS_B.t289 DVSS_B.t76 121.817346279206
Riso14075 DVSS_B.t289 DVSS_B.t80 108.056845527655
Riso14076 DVSS_B.t289 DVSS_B.t82 60.4880974028925
Riso14077 DVSS_B.t289 DVSS_B.t84 649.213023500142
Riso14078 DVSS_B.t289 DVSS_B.t89 54902.736047811
Riso14079 DVSS_B.t289 DVSS_B.t90 532.56913051225
Riso14080 DVSS_B.t289 DVSS_B.t94 387.004240446117
Riso14081 DVSS_B.t289 DVSS_B.t96 573.231930994408
Riso14082 DVSS_B.t289 VSS_A 798.539665208439
Riso14083 DVSS_B.t289 VSS_B 124.672921191028
Riso14084 DVSS_B.t291 DVSS_B.t293 1137.19646012927
Riso14085 DVSS_B.t291 DVSS_B.t295 232.847406108514
Riso14086 DVSS_B.t291 DVSS_B.t297 614.058583319162
Riso14087 DVSS_B.t291 DVSS_B.t299 1069.14737763547
Riso14088 DVSS_B.t291 DVSS_B.t301 34.6001889847887
Riso14089 DVSS_B.t291 DVSS_B.t302 5129.86435669173
Riso14090 DVSS_B.t291 DVSS_B.t303 34.6001889847887
Riso14091 DVSS_B.t291 DVSS_B.t305 655.295069852987
Riso14092 DVSS_B.t291 DVSS_B.t322 5557.57268119184
Riso14093 DVSS_B.t291 DVSS_B.t325 9574.23111791886
Riso14094 DVSS_B.t291 DVSS_B.t326 97.5946493043866
Riso14095 DVSS_B.t291 DVSS_B.t329 1073.13468243865
Riso14096 DVSS_B.t291 DVSS_B.t331 2080.06605910858
Riso14097 DVSS_B.t291 DVSS_B.t333 1977.08820267175
Riso14098 DVSS_B.t291 DVSS_B.t335 1047.57509322062
Riso14099 DVSS_B.t291 DVSS_B.t337 958.140680105178
Riso14100 DVSS_B.t291 DVSS_B.t339 2080.06605910858
Riso14101 DVSS_B.t291 DVSS_B.t341 1977.08820267175
Riso14102 DVSS_B.t291 DVSS_B.t343 855.689315893372
Riso14103 DVSS_B.t291 DVSS_B.t345 418826.517212025
Riso14104 DVSS_B.t291 DVSS_B.t346 1510.31827316559
Riso14105 DVSS_B.t291 DVSS_B.t348 435.4814869732
Riso14106 DVSS_B.t291 DVSS_B.t35 216.175585679901
Riso14107 DVSS_B.t291 DVSS_B.t350 1302.18187956251
Riso14108 DVSS_B.t291 DVSS_B.t352 1301.78926433233
Riso14109 DVSS_B.t291 DVSS_B.t355 1378139.43652159
Riso14110 DVSS_B.t291 DVSS_B.t356 2295.76849571105
Riso14111 DVSS_B.t291 DVSS_B.t358 51.8257131020259
Riso14112 DVSS_B.t291 DVSS_B.t36 227228.209882152
Riso14113 DVSS_B.t291 DVSS_B.t360 127.265515984791
Riso14114 DVSS_B.t291 DVSS_B.t364 32.7677916466635
Riso14115 DVSS_B.t291 DVSS_B.t366 30.6563956400345
Riso14116 DVSS_B.t291 DVSS_B.t37 3536.39034334166
Riso14117 DVSS_B.t291 DVSS_B.t509 30.6563956400345
Riso14118 DVSS_B.t291 DVSS_B.t515 524.832487119032
Riso14119 DVSS_B.t291 DVSS_B.t525 4521.99078027773
Riso14120 DVSS_B.t291 DVSS_B.t529 198.204652562234
Riso14121 DVSS_B.t291 DVSS_B.t531 524.832487119032
Riso14122 DVSS_B.t291 DVSS_B.t59 18890.2992751647
Riso14123 DVSS_B.t291 DVSS_B.t60 314.732131921202
Riso14124 DVSS_B.t291 DVSS_B.t66 570.047053121932
Riso14125 DVSS_B.t291 DVSS_B.t68 1069.14737763547
Riso14126 DVSS_B.t291 DVSS_B.t70 111.793240106292
Riso14127 DVSS_B.t291 DVSS_B.t72 44.8438994372296
Riso14128 DVSS_B.t291 DVSS_B.t74 5557.57268119184
Riso14129 DVSS_B.t291 DVSS_B.t76 1247.43798014778
Riso14130 DVSS_B.t291 DVSS_B.t80 1197.67097069084
Riso14131 DVSS_B.t291 DVSS_B.t82 921.234359567808
Riso14132 DVSS_B.t291 DVSS_B.t84 4521.99078027773
Riso14133 DVSS_B.t291 DVSS_B.t89 9574.23111791886
Riso14134 DVSS_B.t291 DVSS_B.t90 67.0134771184729
Riso14135 DVSS_B.t291 DVSS_B.t94 127.265515984791
Riso14136 DVSS_B.t291 DVSS_B.t96 59.2903242208422
Riso14137 DVSS_B.t291 VSS_A 3643.79817756143
Riso14138 DVSS_B.t291 VSS_B 473.040304149113
Riso14139 DVSS_B.t292 DVSS_B.t67 66.3487
Riso14140 DVSS_B.t293 DVSS_B.t295 409.761129884918
Riso14141 DVSS_B.t293 DVSS_B.t297 127.365817092781
Riso14142 DVSS_B.t293 DVSS_B.t299 39.4864207553317
Riso14143 DVSS_B.t293 DVSS_B.t301 1054.6548102543
Riso14144 DVSS_B.t293 DVSS_B.t302 126527.673048251
Riso14145 DVSS_B.t293 DVSS_B.t303 1054.6548102543
Riso14146 DVSS_B.t293 DVSS_B.t305 110.172941514254
Riso14147 DVSS_B.t293 DVSS_B.t322 310.286104075645
Riso14148 DVSS_B.t293 DVSS_B.t325 94433.275440951
Riso14149 DVSS_B.t293 DVSS_B.t326 777.288539394317
Riso14150 DVSS_B.t293 DVSS_B.t329 135.622745336641
Riso14151 DVSS_B.t293 DVSS_B.t331 247.345050962216
Riso14152 DVSS_B.t293 DVSS_B.t333 235.752011765084
Riso14153 DVSS_B.t293 DVSS_B.t335 131.835531400682
Riso14154 DVSS_B.t293 DVSS_B.t337 114.312120261242
Riso14155 DVSS_B.t293 DVSS_B.t339 247.345050962216
Riso14156 DVSS_B.t293 DVSS_B.t341 235.752011765084
Riso14157 DVSS_B.t293 DVSS_B.t343 98.6629773506209
Riso14158 DVSS_B.t293 DVSS_B.t345 43525.1984708715
Riso14159 DVSS_B.t293 DVSS_B.t346 165.593531413816
Riso14160 DVSS_B.t293 DVSS_B.t348 211.617833773057
Riso14161 DVSS_B.t293 DVSS_B.t35 456.671337357699
Riso14162 DVSS_B.t293 DVSS_B.t350 59.3348568916052
Riso14163 DVSS_B.t293 DVSS_B.t352 65.8582834743072
Riso14164 DVSS_B.t293 DVSS_B.t355 132014.657918973
Riso14165 DVSS_B.t293 DVSS_B.t356 171.223475945
Riso14166 DVSS_B.t293 DVSS_B.t358 1030.72588892974
Riso14167 DVSS_B.t293 DVSS_B.t36 22849.663934589
Riso14168 DVSS_B.t293 DVSS_B.t360 701.461273908505
Riso14169 DVSS_B.t293 DVSS_B.t364 1132.144430239
Riso14170 DVSS_B.t293 DVSS_B.t366 1125.77049601466
Riso14171 DVSS_B.t293 DVSS_B.t37 354.017985522937
Riso14172 DVSS_B.t293 DVSS_B.t509 1125.77049601466
Riso14173 DVSS_B.t293 DVSS_B.t515 166.841217186626
Riso14174 DVSS_B.t293 DVSS_B.t525 277.959706294235
Riso14175 DVSS_B.t293 DVSS_B.t529 505.583934969606
Riso14176 DVSS_B.t293 DVSS_B.t531 166.841217186626
Riso14177 DVSS_B.t293 DVSS_B.t59 25814.7164644003
Riso14178 DVSS_B.t293 DVSS_B.t60 278.233698099827
Riso14179 DVSS_B.t293 DVSS_B.t66 146.294854276344
Riso14180 DVSS_B.t293 DVSS_B.t68 39.4864207553317
Riso14181 DVSS_B.t293 DVSS_B.t70 742.895490213834
Riso14182 DVSS_B.t293 DVSS_B.t72 1076.97387545588
Riso14183 DVSS_B.t293 DVSS_B.t74 310.286104075645
Riso14184 DVSS_B.t293 DVSS_B.t76 45.6492696871384
Riso14185 DVSS_B.t293 DVSS_B.t80 39.2269431528519
Riso14186 DVSS_B.t293 DVSS_B.t82 53.9339739343007
Riso14187 DVSS_B.t293 DVSS_B.t84 277.959706294235
Riso14188 DVSS_B.t293 DVSS_B.t89 94433.275440951
Riso14189 DVSS_B.t293 DVSS_B.t90 913.066104973993
Riso14190 DVSS_B.t293 DVSS_B.t94 701.461273908505
Riso14191 DVSS_B.t293 DVSS_B.t96 975.247973283235
Riso14192 DVSS_B.t293 VSS_A 473.686638139063
Riso14193 DVSS_B.t293 VSS_B 76.512492733405
Riso14194 DVSS_B.t294 DVSS_B.t34 66.3487
Riso14195 DVSS_B.t295 DVSS_B.t297 169.425334649602
Riso14196 DVSS_B.t295 DVSS_B.t299 376.555061545389
Riso14197 DVSS_B.t295 DVSS_B.t301 233.532250022744
Riso14198 DVSS_B.t295 DVSS_B.t302 29534.5074437748
Riso14199 DVSS_B.t295 DVSS_B.t303 233.532250022744
Riso14200 DVSS_B.t295 DVSS_B.t305 188.315236746854
Riso14201 DVSS_B.t295 DVSS_B.t322 2332.77776600604
Riso14202 DVSS_B.t295 DVSS_B.t325 14858.2611385278
Riso14203 DVSS_B.t295 DVSS_B.t326 107.585042718235
Riso14204 DVSS_B.t295 DVSS_B.t329 487.424103370478
Riso14205 DVSS_B.t295 DVSS_B.t331 939.063421208639
Riso14206 DVSS_B.t295 DVSS_B.t333 890.595216659188
Riso14207 DVSS_B.t295 DVSS_B.t335 474.995481913038
Riso14208 DVSS_B.t295 DVSS_B.t337 430.588918233514
Riso14209 DVSS_B.t295 DVSS_B.t339 939.063421208639
Riso14210 DVSS_B.t295 DVSS_B.t341 890.595216659188
Riso14211 DVSS_B.t295 DVSS_B.t343 381.729088867037
Riso14212 DVSS_B.t295 DVSS_B.t345 187682.634698276
Riso14213 DVSS_B.t295 DVSS_B.t346 679.601125124323
Riso14214 DVSS_B.t295 DVSS_B.t348 100.695385436343
Riso14215 DVSS_B.t295 DVSS_B.t35 39.9043964026663
Riso14216 DVSS_B.t295 DVSS_B.t350 510.273436099135
Riso14217 DVSS_B.t295 DVSS_B.t352 519.551757694373
Riso14218 DVSS_B.t295 DVSS_B.t355 613462.256832329
Riso14219 DVSS_B.t295 DVSS_B.t356 997.963784786457
Riso14220 DVSS_B.t295 DVSS_B.t358 181.799616718609
Riso14221 DVSS_B.t295 DVSS_B.t36 95516.8017211842
Riso14222 DVSS_B.t295 DVSS_B.t360 85.5095664056503
Riso14223 DVSS_B.t295 DVSS_B.t364 224.216722212325
Riso14224 DVSS_B.t295 DVSS_B.t366 237.508573743323
Riso14225 DVSS_B.t295 DVSS_B.t37 1484.80768019199
Riso14226 DVSS_B.t295 DVSS_B.t509 237.508573743323
Riso14227 DVSS_B.t295 DVSS_B.t515 132.85873689152
Riso14228 DVSS_B.t295 DVSS_B.t525 1922.20837192178
Riso14229 DVSS_B.t295 DVSS_B.t529 47.1978177563535
Riso14230 DVSS_B.t295 DVSS_B.t531 132.85873689152
Riso14231 DVSS_B.t295 DVSS_B.t59 9135.45904244295
Riso14232 DVSS_B.t295 DVSS_B.t60 63.2576685975986
Riso14233 DVSS_B.t295 DVSS_B.t66 150.756325539281
Riso14234 DVSS_B.t295 DVSS_B.t68 376.555061545389
Riso14235 DVSS_B.t295 DVSS_B.t70 96.6110501893887
Riso14236 DVSS_B.t295 DVSS_B.t72 197.86702700989
Riso14237 DVSS_B.t295 DVSS_B.t74 2332.77776600604
Riso14238 DVSS_B.t295 DVSS_B.t76 469.542715318073
Riso14239 DVSS_B.t295 DVSS_B.t80 441.231325333567
Riso14240 DVSS_B.t295 DVSS_B.t82 309.454282783292
Riso14241 DVSS_B.t295 DVSS_B.t84 1922.20837192178
Riso14242 DVSS_B.t295 DVSS_B.t89 14858.2611385278
Riso14243 DVSS_B.t295 DVSS_B.t90 147.785663010534
Riso14244 DVSS_B.t295 DVSS_B.t94 85.5095664056503
Riso14245 DVSS_B.t295 DVSS_B.t96 164.877233742514
Riso14246 DVSS_B.t295 VSS_A 1663.06517684658
Riso14247 DVSS_B.t295 VSS_B 223.719834316282
Riso14248 DVSS_B.t297 DVSS_B.t299 111.520603016028
Riso14249 DVSS_B.t297 DVSS_B.t301 581.747278381021
Riso14250 DVSS_B.t297 DVSS_B.t302 70870.6984835324
Riso14251 DVSS_B.t297 DVSS_B.t303 581.747278381021
Riso14252 DVSS_B.t297 DVSS_B.t305 39.5116216084411
Riso14253 DVSS_B.t297 DVSS_B.t322 966.597395115256
Riso14254 DVSS_B.t297 DVSS_B.t325 47763.9053073471
Riso14255 DVSS_B.t297 DVSS_B.t326 378.720874047976
Riso14256 DVSS_B.t297 DVSS_B.t329 274.923336678163
Riso14257 DVSS_B.t297 DVSS_B.t331 521.995460199884
Riso14258 DVSS_B.t297 DVSS_B.t333 499.541191045827
Riso14259 DVSS_B.t297 DVSS_B.t335 270.419103155661
Riso14260 DVSS_B.t297 DVSS_B.t337 235.856282102029
Riso14261 DVSS_B.t297 DVSS_B.t339 521.995460199884
Riso14262 DVSS_B.t297 DVSS_B.t341 499.541191045827
Riso14263 DVSS_B.t297 DVSS_B.t343 207.506022800375
Riso14264 DVSS_B.t297 DVSS_B.t345 95584.5780209661
Riso14265 DVSS_B.t297 DVSS_B.t346 351.336107826984
Riso14266 DVSS_B.t297 DVSS_B.t348 65.8351296657675
Riso14267 DVSS_B.t297 DVSS_B.t35 193.08639546778
Riso14268 DVSS_B.t297 DVSS_B.t350 192.38103102842
Riso14269 DVSS_B.t297 DVSS_B.t352 204.957454616503
Riso14270 DVSS_B.t297 DVSS_B.t355 305126.461528137
Riso14271 DVSS_B.t297 DVSS_B.t356 458.560356001596
Riso14272 DVSS_B.t297 DVSS_B.t358 535.575649681531
Riso14273 DVSS_B.t297 DVSS_B.t36 48965.6843096446
Riso14274 DVSS_B.t297 DVSS_B.t360 329.385311919813
Riso14275 DVSS_B.t297 DVSS_B.t364 606.017590930004
Riso14276 DVSS_B.t297 DVSS_B.t366 612.753765051766
Riso14277 DVSS_B.t297 DVSS_B.t37 759.402039509168
Riso14278 DVSS_B.t297 DVSS_B.t509 612.753765051766
Riso14279 DVSS_B.t297 DVSS_B.t515 47.6763241724958
Riso14280 DVSS_B.t297 DVSS_B.t525 825.400454164463
Riso14281 DVSS_B.t297 DVSS_B.t529 218.521217781216
Riso14282 DVSS_B.t297 DVSS_B.t531 47.6763241724958
Riso14283 DVSS_B.t297 DVSS_B.t59 16003.8170839232
Riso14284 DVSS_B.t297 DVSS_B.t60 100.073932320985
Riso14285 DVSS_B.t297 DVSS_B.t66 40.195373193485
Riso14286 DVSS_B.t297 DVSS_B.t68 111.520603016028
Riso14287 DVSS_B.t297 DVSS_B.t70 355.517133955106
Riso14288 DVSS_B.t297 DVSS_B.t72 565.453961567905
Riso14289 DVSS_B.t297 DVSS_B.t74 966.597395115256
Riso14290 DVSS_B.t297 DVSS_B.t76 160.891370359028
Riso14291 DVSS_B.t297 DVSS_B.t80 143.994896857435
Riso14292 DVSS_B.t297 DVSS_B.t82 83.3670983464817
Riso14293 DVSS_B.t297 DVSS_B.t84 825.400454164463
Riso14294 DVSS_B.t297 DVSS_B.t89 47763.9053073471
Riso14295 DVSS_B.t297 DVSS_B.t90 464.185794824784
Riso14296 DVSS_B.t297 DVSS_B.t94 329.385311919813
Riso14297 DVSS_B.t297 DVSS_B.t96 501.320341360051
Riso14298 DVSS_B.t297 VSS_A 950.933817304375
Riso14299 DVSS_B.t297 VSS_B 146.889913555606
Riso14300 DVSS_B.t298 DVSS_B.t67 66.3487
Riso14301 DVSS_B.t299 DVSS_B.t301 993.707117573775
Riso14302 DVSS_B.t299 DVSS_B.t302 119416.825530607
Riso14303 DVSS_B.t299 DVSS_B.t303 993.707117573775
Riso14304 DVSS_B.t299 DVSS_B.t305 96.0459988669639
Riso14305 DVSS_B.t299 DVSS_B.t322 360.184502745662
Riso14306 DVSS_B.t299 DVSS_B.t325 88283.6761527032
Riso14307 DVSS_B.t299 DVSS_B.t326 724.113429647593
Riso14308 DVSS_B.t299 DVSS_B.t329 148.498769088232
Riso14309 DVSS_B.t299 DVSS_B.t331 272.553678690286
Riso14310 DVSS_B.t299 DVSS_B.t333 259.937893938231
Riso14311 DVSS_B.t299 DVSS_B.t335 144.650560092669
Riso14312 DVSS_B.t299 DVSS_B.t337 125.388600114306
Riso14313 DVSS_B.t299 DVSS_B.t339 272.553678690286
Riso14314 DVSS_B.t299 DVSS_B.t341 259.937893938231
Riso14315 DVSS_B.t299 DVSS_B.t343 108.509111959696
Riso14316 DVSS_B.t299 DVSS_B.t345 48211.4273046576
Riso14317 DVSS_B.t299 DVSS_B.t346 182.430381072419
Riso14318 DVSS_B.t299 DVSS_B.t348 188.846313871172
Riso14319 DVSS_B.t299 DVSS_B.t35 420.422602881445
Riso14320 DVSS_B.t299 DVSS_B.t350 69.0208083006028
Riso14321 DVSS_B.t299 DVSS_B.t352 76.2609636557803
Riso14322 DVSS_B.t299 DVSS_B.t355 147368.061774476
Riso14323 DVSS_B.t299 DVSS_B.t356 195.108392346295
Riso14324 DVSS_B.t299 DVSS_B.t358 965.580995493636
Riso14325 DVSS_B.t299 DVSS_B.t36 25078.31189469
Riso14326 DVSS_B.t299 DVSS_B.t360 651.385016963825
Riso14327 DVSS_B.t299 DVSS_B.t364 1063.49516890581
Riso14328 DVSS_B.t299 DVSS_B.t366 1059.24728691083
Riso14329 DVSS_B.t299 DVSS_B.t37 388.576423607267
Riso14330 DVSS_B.t299 DVSS_B.t509 1059.24728691083
Riso14331 DVSS_B.t299 DVSS_B.t515 147.433695886958
Riso14332 DVSS_B.t299 DVSS_B.t525 320.854905089406
Riso14333 DVSS_B.t299 DVSS_B.t529 466.282970277239
Riso14334 DVSS_B.t299 DVSS_B.t531 147.433695886958
Riso14335 DVSS_B.t299 DVSS_B.t59 24685.4605453211
Riso14336 DVSS_B.t299 DVSS_B.t60 252.299690161954
Riso14337 DVSS_B.t299 DVSS_B.t66 128.674992451353
Riso14338 DVSS_B.t299 DVSS_B.t68 0.0669608039982236
Riso14339 DVSS_B.t299 DVSS_B.t70 690.984813867472
Riso14340 DVSS_B.t299 DVSS_B.t72 1009.8470573387
Riso14341 DVSS_B.t299 DVSS_B.t74 360.184502745662
Riso14342 DVSS_B.t299 DVSS_B.t76 53.5821726253219
Riso14343 DVSS_B.t299 DVSS_B.t80 46.2402028310833
Riso14344 DVSS_B.t299 DVSS_B.t82 46.0335200823345
Riso14345 DVSS_B.t299 DVSS_B.t84 320.854905089406
Riso14346 DVSS_B.t299 DVSS_B.t89 88283.6761527032
Riso14347 DVSS_B.t299 DVSS_B.t90 853.747951435537
Riso14348 DVSS_B.t299 DVSS_B.t94 651.385016963825
Riso14349 DVSS_B.t299 DVSS_B.t96 912.750378633478
Riso14350 DVSS_B.t299 VSS_A 518.097108353324
Riso14351 DVSS_B.t299 VSS_B 83.543748019247
Riso14352 DVSS_B.t300 DVSS_B.t302 66.3487
Riso14353 DVSS_B.t301 DVSS_B.t302 3208.20564627279
Riso14354 DVSS_B.t301 DVSS_B.t303 0.0668821535626179
Riso14355 DVSS_B.t301 DVSS_B.t305 618.935550300872
Riso14356 DVSS_B.t301 DVSS_B.t322 5067.69524977251
Riso14357 DVSS_B.t301 DVSS_B.t325 10663.1417043643
Riso14358 DVSS_B.t301 DVSS_B.t326 108.015798519143
Riso14359 DVSS_B.t301 DVSS_B.t329 965.347581791195
Riso14360 DVSS_B.t301 DVSS_B.t331 1869.62767355324
Riso14361 DVSS_B.t301 DVSS_B.t333 1772.60307225861
Riso14362 DVSS_B.t301 DVSS_B.t335 939.582416016702
Riso14363 DVSS_B.t301 DVSS_B.t337 864.43537685093
Riso14364 DVSS_B.t301 DVSS_B.t339 1869.62767355324
Riso14365 DVSS_B.t301 DVSS_B.t341 1772.60307225861
Riso14366 DVSS_B.t301 DVSS_B.t343 771.189376373498
Riso14367 DVSS_B.t301 DVSS_B.t345 381945.7366666
Riso14368 DVSS_B.t301 DVSS_B.t346 1377.33947492442
Riso14369 DVSS_B.t301 DVSS_B.t348 417.088687467171
Riso14370 DVSS_B.t301 DVSS_B.t35 219.746302310747
Riso14371 DVSS_B.t301 DVSS_B.t350 1195.63814913661
Riso14372 DVSS_B.t301 DVSS_B.t352 1192.12601487491
Riso14373 DVSS_B.t301 DVSS_B.t355 1256765.95764269
Riso14374 DVSS_B.t301 DVSS_B.t356 2093.51543258223
Riso14375 DVSS_B.t301 DVSS_B.t358 61.3101704014127
Riso14376 DVSS_B.t301 DVSS_B.t36 204973.326957081
Riso14377 DVSS_B.t301 DVSS_B.t360 137.624738764229
Riso14378 DVSS_B.t301 DVSS_B.t364 40.3684433969124
Riso14379 DVSS_B.t301 DVSS_B.t366 29.4781897029775
Riso14380 DVSS_B.t301 DVSS_B.t37 3190.8616407285
Riso14381 DVSS_B.t301 DVSS_B.t509 29.4781897029775
Riso14382 DVSS_B.t301 DVSS_B.t515 500.052477786351
Riso14383 DVSS_B.t301 DVSS_B.t525 4123.47442231695
Riso14384 DVSS_B.t301 DVSS_B.t529 204.120878245618
Riso14385 DVSS_B.t301 DVSS_B.t531 500.052477786351
Riso14386 DVSS_B.t301 DVSS_B.t59 16450.1553130744
Riso14387 DVSS_B.t301 DVSS_B.t60 303.603284738556
Riso14388 DVSS_B.t301 DVSS_B.t66 541.623994642638
Riso14389 DVSS_B.t301 DVSS_B.t68 993.707117573775
Riso14390 DVSS_B.t301 DVSS_B.t70 122.312240984451
Riso14391 DVSS_B.t301 DVSS_B.t72 53.7932548062042
Riso14392 DVSS_B.t301 DVSS_B.t74 5067.69524977251
Riso14393 DVSS_B.t301 DVSS_B.t76 1151.35933039464
Riso14394 DVSS_B.t301 DVSS_B.t80 1108.15541018533
Riso14395 DVSS_B.t301 DVSS_B.t82 859.578396062478
Riso14396 DVSS_B.t301 DVSS_B.t84 4123.47442231695
Riso14397 DVSS_B.t301 DVSS_B.t89 10663.1417043643
Riso14398 DVSS_B.t301 DVSS_B.t90 77.0720256126252
Riso14399 DVSS_B.t301 DVSS_B.t94 137.624738764229
Riso14400 DVSS_B.t301 DVSS_B.t96 69.1584453820539
Riso14401 DVSS_B.t301 VSS_A 3273.74973511583
Riso14402 DVSS_B.t301 VSS_B 418.278214678146
Riso14403 DVSS_B.t302 DVSS_B.t303 3208.20564627279
Riso14404 DVSS_B.t302 DVSS_B.t305 75244.7448141053
Riso14405 DVSS_B.t302 DVSS_B.t322 601123.747265434
Riso14406 DVSS_B.t302 DVSS_B.t325 1443227.94796985
Riso14407 DVSS_B.t302 DVSS_B.t326 14648.7915513392
Riso14408 DVSS_B.t302 DVSS_B.t329 112985.276036725
Riso14409 DVSS_B.t302 DVSS_B.t331 218531.178469439
Riso14410 DVSS_B.t302 DVSS_B.t333 206514.704889409
Riso14411 DVSS_B.t302 DVSS_B.t335 109560.435236013
Riso14412 DVSS_B.t302 DVSS_B.t337 101459.022476399
Riso14413 DVSS_B.t302 DVSS_B.t339 218531.178469439
Riso14414 DVSS_B.t302 DVSS_B.t341 206514.704889409
Riso14415 DVSS_B.t302 DVSS_B.t343 90347.0577582095
Riso14416 DVSS_B.t302 DVSS_B.t345 45442737.3440835
Riso14417 DVSS_B.t302 DVSS_B.t346 163903.309070838
Riso14418 DVSS_B.t302 DVSS_B.t348 51133.9026799483
Riso14419 DVSS_B.t302 DVSS_B.t35 28071.4061226391
Riso14420 DVSS_B.t302 DVSS_B.t350 142267.778764012
Riso14421 DVSS_B.t302 DVSS_B.t352 141531.358166789
Riso14422 DVSS_B.t302 DVSS_B.t355 149480368.205782
Riso14423 DVSS_B.t302 DVSS_B.t356 248736.841515092
Riso14424 DVSS_B.t302 DVSS_B.t358 8729.58754922703
Riso14425 DVSS_B.t302 DVSS_B.t36 23915930.1786451
Riso14426 DVSS_B.t302 DVSS_B.t360 18371.4195892759
Riso14427 DVSS_B.t302 DVSS_B.t364 5927.25136330284
Riso14428 DVSS_B.t302 DVSS_B.t366 4411.58724239467
Riso14429 DVSS_B.t302 DVSS_B.t37 372385.581077599
Riso14430 DVSS_B.t302 DVSS_B.t509 4411.58724239467
Riso14431 DVSS_B.t302 DVSS_B.t515 61135.1174939734
Riso14432 DVSS_B.t302 DVSS_B.t525 489413.277900016
Riso14433 DVSS_B.t302 DVSS_B.t529 26325.9978738146
Riso14434 DVSS_B.t302 DVSS_B.t531 61135.1174939734
Riso14435 DVSS_B.t302 DVSS_B.t59 1865649.40620662
Riso14436 DVSS_B.t302 DVSS_B.t60 37330.8492652752
Riso14437 DVSS_B.t302 DVSS_B.t66 66106.7095628215
Riso14438 DVSS_B.t302 DVSS_B.t68 119416.825530607
Riso14439 DVSS_B.t302 DVSS_B.t70 16458.1045320414
Riso14440 DVSS_B.t302 DVSS_B.t72 7739.83175149707
Riso14441 DVSS_B.t302 DVSS_B.t74 601123.747265434
Riso14442 DVSS_B.t302 DVSS_B.t76 137597.01643694
Riso14443 DVSS_B.t302 DVSS_B.t80 132699.985724336
Riso14444 DVSS_B.t302 DVSS_B.t82 103594.466138459
Riso14445 DVSS_B.t302 DVSS_B.t84 489413.277900016
Riso14446 DVSS_B.t302 DVSS_B.t89 1443227.94796985
Riso14447 DVSS_B.t302 DVSS_B.t90 10744.50541548
Riso14448 DVSS_B.t302 DVSS_B.t94 18371.4195892759
Riso14449 DVSS_B.t302 DVSS_B.t96 9743.56876149187
Riso14450 DVSS_B.t302 VSS_A 382717.307511831
Riso14451 DVSS_B.t302 VSS_B 48091.9052427556
Riso14452 DVSS_B.t303 DVSS_B.t305 618.935550300872
Riso14453 DVSS_B.t303 DVSS_B.t322 5067.69524977251
Riso14454 DVSS_B.t303 DVSS_B.t325 10663.1417043643
Riso14455 DVSS_B.t303 DVSS_B.t326 108.015798519143
Riso14456 DVSS_B.t303 DVSS_B.t329 965.347581791195
Riso14457 DVSS_B.t303 DVSS_B.t331 1869.62767355324
Riso14458 DVSS_B.t303 DVSS_B.t333 1772.60307225861
Riso14459 DVSS_B.t303 DVSS_B.t335 939.582416016702
Riso14460 DVSS_B.t303 DVSS_B.t337 864.43537685093
Riso14461 DVSS_B.t303 DVSS_B.t339 1869.62767355324
Riso14462 DVSS_B.t303 DVSS_B.t341 1772.60307225861
Riso14463 DVSS_B.t303 DVSS_B.t343 771.189376373498
Riso14464 DVSS_B.t303 DVSS_B.t345 381945.7366666
Riso14465 DVSS_B.t303 DVSS_B.t346 1377.33947492442
Riso14466 DVSS_B.t303 DVSS_B.t348 417.088687467171
Riso14467 DVSS_B.t303 DVSS_B.t35 219.746302310747
Riso14468 DVSS_B.t303 DVSS_B.t350 1195.63814913661
Riso14469 DVSS_B.t303 DVSS_B.t352 1192.12601487491
Riso14470 DVSS_B.t303 DVSS_B.t355 1256765.95764269
Riso14471 DVSS_B.t303 DVSS_B.t356 2093.51543258223
Riso14472 DVSS_B.t303 DVSS_B.t358 61.3101704014127
Riso14473 DVSS_B.t303 DVSS_B.t36 204973.326957081
Riso14474 DVSS_B.t303 DVSS_B.t360 137.624738764229
Riso14475 DVSS_B.t303 DVSS_B.t364 40.3684433969124
Riso14476 DVSS_B.t303 DVSS_B.t366 29.4781897029775
Riso14477 DVSS_B.t303 DVSS_B.t37 3190.8616407285
Riso14478 DVSS_B.t303 DVSS_B.t509 29.4781897029775
Riso14479 DVSS_B.t303 DVSS_B.t515 500.052477786351
Riso14480 DVSS_B.t303 DVSS_B.t525 4123.47442231695
Riso14481 DVSS_B.t303 DVSS_B.t529 204.120878245618
Riso14482 DVSS_B.t303 DVSS_B.t531 500.052477786351
Riso14483 DVSS_B.t303 DVSS_B.t59 16450.1553130744
Riso14484 DVSS_B.t303 DVSS_B.t60 303.603284738556
Riso14485 DVSS_B.t303 DVSS_B.t66 541.623994642638
Riso14486 DVSS_B.t303 DVSS_B.t68 993.707117573775
Riso14487 DVSS_B.t303 DVSS_B.t70 122.312240984451
Riso14488 DVSS_B.t303 DVSS_B.t72 53.7932548062042
Riso14489 DVSS_B.t303 DVSS_B.t74 5067.69524977251
Riso14490 DVSS_B.t303 DVSS_B.t76 1151.35933039464
Riso14491 DVSS_B.t303 DVSS_B.t80 1108.15541018533
Riso14492 DVSS_B.t303 DVSS_B.t82 859.578396062478
Riso14493 DVSS_B.t303 DVSS_B.t84 4123.47442231695
Riso14494 DVSS_B.t303 DVSS_B.t89 10663.1417043643
Riso14495 DVSS_B.t303 DVSS_B.t90 77.0720256126252
Riso14496 DVSS_B.t303 DVSS_B.t94 137.624738764229
Riso14497 DVSS_B.t303 DVSS_B.t96 69.1584453820539
Riso14498 DVSS_B.t303 VSS_A 3273.74973511583
Riso14499 DVSS_B.t303 VSS_B 418.278214678146
Riso14500 DVSS_B.t305 DVSS_B.t322 856.294821519518
Riso14501 DVSS_B.t305 DVSS_B.t325 51496.0097091273
Riso14502 DVSS_B.t305 DVSS_B.t326 410.56219728836
Riso14503 DVSS_B.t305 DVSS_B.t329 252.535341996905
Riso14504 DVSS_B.t305 DVSS_B.t331 478.125180111101
Riso14505 DVSS_B.t305 DVSS_B.t333 457.436127513841
Riso14506 DVSS_B.t305 DVSS_B.t335 248.228037445791
Riso14507 DVSS_B.t305 DVSS_B.t337 216.247289465065
Riso14508 DVSS_B.t305 DVSS_B.t339 478.125180111101
Riso14509 DVSS_B.t305 DVSS_B.t341 457.436127513841
Riso14510 DVSS_B.t305 DVSS_B.t343 189.955234227283
Riso14511 DVSS_B.t305 DVSS_B.t345 87235.4013792996
Riso14512 DVSS_B.t305 DVSS_B.t346 321.434044637572
Riso14513 DVSS_B.t305 DVSS_B.t348 75.8262361345515
Riso14514 DVSS_B.t305 DVSS_B.t35 213.895881041146
Riso14515 DVSS_B.t305 DVSS_B.t350 169.422110220124
Riso14516 DVSS_B.t305 DVSS_B.t352 181.26430578774
Riso14517 DVSS_B.t305 DVSS_B.t355 277422.814091252
Riso14518 DVSS_B.t305 DVSS_B.t356 411.977199784866
Riso14519 DVSS_B.t305 DVSS_B.t358 574.853962228456
Riso14520 DVSS_B.t305 DVSS_B.t36 44633.8049566657
Riso14521 DVSS_B.t305 DVSS_B.t360 359.093184310337
Riso14522 DVSS_B.t305 DVSS_B.t364 647.543901765201
Riso14523 DVSS_B.t305 DVSS_B.t366 653.14951834088
Riso14524 DVSS_B.t305 DVSS_B.t37 692.133423369118
Riso14525 DVSS_B.t305 DVSS_B.t509 653.14951834088
Riso14526 DVSS_B.t305 DVSS_B.t515 55.4268738276773
Riso14527 DVSS_B.t305 DVSS_B.t525 734.625406414423
Riso14528 DVSS_B.t305 DVSS_B.t529 241.267463887378
Riso14529 DVSS_B.t305 DVSS_B.t531 55.4268738276773
Riso14530 DVSS_B.t305 DVSS_B.t59 16799.2268104228
Riso14531 DVSS_B.t305 DVSS_B.t60 113.322506210338
Riso14532 DVSS_B.t305 DVSS_B.t66 46.924530296379
Riso14533 DVSS_B.t305 DVSS_B.t68 96.0459988669639
Riso14534 DVSS_B.t305 DVSS_B.t70 386.461557205248
Riso14535 DVSS_B.t305 DVSS_B.t72 605.957150482338
Riso14536 DVSS_B.t305 DVSS_B.t74 856.294821519518
Riso14537 DVSS_B.t305 DVSS_B.t76 140.429693489005
Riso14538 DVSS_B.t305 DVSS_B.t80 125.115105823218
Riso14539 DVSS_B.t305 DVSS_B.t82 71.2040975289504
Riso14540 DVSS_B.t305 DVSS_B.t84 734.625406414423
Riso14541 DVSS_B.t305 DVSS_B.t89 51496.0097091273
Riso14542 DVSS_B.t305 DVSS_B.t90 499.929882371037
Riso14543 DVSS_B.t305 DVSS_B.t94 359.093184310337
Riso14544 DVSS_B.t305 DVSS_B.t96 538.986454456892
Riso14545 DVSS_B.t305 VSS_A 874.331997492871
Riso14546 DVSS_B.t305 VSS_B 135.909882526728
Riso14547 DVSS_B.t321 DVSS_B.t73 356.886
Riso14548 DVSS_B.t322 DVSS_B.t325 483510.725587785
Riso14549 DVSS_B.t322 DVSS_B.t326 4079.27892648699
Riso14550 DVSS_B.t322 DVSS_B.t329 172.599959766998
Riso14551 DVSS_B.t322 DVSS_B.t331 285.333576685189
Riso14552 DVSS_B.t322 DVSS_B.t333 291.585852345372
Riso14553 DVSS_B.t322 DVSS_B.t335 174.929598140211
Riso14554 DVSS_B.t322 DVSS_B.t337 143.639929184872
Riso14555 DVSS_B.t322 DVSS_B.t339 285.333576685189
Riso14556 DVSS_B.t322 DVSS_B.t341 291.585852345372
Riso14557 DVSS_B.t322 DVSS_B.t343 127.317598752218
Riso14558 DVSS_B.t322 DVSS_B.t345 17262.977278732
Riso14559 DVSS_B.t322 DVSS_B.t346 74.1874982998565
Riso14560 DVSS_B.t322 DVSS_B.t348 1438.63959056653
Riso14561 DVSS_B.t322 DVSS_B.t35 2577.19111973622
Riso14562 DVSS_B.t322 DVSS_B.t350 159.201829390236
Riso14563 DVSS_B.t322 DVSS_B.t352 132.934950589459
Riso14564 DVSS_B.t322 DVSS_B.t355 45006.257911254
Riso14565 DVSS_B.t322 DVSS_B.t356 42.6804252459829
Riso14566 DVSS_B.t322 DVSS_B.t358 5185.85534553092
Riso14567 DVSS_B.t322 DVSS_B.t36 77135.8650246703
Riso14568 DVSS_B.t322 DVSS_B.t360 3763.60495989847
Riso14569 DVSS_B.t322 DVSS_B.t364 5570.80773509555
Riso14570 DVSS_B.t322 DVSS_B.t366 5467.13251207964
Riso14571 DVSS_B.t322 DVSS_B.t37 1200.34188810837
Riso14572 DVSS_B.t322 DVSS_B.t509 5467.13251207964
Riso14573 DVSS_B.t322 DVSS_B.t515 1202.20791521981
Riso14574 DVSS_B.t322 DVSS_B.t525 54.7946959357319
Riso14575 DVSS_B.t322 DVSS_B.t529 2826.97511231578
Riso14576 DVSS_B.t322 DVSS_B.t531 1202.20791521981
Riso14577 DVSS_B.t322 DVSS_B.t59 112261.842450539
Riso14578 DVSS_B.t322 DVSS_B.t60 1710.02631543506
Riso14579 DVSS_B.t322 DVSS_B.t66 1082.63023240449
Riso14580 DVSS_B.t322 DVSS_B.t68 360.184502745662
Riso14581 DVSS_B.t322 DVSS_B.t70 3942.15408437973
Riso14582 DVSS_B.t322 DVSS_B.t72 5377.69868342895
Riso14583 DVSS_B.t322 DVSS_B.t74 0.725677299991457
Riso14584 DVSS_B.t322 DVSS_B.t76 224.993310592486
Riso14585 DVSS_B.t322 DVSS_B.t80 265.144936279763
Riso14586 DVSS_B.t322 DVSS_B.t82 470.998467091223
Riso14587 DVSS_B.t322 DVSS_B.t84 54.7946959357319
Riso14588 DVSS_B.t322 DVSS_B.t89 483510.725587785
Riso14589 DVSS_B.t322 DVSS_B.t90 4663.09862657295
Riso14590 DVSS_B.t322 DVSS_B.t94 3763.60495989847
Riso14591 DVSS_B.t322 DVSS_B.t96 4943.88692178841
Riso14592 DVSS_B.t322 VSS_A 609.017047215001
Riso14593 DVSS_B.t322 VSS_B 109.596991783938
Riso14594 DVSS_B.t325 DVSS_B.t326 4738.68196417508
Riso14595 DVSS_B.t325 DVSS_B.t329 94997.6989504504
Riso14596 DVSS_B.t325 DVSS_B.t331 183783.702460563
Riso14597 DVSS_B.t325 DVSS_B.t333 174456.807755679
Riso14598 DVSS_B.t325 DVSS_B.t335 92636.0728808115
Riso14599 DVSS_B.t325 DVSS_B.t337 84531.6520302207
Riso14600 DVSS_B.t325 DVSS_B.t339 183783.702460563
Riso14601 DVSS_B.t325 DVSS_B.t341 174456.807755679
Riso14602 DVSS_B.t325 DVSS_B.t343 75280.3343987356
Riso14603 DVSS_B.t325 DVSS_B.t345 37027977.7781756
Riso14604 DVSS_B.t325 DVSS_B.t346 133658.562892934
Riso14605 DVSS_B.t325 DVSS_B.t348 32376.6901515752
Riso14606 DVSS_B.t325 DVSS_B.t35 13296.5146737282
Riso14607 DVSS_B.t325 DVSS_B.t350 110523.807786383
Riso14608 DVSS_B.t325 DVSS_B.t352 111048.527284968
Riso14609 DVSS_B.t325 DVSS_B.t355 121644081.27574
Riso14610 DVSS_B.t325 DVSS_B.t356 201476.321947978
Riso14611 DVSS_B.t325 DVSS_B.t358 6262.36927038814
Riso14612 DVSS_B.t325 DVSS_B.t36 19522155.4310257
Riso14613 DVSS_B.t325 DVSS_B.t360 6584.39205989308
Riso14614 DVSS_B.t325 DVSS_B.t364 8836.02887893756
Riso14615 DVSS_B.t325 DVSS_B.t366 10158.481858611
Riso14616 DVSS_B.t325 DVSS_B.t37 303700.365180286
Riso14617 DVSS_B.t325 DVSS_B.t509 10158.481858611
Riso14618 DVSS_B.t325 DVSS_B.t515 39943.5156574438
Riso14619 DVSS_B.t325 DVSS_B.t525 394660.662990591
Riso14620 DVSS_B.t325 DVSS_B.t529 11758.9011704138
Riso14621 DVSS_B.t325 DVSS_B.t531 39943.5156574438
Riso14622 DVSS_B.t325 DVSS_B.t59 1719133.72711855
Riso14623 DVSS_B.t325 DVSS_B.t60 22530.3477113651
Riso14624 DVSS_B.t325 DVSS_B.t66 43869.1655051334
Riso14625 DVSS_B.t325 DVSS_B.t68 88283.6761527032
Riso14626 DVSS_B.t325 DVSS_B.t70 5600.62187897058
Riso14627 DVSS_B.t325 DVSS_B.t72 7129.89260432608
Riso14628 DVSS_B.t325 DVSS_B.t74 483510.725587785
Riso14629 DVSS_B.t325 DVSS_B.t76 104748.098993351
Riso14630 DVSS_B.t325 DVSS_B.t80 100013.43206676
Riso14631 DVSS_B.t325 DVSS_B.t82 75210.3716403229
Riso14632 DVSS_B.t325 DVSS_B.t84 394660.662990591
Riso14633 DVSS_B.t325 DVSS_B.t89 73732.9345300572
Riso14634 DVSS_B.t325 DVSS_B.t90 4666.6047454208
Riso14635 DVSS_B.t325 DVSS_B.t94 6584.39205989308
Riso14636 DVSS_B.t325 DVSS_B.t96 5433.92135345516
Riso14637 DVSS_B.t325 VSS_A 323055.658796378
Riso14638 DVSS_B.t325 VSS_B 42370.7212103935
Riso14639 DVSS_B.t326 DVSS_B.t329 817.79885240711
Riso14640 DVSS_B.t326 DVSS_B.t331 1583.2454741209
Riso14641 DVSS_B.t326 DVSS_B.t333 1507.39836295828
Riso14642 DVSS_B.t326 DVSS_B.t335 800.272026587105
Riso14643 DVSS_B.t326 DVSS_B.t337 724.90073211588
Riso14644 DVSS_B.t326 DVSS_B.t339 1583.2454741209
Riso14645 DVSS_B.t326 DVSS_B.t341 1507.39836295828
Riso14646 DVSS_B.t326 DVSS_B.t343 646.233585482921
Riso14647 DVSS_B.t326 DVSS_B.t345 313406.534402903
Riso14648 DVSS_B.t326 DVSS_B.t346 1131.51049792537
Riso14649 DVSS_B.t326 DVSS_B.t348 251.082048960639
Riso14650 DVSS_B.t326 DVSS_B.t35 94.8612575334884
Riso14651 DVSS_B.t326 DVSS_B.t350 923.444701167119
Riso14652 DVSS_B.t326 DVSS_B.t352 931.322282719418
Riso14653 DVSS_B.t326 DVSS_B.t355 1029274.17369711
Riso14654 DVSS_B.t326 DVSS_B.t356 1702.77146005235
Riso14655 DVSS_B.t326 DVSS_B.t358 64.6789904678678
Riso14656 DVSS_B.t326 DVSS_B.t36 167157.322652288
Riso14657 DVSS_B.t326 DVSS_B.t360 44.3292819159557
Riso14658 DVSS_B.t326 DVSS_B.t364 90.3392273743521
Riso14659 DVSS_B.t326 DVSS_B.t366 103.281412064433
Riso14660 DVSS_B.t326 DVSS_B.t37 2599.54510433101
Riso14661 DVSS_B.t326 DVSS_B.t509 103.281412064433
Riso14662 DVSS_B.t326 DVSS_B.t515 313.226652519204
Riso14663 DVSS_B.t326 DVSS_B.t525 3331.76901849228
Riso14664 DVSS_B.t326 DVSS_B.t529 82.7595259617916
Riso14665 DVSS_B.t326 DVSS_B.t531 313.226652519204
Riso14666 DVSS_B.t326 DVSS_B.t59 15528.6834245137
Riso14667 DVSS_B.t326 DVSS_B.t60 171.823249801803
Riso14668 DVSS_B.t326 DVSS_B.t66 345.922641505063
Riso14669 DVSS_B.t326 DVSS_B.t68 724.113429647593
Riso14670 DVSS_B.t326 DVSS_B.t70 37.3646039190236
Riso14671 DVSS_B.t326 DVSS_B.t72 73.3838775697343
Riso14672 DVSS_B.t326 DVSS_B.t74 4079.27892648699
Riso14673 DVSS_B.t326 DVSS_B.t76 868.557821068668
Riso14674 DVSS_B.t326 DVSS_B.t80 826.213964054565
Riso14675 DVSS_B.t326 DVSS_B.t82 612.731860276877
Riso14676 DVSS_B.t326 DVSS_B.t84 3331.76901849228
Riso14677 DVSS_B.t326 DVSS_B.t89 4738.68196417508
Riso14678 DVSS_B.t326 DVSS_B.t90 48.5258328959326
Riso14679 DVSS_B.t326 DVSS_B.t94 44.3292819159557
Riso14680 DVSS_B.t326 DVSS_B.t96 56.3160214267571
Riso14681 DVSS_B.t326 VSS_A 2785.67582856353
Riso14682 DVSS_B.t326 VSS_B 373.117935885685
Riso14683 DVSS_B.t329 DVSS_B.t331 0.404053365910278
Riso14684 DVSS_B.t329 DVSS_B.t333 9.14591748503968
Riso14685 DVSS_B.t329 DVSS_B.t335 1.28463187986639
Riso14686 DVSS_B.t329 DVSS_B.t337 2.59051349166629
Riso14687 DVSS_B.t329 DVSS_B.t339 6.28969439708081
Riso14688 DVSS_B.t329 DVSS_B.t341 9.14591748503968
Riso14689 DVSS_B.t329 DVSS_B.t343 3.44872680318382
Riso14690 DVSS_B.t329 DVSS_B.t345 15894.4372368045
Riso14691 DVSS_B.t329 DVSS_B.t346 58.0959354832757
Riso14692 DVSS_B.t329 DVSS_B.t348 355.118492416369
Riso14693 DVSS_B.t329 DVSS_B.t35 536.434704414419
Riso14694 DVSS_B.t329 DVSS_B.t350 88.1537175486034
Riso14695 DVSS_B.t329 DVSS_B.t352 77.9984216105572
Riso14696 DVSS_B.t329 DVSS_B.t355 51189.7715570815
Riso14697 DVSS_B.t329 DVSS_B.t356 79.1093525065766
Riso14698 DVSS_B.t329 DVSS_B.t358 1018.21902391489
Riso14699 DVSS_B.t329 DVSS_B.t36 10939.610496848
Riso14700 DVSS_B.t329 DVSS_B.t360 764.25088092526
Riso14701 DVSS_B.t329 DVSS_B.t364 1080.57113572232
Riso14702 DVSS_B.t329 DVSS_B.t366 1050.8197969893
Riso14703 DVSS_B.t329 DVSS_B.t37 169.73570666981
Riso14704 DVSS_B.t329 DVSS_B.t509 1050.8197969893
Riso14705 DVSS_B.t329 DVSS_B.t515 318.438132737798
Riso14706 DVSS_B.t329 DVSS_B.t525 145.684794123664
Riso14707 DVSS_B.t329 DVSS_B.t529 585.996542926376
Riso14708 DVSS_B.t329 DVSS_B.t531 318.438132737798
Riso14709 DVSS_B.t329 DVSS_B.t59 19007.2798924397
Riso14710 DVSS_B.t329 DVSS_B.t60 379.779685271877
Riso14711 DVSS_B.t329 DVSS_B.t66 297.10916962501
Riso14712 DVSS_B.t329 DVSS_B.t68 148.498769088232
Riso14713 DVSS_B.t329 DVSS_B.t70 795.532020126372
Riso14714 DVSS_B.t329 DVSS_B.t72 1051.93261835044
Riso14715 DVSS_B.t329 DVSS_B.t74 172.599959766998
Riso14716 DVSS_B.t329 DVSS_B.t76 110.715044463576
Riso14717 DVSS_B.t329 DVSS_B.t80 122.950187354063
Riso14718 DVSS_B.t329 DVSS_B.t82 173.486018837318
Riso14719 DVSS_B.t329 DVSS_B.t84 145.684794123664
Riso14720 DVSS_B.t329 DVSS_B.t89 94997.6989504504
Riso14721 DVSS_B.t329 DVSS_B.t90 921.490871494623
Riso14722 DVSS_B.t329 DVSS_B.t94 764.25088092526
Riso14723 DVSS_B.t329 DVSS_B.t96 974.01362481009
Riso14724 DVSS_B.t329 VSS_A 13.8873012492758
Riso14725 DVSS_B.t329 VSS_B 3.51473982386089
Riso14726 DVSS_B.t331 DVSS_B.t333 0.413238703655695
Riso14727 DVSS_B.t331 DVSS_B.t335 8.59468041989593
Riso14728 DVSS_B.t331 DVSS_B.t337 6.45116798666636
Riso14729 DVSS_B.t331 DVSS_B.t339 6.85733553611521
Riso14730 DVSS_B.t331 DVSS_B.t341 9.61737347921244
Riso14731 DVSS_B.t331 DVSS_B.t343 9.15742497936094
Riso14732 DVSS_B.t331 DVSS_B.t345 31688.1397313803
Riso14733 DVSS_B.t331 DVSS_B.t346 117.642481015383
Riso14734 DVSS_B.t331 DVSS_B.t348 680.068236140363
Riso14735 DVSS_B.t331 DVSS_B.t35 1034.43457278892
Riso14736 DVSS_B.t331 DVSS_B.t350 156.226900884813
Riso14737 DVSS_B.t331 DVSS_B.t352 137.161571567287
Riso14738 DVSS_B.t331 DVSS_B.t355 99628.3544724111
Riso14739 DVSS_B.t331 DVSS_B.t356 142.808005409617
Riso14740 DVSS_B.t331 DVSS_B.t358 1973.61236208347
Riso14741 DVSS_B.t331 DVSS_B.t36 19012.1841774176
Riso14742 DVSS_B.t331 DVSS_B.t360 1478.74285572519
Riso14743 DVSS_B.t331 DVSS_B.t364 2094.75883260541
Riso14744 DVSS_B.t331 DVSS_B.t366 2036.38257020315
Riso14745 DVSS_B.t331 DVSS_B.t37 294.9253215709
Riso14746 DVSS_B.t331 DVSS_B.t509 2036.38257020315
Riso14747 DVSS_B.t331 DVSS_B.t515 607.579574607454
Riso14748 DVSS_B.t331 DVSS_B.t525 247.961529416598
Riso14749 DVSS_B.t331 DVSS_B.t529 1130.9762013601
Riso14750 DVSS_B.t331 DVSS_B.t531 607.579574607454
Riso14751 DVSS_B.t331 DVSS_B.t59 36338.149174577
Riso14752 DVSS_B.t331 DVSS_B.t60 729.519583979635
Riso14753 DVSS_B.t331 DVSS_B.t66 565.579555330821
Riso14754 DVSS_B.t331 DVSS_B.t68 272.553678690286
Riso14755 DVSS_B.t331 DVSS_B.t70 1539.80077763858
Riso14756 DVSS_B.t331 DVSS_B.t72 2039.2389962905
Riso14757 DVSS_B.t331 DVSS_B.t74 285.333576685189
Riso14758 DVSS_B.t331 DVSS_B.t76 199.156659968529
Riso14759 DVSS_B.t331 DVSS_B.t80 222.730563767566
Riso14760 DVSS_B.t331 DVSS_B.t82 322.067302138741
Riso14761 DVSS_B.t331 DVSS_B.t84 247.961529416598
Riso14762 DVSS_B.t331 DVSS_B.t89 183783.702460563
Riso14763 DVSS_B.t331 DVSS_B.t90 1785.19581796598
Riso14764 DVSS_B.t331 DVSS_B.t94 1478.74285572519
Riso14765 DVSS_B.t331 DVSS_B.t96 1887.50974676565
Riso14766 DVSS_B.t331 VSS_A 33.3954080084334
Riso14767 DVSS_B.t331 VSS_B 6.3186464104316
Riso14768 DVSS_B.t333 DVSS_B.t335 0.404598962617403
Riso14769 DVSS_B.t333 DVSS_B.t337 9.56143099132741
Riso14770 DVSS_B.t333 DVSS_B.t339 9.61737347921244
Riso14771 DVSS_B.t333 DVSS_B.t341 7.33738688071855
Riso14772 DVSS_B.t333 DVSS_B.t343 6.77884320445216
Riso14773 DVSS_B.t333 DVSS_B.t345 35291.2450767224
Riso14774 DVSS_B.t333 DVSS_B.t346 132.134203118136
Riso14775 DVSS_B.t333 DVSS_B.t348 649.478458257071
Riso14776 DVSS_B.t333 DVSS_B.t35 982.147291630329
Riso14777 DVSS_B.t333 DVSS_B.t350 148.606010602241
Riso14778 DVSS_B.t333 DVSS_B.t352 130.43700253692
Riso14779 DVSS_B.t333 DVSS_B.t355 109575.863685406
Riso14780 DVSS_B.t333 DVSS_B.t356 151.514020636334
Riso14781 DVSS_B.t333 DVSS_B.t358 1878.86505176903
Riso14782 DVSS_B.t333 DVSS_B.t36 15437.1166985975
Riso14783 DVSS_B.t333 DVSS_B.t360 1408.35257197319
Riso14784 DVSS_B.t333 DVSS_B.t364 1992.31558411108
Riso14785 DVSS_B.t333 DVSS_B.t366 1934.09818803435
Riso14786 DVSS_B.t333 DVSS_B.t37 239.417655627765
Riso14787 DVSS_B.t333 DVSS_B.t509 1934.09818803435
Riso14788 DVSS_B.t333 DVSS_B.t515 581.27480509393
Riso14789 DVSS_B.t333 DVSS_B.t525 256.429863148727
Riso14790 DVSS_B.t333 DVSS_B.t529 1074.87622321504
Riso14791 DVSS_B.t333 DVSS_B.t531 581.27480509393
Riso14792 DVSS_B.t333 DVSS_B.t59 33451.8707530649
Riso14793 DVSS_B.t333 DVSS_B.t60 692.591708146091
Riso14794 DVSS_B.t333 DVSS_B.t66 541.256876162163
Riso14795 DVSS_B.t333 DVSS_B.t68 259.937893938231
Riso14796 DVSS_B.t333 DVSS_B.t70 1466.44265777539
Riso14797 DVSS_B.t333 DVSS_B.t72 1941.06037736855
Riso14798 DVSS_B.t333 DVSS_B.t74 291.585852345372
Riso14799 DVSS_B.t333 DVSS_B.t76 189.603377089522
Riso14800 DVSS_B.t333 DVSS_B.t80 212.163855770821
Riso14801 DVSS_B.t333 DVSS_B.t82 307.494106521785
Riso14802 DVSS_B.t333 DVSS_B.t84 256.429863148727
Riso14803 DVSS_B.t333 DVSS_B.t89 174456.807755679
Riso14804 DVSS_B.t333 DVSS_B.t90 1699.15905109992
Riso14805 DVSS_B.t333 DVSS_B.t94 1408.35257197319
Riso14806 DVSS_B.t333 DVSS_B.t96 1796.85673821514
Riso14807 DVSS_B.t333 VSS_A 37.3095716359244
Riso14808 DVSS_B.t333 VSS_B 5.22135724266397
Riso14809 DVSS_B.t335 DVSS_B.t337 3.39572798605378
Riso14810 DVSS_B.t335 DVSS_B.t339 8.59468041989593
Riso14811 DVSS_B.t335 DVSS_B.t341 6.42455365058968
Riso14812 DVSS_B.t335 DVSS_B.t343 2.49554424507018
Riso14813 DVSS_B.t335 DVSS_B.t345 18079.4199090308
Riso14814 DVSS_B.t335 DVSS_B.t346 66.7063381554801
Riso14815 DVSS_B.t335 DVSS_B.t348 348.785720946574
Riso14816 DVSS_B.t335 DVSS_B.t35 523.432443424868
Riso14817 DVSS_B.t335 DVSS_B.t350 84.9030550163693
Riso14818 DVSS_B.t335 DVSS_B.t352 74.9458312857548
Riso14819 DVSS_B.t335 DVSS_B.t355 57392.9676663036
Riso14820 DVSS_B.t335 DVSS_B.t356 84.7323499049061
Riso14821 DVSS_B.t335 DVSS_B.t358 995.964686972137
Riso14822 DVSS_B.t335 DVSS_B.t36 9010.68771833767
Riso14823 DVSS_B.t335 DVSS_B.t360 748.238993762208
Riso14824 DVSS_B.t335 DVSS_B.t364 1055.64176248748
Riso14825 DVSS_B.t335 DVSS_B.t366 1024.86872962049
Riso14826 DVSS_B.t335 DVSS_B.t37 139.780889018338
Riso14827 DVSS_B.t335 DVSS_B.t509 1024.86872962049
Riso14828 DVSS_B.t335 DVSS_B.t515 313.291692600121
Riso14829 DVSS_B.t335 DVSS_B.t525 150.408822599912
Riso14830 DVSS_B.t335 DVSS_B.t529 572.437222670577
Riso14831 DVSS_B.t335 DVSS_B.t531 313.291692600121
Riso14832 DVSS_B.t335 DVSS_B.t59 17885.2413759014
Riso14833 DVSS_B.t335 DVSS_B.t60 370.528945137889
Riso14834 DVSS_B.t335 DVSS_B.t66 292.336413429484
Riso14835 DVSS_B.t335 DVSS_B.t68 144.650560092669
Riso14836 DVSS_B.t335 DVSS_B.t70 778.779497698561
Riso14837 DVSS_B.t335 DVSS_B.t72 1028.70942898013
Riso14838 DVSS_B.t335 DVSS_B.t74 174.929598140211
Riso14839 DVSS_B.t335 DVSS_B.t76 107.138271501293
Riso14840 DVSS_B.t335 DVSS_B.t80 119.252942659024
Riso14841 DVSS_B.t335 DVSS_B.t82 169.581301983366
Riso14842 DVSS_B.t335 DVSS_B.t84 150.408822599912
Riso14843 DVSS_B.t335 DVSS_B.t89 92636.0728808115
Riso14844 DVSS_B.t335 DVSS_B.t90 901.261525658017
Riso14845 DVSS_B.t335 DVSS_B.t94 748.238993762208
Riso14846 DVSS_B.t335 DVSS_B.t96 952.761622049252
Riso14847 DVSS_B.t335 VSS_A 14.5686809546125
Riso14848 DVSS_B.t335 VSS_B 2.87482308604055
Riso14849 DVSS_B.t337 DVSS_B.t339 0.404704109573531
Riso14850 DVSS_B.t337 DVSS_B.t341 9.56143099132741
Riso14851 DVSS_B.t337 DVSS_B.t343 1.28383729352707
Riso14852 DVSS_B.t337 DVSS_B.t345 13466.1325208159
Riso14853 DVSS_B.t337 DVSS_B.t346 49.2867340338235
Riso14854 DVSS_B.t337 DVSS_B.t348 307.999082014781
Riso14855 DVSS_B.t337 DVSS_B.t35 473.759859080652
Riso14856 DVSS_B.t337 DVSS_B.t350 73.8816687694812
Riso14857 DVSS_B.t337 DVSS_B.t352 65.2958897755434
Riso14858 DVSS_B.t337 DVSS_B.t355 43276.4979317137
Riso14859 DVSS_B.t337 DVSS_B.t356 66.415879222611
Riso14860 DVSS_B.t337 DVSS_B.t358 905.920169904085
Riso14861 DVSS_B.t337 DVSS_B.t36 9093.45966129629
Riso14862 DVSS_B.t337 DVSS_B.t360 676.063261683276
Riso14863 DVSS_B.t337 DVSS_B.t364 963.840339514965
Riso14864 DVSS_B.t337 DVSS_B.t366 939.151887887846
Riso14865 DVSS_B.t337 DVSS_B.t37 141.016603597504
Riso14866 DVSS_B.t337 DVSS_B.t509 939.151887887846
Riso14867 DVSS_B.t337 DVSS_B.t515 274.469351847554
Riso14868 DVSS_B.t337 DVSS_B.t525 121.602975310731
Riso14869 DVSS_B.t337 DVSS_B.t529 517.490240229678
Riso14870 DVSS_B.t337 DVSS_B.t531 274.469351847554
Riso14871 DVSS_B.t337 DVSS_B.t59 17437.0801305571
Riso14872 DVSS_B.t337 DVSS_B.t60 333.511707239
Riso14873 DVSS_B.t337 DVSS_B.t66 255.44192530103
Riso14874 DVSS_B.t337 DVSS_B.t68 125.388600114306
Riso14875 DVSS_B.t337 DVSS_B.t70 704.389757151159
Riso14876 DVSS_B.t337 DVSS_B.t72 936.628432101152
Riso14877 DVSS_B.t337 DVSS_B.t74 143.639929184872
Riso14878 DVSS_B.t337 DVSS_B.t76 93.0301161431313
Riso14879 DVSS_B.t337 DVSS_B.t80 103.463138385398
Riso14880 DVSS_B.t337 DVSS_B.t82 147.093615238496
Riso14881 DVSS_B.t337 DVSS_B.t84 121.602975310731
Riso14882 DVSS_B.t337 DVSS_B.t89 84531.6520302207
Riso14883 DVSS_B.t337 DVSS_B.t90 818.872200183999
Riso14884 DVSS_B.t337 DVSS_B.t94 676.063261683276
Riso14885 DVSS_B.t337 DVSS_B.t96 866.020260406811
Riso14886 DVSS_B.t337 VSS_A 16.4754008895177
Riso14887 DVSS_B.t337 VSS_B 4.00029605794523
Riso14888 DVSS_B.t339 DVSS_B.t341 0.413238703655695
Riso14889 DVSS_B.t339 DVSS_B.t343 9.15742497936094
Riso14890 DVSS_B.t339 DVSS_B.t345 31688.1397313803
Riso14891 DVSS_B.t339 DVSS_B.t346 117.642481015383
Riso14892 DVSS_B.t339 DVSS_B.t348 680.068236140363
Riso14893 DVSS_B.t339 DVSS_B.t35 1034.43457278892
Riso14894 DVSS_B.t339 DVSS_B.t350 156.226900884813
Riso14895 DVSS_B.t339 DVSS_B.t352 137.161571567287
Riso14896 DVSS_B.t339 DVSS_B.t355 99628.3544724111
Riso14897 DVSS_B.t339 DVSS_B.t356 142.808005409617
Riso14898 DVSS_B.t339 DVSS_B.t358 1973.61236208347
Riso14899 DVSS_B.t339 DVSS_B.t36 19012.1841774176
Riso14900 DVSS_B.t339 DVSS_B.t360 1478.74285572519
Riso14901 DVSS_B.t339 DVSS_B.t364 2094.75883260541
Riso14902 DVSS_B.t339 DVSS_B.t366 2036.38257020315
Riso14903 DVSS_B.t339 DVSS_B.t37 294.9253215709
Riso14904 DVSS_B.t339 DVSS_B.t509 2036.38257020315
Riso14905 DVSS_B.t339 DVSS_B.t515 607.579574607454
Riso14906 DVSS_B.t339 DVSS_B.t525 247.961529416598
Riso14907 DVSS_B.t339 DVSS_B.t529 1130.9762013601
Riso14908 DVSS_B.t339 DVSS_B.t531 607.579574607454
Riso14909 DVSS_B.t339 DVSS_B.t59 36338.149174577
Riso14910 DVSS_B.t339 DVSS_B.t60 729.519583979635
Riso14911 DVSS_B.t339 DVSS_B.t66 565.579555330821
Riso14912 DVSS_B.t339 DVSS_B.t68 272.553678690286
Riso14913 DVSS_B.t339 DVSS_B.t70 1539.80077763858
Riso14914 DVSS_B.t339 DVSS_B.t72 2039.2389962905
Riso14915 DVSS_B.t339 DVSS_B.t74 285.333576685189
Riso14916 DVSS_B.t339 DVSS_B.t76 199.156659968529
Riso14917 DVSS_B.t339 DVSS_B.t80 222.730563767566
Riso14918 DVSS_B.t339 DVSS_B.t82 322.067302138741
Riso14919 DVSS_B.t339 DVSS_B.t84 247.961529416598
Riso14920 DVSS_B.t339 DVSS_B.t89 183783.702460563
Riso14921 DVSS_B.t339 DVSS_B.t90 1785.19581796598
Riso14922 DVSS_B.t339 DVSS_B.t94 1478.74285572519
Riso14923 DVSS_B.t339 DVSS_B.t96 1887.50974676565
Riso14924 DVSS_B.t339 VSS_A 33.3954080084334
Riso14925 DVSS_B.t339 VSS_B 6.3186464104316
Riso14926 DVSS_B.t341 DVSS_B.t343 0.405935069298579
Riso14927 DVSS_B.t341 DVSS_B.t345 35291.2450767224
Riso14928 DVSS_B.t341 DVSS_B.t346 132.134203118136
Riso14929 DVSS_B.t341 DVSS_B.t348 649.478458257071
Riso14930 DVSS_B.t341 DVSS_B.t35 982.147291630329
Riso14931 DVSS_B.t341 DVSS_B.t350 148.606010602241
Riso14932 DVSS_B.t341 DVSS_B.t352 130.43700253692
Riso14933 DVSS_B.t341 DVSS_B.t355 109575.863685406
Riso14934 DVSS_B.t341 DVSS_B.t356 151.514020636334
Riso14935 DVSS_B.t341 DVSS_B.t358 1878.86505176903
Riso14936 DVSS_B.t341 DVSS_B.t36 15437.1166985975
Riso14937 DVSS_B.t341 DVSS_B.t360 1408.35257197319
Riso14938 DVSS_B.t341 DVSS_B.t364 1992.31558411108
Riso14939 DVSS_B.t341 DVSS_B.t366 1934.09818803435
Riso14940 DVSS_B.t341 DVSS_B.t37 239.417655627765
Riso14941 DVSS_B.t341 DVSS_B.t509 1934.09818803435
Riso14942 DVSS_B.t341 DVSS_B.t515 581.27480509393
Riso14943 DVSS_B.t341 DVSS_B.t525 256.429863148727
Riso14944 DVSS_B.t341 DVSS_B.t529 1074.87622321504
Riso14945 DVSS_B.t341 DVSS_B.t531 581.27480509393
Riso14946 DVSS_B.t341 DVSS_B.t59 33451.8707530649
Riso14947 DVSS_B.t341 DVSS_B.t60 692.591708146091
Riso14948 DVSS_B.t341 DVSS_B.t66 541.256876162163
Riso14949 DVSS_B.t341 DVSS_B.t68 259.937893938231
Riso14950 DVSS_B.t341 DVSS_B.t70 1466.44265777539
Riso14951 DVSS_B.t341 DVSS_B.t72 1941.06037736855
Riso14952 DVSS_B.t341 DVSS_B.t74 291.585852345372
Riso14953 DVSS_B.t341 DVSS_B.t76 189.603377089522
Riso14954 DVSS_B.t341 DVSS_B.t80 212.163855770821
Riso14955 DVSS_B.t341 DVSS_B.t82 307.494106521785
Riso14956 DVSS_B.t341 DVSS_B.t84 256.429863148727
Riso14957 DVSS_B.t341 DVSS_B.t89 174456.807755679
Riso14958 DVSS_B.t341 DVSS_B.t90 1699.15905109992
Riso14959 DVSS_B.t341 DVSS_B.t94 1408.35257197319
Riso14960 DVSS_B.t341 DVSS_B.t96 1796.85673821514
Riso14961 DVSS_B.t341 VSS_A 37.3095716359244
Riso14962 DVSS_B.t341 VSS_B 5.22135724266397
Riso14963 DVSS_B.t343 DVSS_B.t345 13261.6021524575
Riso14964 DVSS_B.t343 DVSS_B.t346 48.9605399021423
Riso14965 DVSS_B.t343 DVSS_B.t348 272.220887797599
Riso14966 DVSS_B.t343 DVSS_B.t35 420.424850930104
Riso14967 DVSS_B.t343 DVSS_B.t350 63.0969121861213
Riso14968 DVSS_B.t343 DVSS_B.t352 55.6238156125087
Riso14969 DVSS_B.t343 DVSS_B.t355 42055.4279771252
Riso14970 DVSS_B.t343 DVSS_B.t356 61.8925648090733
Riso14971 DVSS_B.t343 DVSS_B.t358 808.949169307759
Riso14972 DVSS_B.t343 DVSS_B.t36 6806.83616725573
Riso14973 DVSS_B.t343 DVSS_B.t360 602.289893228353
Riso14974 DVSS_B.t343 DVSS_B.t364 860.911676491454
Riso14975 DVSS_B.t343 DVSS_B.t366 838.508353895911
Riso14976 DVSS_B.t343 DVSS_B.t37 105.520772747074
Riso14977 DVSS_B.t343 DVSS_B.t509 838.508353895911
Riso14978 DVSS_B.t343 DVSS_B.t515 242.129589368991
Riso14979 DVSS_B.t343 DVSS_B.t525 109.600365255087
Riso14980 DVSS_B.t343 DVSS_B.t529 459.672806371962
Riso14981 DVSS_B.t343 DVSS_B.t531 242.129589368991
Riso14982 DVSS_B.t343 DVSS_B.t59 15273.2745037165
Riso14983 DVSS_B.t343 DVSS_B.t60 295.026897322454
Riso14984 DVSS_B.t343 DVSS_B.t66 225.059811807008
Riso14985 DVSS_B.t343 DVSS_B.t68 108.509111959696
Riso14986 DVSS_B.t343 DVSS_B.t70 627.784245273726
Riso14987 DVSS_B.t343 DVSS_B.t72 836.551855464142
Riso14988 DVSS_B.t343 DVSS_B.t74 127.317598752218
Riso14989 DVSS_B.t343 DVSS_B.t76 79.8672011417352
Riso14990 DVSS_B.t343 DVSS_B.t80 89.0612903561792
Riso14991 DVSS_B.t343 DVSS_B.t82 127.937364671767
Riso14992 DVSS_B.t343 DVSS_B.t84 109.600365255087
Riso14993 DVSS_B.t343 DVSS_B.t89 75280.3343987356
Riso14994 DVSS_B.t343 DVSS_B.t90 730.668823794262
Riso14995 DVSS_B.t343 DVSS_B.t94 602.289893228353
Riso14996 DVSS_B.t343 DVSS_B.t96 773.066374963921
Riso14997 DVSS_B.t343 VSS_A 19.6295034780857
Riso14998 DVSS_B.t343 VSS_B 3.34918294983427
Riso14999 DVSS_B.t345 DVSS_B.t346 2341.52222583995
Riso15000 DVSS_B.t345 DVSS_B.t348 128216.634350057
Riso15001 DVSS_B.t345 DVSS_B.t35 205786.529632381
Riso15002 DVSS_B.t345 DVSS_B.t350 26850.1433130199
Riso15003 DVSS_B.t345 DVSS_B.t352 23409.7491879177
Riso15004 DVSS_B.t345 DVSS_B.t355 868798.769874104
Riso15005 DVSS_B.t345 DVSS_B.t356 3175.87707627865
Riso15006 DVSS_B.t345 DVSS_B.t358 392929.446531404
Riso15007 DVSS_B.t345 DVSS_B.t36 9828767.15979044
Riso15008 DVSS_B.t345 DVSS_B.t360 291472.40407788
Riso15009 DVSS_B.t345 DVSS_B.t364 420126.322950284
Riso15010 DVSS_B.t345 DVSS_B.t366 411880.818360669
Riso15011 DVSS_B.t345 DVSS_B.t37 156246.281601183
Riso15012 DVSS_B.t345 DVSS_B.t509 411880.818360669
Riso15013 DVSS_B.t345 DVSS_B.t515 112493.149570819
Riso15014 DVSS_B.t345 DVSS_B.t525 9658.48059943452
Riso15015 DVSS_B.t345 DVSS_B.t529 224124.249721254
Riso15016 DVSS_B.t345 DVSS_B.t531 112493.149570819
Riso15017 DVSS_B.t345 DVSS_B.t59 8814186.32824554
Riso15018 DVSS_B.t345 DVSS_B.t60 143681.866893432
Riso15019 DVSS_B.t345 DVSS_B.t66 104062.666200959
Riso15020 DVSS_B.t345 DVSS_B.t68 48211.4273046576
Riso15021 DVSS_B.t345 DVSS_B.t70 303980.415548699
Riso15022 DVSS_B.t345 DVSS_B.t72 406663.166748468
Riso15023 DVSS_B.t345 DVSS_B.t74 17262.977278732
Riso15024 DVSS_B.t345 DVSS_B.t76 34660.4568005506
Riso15025 DVSS_B.t345 DVSS_B.t80 38983.5604617086
Riso15026 DVSS_B.t345 DVSS_B.t82 57568.1211613182
Riso15027 DVSS_B.t345 DVSS_B.t84 9658.48059943452
Riso15028 DVSS_B.t345 DVSS_B.t89 37027977.7781756
Riso15029 DVSS_B.t345 DVSS_B.t90 355096.620855778
Riso15030 DVSS_B.t345 DVSS_B.t94 291472.40407788
Riso15031 DVSS_B.t345 DVSS_B.t96 375474.207016845
Riso15032 DVSS_B.t345 VSS_A 55171.3484920966
Riso15033 DVSS_B.t345 VSS_B 13155.8688372743
Riso15034 DVSS_B.t346 DVSS_B.t348 467.542035500499
Riso15035 DVSS_B.t346 DVSS_B.t35 744.788343077756
Riso15036 DVSS_B.t346 DVSS_B.t350 104.666759906442
Riso15037 DVSS_B.t346 DVSS_B.t352 91.8482126075223
Riso15038 DVSS_B.t346 DVSS_B.t355 6135.82074944713
Riso15039 DVSS_B.t346 DVSS_B.t356 13.8859163236056
Riso15040 DVSS_B.t346 DVSS_B.t358 1417.39723654349
Riso15041 DVSS_B.t346 DVSS_B.t36 38681.1162785308
Riso15042 DVSS_B.t346 DVSS_B.t360 1052.84524137609
Riso15043 DVSS_B.t346 DVSS_B.t364 1515.07031830769
Riso15044 DVSS_B.t346 DVSS_B.t366 1485.24531123434
Riso15045 DVSS_B.t346 DVSS_B.t37 609.912201082061
Riso15046 DVSS_B.t346 DVSS_B.t509 1485.24531123434
Riso15047 DVSS_B.t346 DVSS_B.t515 411.693798789884
Riso15048 DVSS_B.t346 DVSS_B.t525 41.9111529269143
Riso15049 DVSS_B.t346 DVSS_B.t529 810.781444524079
Riso15050 DVSS_B.t346 DVSS_B.t531 411.693798789884
Riso15051 DVSS_B.t346 DVSS_B.t59 31869.1975086765
Riso15052 DVSS_B.t346 DVSS_B.t60 521.778231201172
Riso15053 DVSS_B.t346 DVSS_B.t66 381.633552762014
Riso15054 DVSS_B.t346 DVSS_B.t68 182.430381072419
Riso15055 DVSS_B.t346 DVSS_B.t70 1097.72843183081
Riso15056 DVSS_B.t346 DVSS_B.t72 1466.76078112146
Riso15057 DVSS_B.t346 DVSS_B.t74 74.1874982998565
Riso15058 DVSS_B.t346 DVSS_B.t76 133.423296634586
Riso15059 DVSS_B.t346 DVSS_B.t80 149.167494396697
Riso15060 DVSS_B.t346 DVSS_B.t82 215.722953344064
Riso15061 DVSS_B.t346 DVSS_B.t84 41.9111529269143
Riso15062 DVSS_B.t346 DVSS_B.t89 133658.562892934
Riso15063 DVSS_B.t346 DVSS_B.t90 1281.3217844149
Riso15064 DVSS_B.t346 DVSS_B.t94 1052.84524137609
Riso15065 DVSS_B.t346 DVSS_B.t96 1354.62750122548
Riso15066 DVSS_B.t346 VSS_A 201.549626536883
Riso15067 DVSS_B.t346 VSS_B 49.2255419192282
Riso15068 DVSS_B.t348 DVSS_B.t35 116.441358192348
Riso15069 DVSS_B.t348 DVSS_B.t350 295.826130987216
Riso15070 DVSS_B.t348 DVSS_B.t352 309.421207980297
Riso15071 DVSS_B.t348 DVSS_B.t355 414426.676197562
Riso15072 DVSS_B.t348 DVSS_B.t356 648.706036203282
Riso15073 DVSS_B.t348 DVSS_B.t358 370.904646089043
Riso15074 DVSS_B.t348 DVSS_B.t36 65676.8406030758
Riso15075 DVSS_B.t348 DVSS_B.t360 213.108255668795
Riso15076 DVSS_B.t348 DVSS_B.t364 427.631561340154
Riso15077 DVSS_B.t348 DVSS_B.t366 436.44000586396
Riso15078 DVSS_B.t348 DVSS_B.t37 1019.39484448801
Riso15079 DVSS_B.t348 DVSS_B.t509 436.44000586396
Riso15080 DVSS_B.t348 DVSS_B.t515 48.2052231232574
Riso15081 DVSS_B.t348 DVSS_B.t525 1207.51937440318
Riso15082 DVSS_B.t348 DVSS_B.t529 133.712532345989
Riso15083 DVSS_B.t348 DVSS_B.t531 48.2052231232574
Riso15084 DVSS_B.t348 DVSS_B.t59 11589.2379347927
Riso15085 DVSS_B.t348 DVSS_B.t60 55.3336109699856
Riso15086 DVSS_B.t348 DVSS_B.t66 56.5755788823354
Riso15087 DVSS_B.t348 DVSS_B.t68 188.846313871172
Riso15088 DVSS_B.t348 DVSS_B.t70 232.937979675356
Riso15089 DVSS_B.t348 DVSS_B.t72 394.276591577843
Riso15090 DVSS_B.t348 DVSS_B.t74 1438.63959056653
Riso15091 DVSS_B.t348 DVSS_B.t76 257.134515417272
Riso15092 DVSS_B.t348 DVSS_B.t80 234.664817520121
Riso15093 DVSS_B.t348 DVSS_B.t82 146.431348427716
Riso15094 DVSS_B.t348 DVSS_B.t84 1207.51937440318
Riso15095 DVSS_B.t348 DVSS_B.t89 32376.6901515752
Riso15096 DVSS_B.t348 DVSS_B.t90 316.659018362866
Riso15097 DVSS_B.t348 DVSS_B.t94 213.108255668795
Riso15098 DVSS_B.t348 DVSS_B.t96 344.651394398038
Riso15099 DVSS_B.t348 VSS_A 1221.86032302526
Riso15100 DVSS_B.t348 VSS_B 179.61359755908
Riso15101 DVSS_B.t349 DVSS_B.t351 66.3487
Riso15102 DVSS_B.t35 DVSS_B.t350 565.520738886817
Riso15103 DVSS_B.t35 DVSS_B.t352 575.256480447287
Riso15104 DVSS_B.t35 DVSS_B.t355 673168.83130837
Riso15105 DVSS_B.t35 DVSS_B.t356 1098.13624996016
Riso15106 DVSS_B.t35 DVSS_B.t358 165.05687821457
Riso15107 DVSS_B.t35 DVSS_B.t36 105610.277788843
Riso15108 DVSS_B.t35 DVSS_B.t360 74.4560423420983
Riso15109 DVSS_B.t35 DVSS_B.t364 207.055745157195
Riso15110 DVSS_B.t35 DVSS_B.t366 221.603620993408
Riso15111 DVSS_B.t35 DVSS_B.t37 1641.69978473303
Riso15112 DVSS_B.t35 DVSS_B.t509 221.603620993408
Riso15113 DVSS_B.t35 DVSS_B.t515 152.499054947194
Riso15114 DVSS_B.t35 DVSS_B.t525 2120.58256833233
Riso15115 DVSS_B.t35 DVSS_B.t529 40.2286339578654
Riso15116 DVSS_B.t35 DVSS_B.t531 152.499054947194
Riso15117 DVSS_B.t35 DVSS_B.t59 10201.9878497633
Riso15118 DVSS_B.t35 DVSS_B.t60 73.9548992981842
Riso15119 DVSS_B.t35 DVSS_B.t66 172.415494815057
Riso15120 DVSS_B.t35 DVSS_B.t68 420.422602881445
Riso15121 DVSS_B.t35 DVSS_B.t70 84.6433276372939
Riso15122 DVSS_B.t35 DVSS_B.t72 180.675893217245
Riso15123 DVSS_B.t35 DVSS_B.t74 2577.19111973622
Riso15124 DVSS_B.t35 DVSS_B.t76 521.655961169071
Riso15125 DVSS_B.t35 DVSS_B.t80 490.932358035521
Riso15126 DVSS_B.t35 DVSS_B.t82 346.8996734152
Riso15127 DVSS_B.t35 DVSS_B.t84 2120.58256833233
Riso15128 DVSS_B.t35 DVSS_B.t89 13296.5146737282
Riso15129 DVSS_B.t35 DVSS_B.t90 132.676898823758
Riso15130 DVSS_B.t35 DVSS_B.t94 74.4560423420983
Riso15131 DVSS_B.t35 DVSS_B.t96 148.846166999463
Riso15132 DVSS_B.t35 VSS_A 1830.44187256979
Riso15133 DVSS_B.t35 VSS_B 247.129388396584
Riso15134 DVSS_B.t350 DVSS_B.t352 34.2734680544342
Riso15135 DVSS_B.t350 DVSS_B.t355 78747.452776825
Riso15136 DVSS_B.t350 DVSS_B.t356 94.0205516073085
Riso15137 DVSS_B.t350 DVSS_B.t358 1198.30280881897
Riso15138 DVSS_B.t350 DVSS_B.t36 14989.6634295741
Riso15139 DVSS_B.t350 DVSS_B.t360 843.587769387361
Riso15140 DVSS_B.t350 DVSS_B.t364 1301.24581323202
Riso15141 DVSS_B.t350 DVSS_B.t366 1284.48928967806
Riso15142 DVSS_B.t350 DVSS_B.t37 232.204689527914
Riso15143 DVSS_B.t350 DVSS_B.t509 1284.48928967806
Riso15144 DVSS_B.t350 DVSS_B.t515 242.74353177782
Riso15145 DVSS_B.t350 DVSS_B.t525 145.485618953261
Riso15146 DVSS_B.t350 DVSS_B.t529 622.553521818353
Riso15147 DVSS_B.t350 DVSS_B.t531 242.74353177782
Riso15148 DVSS_B.t350 DVSS_B.t59 27092.183250542
Riso15149 DVSS_B.t350 DVSS_B.t60 364.177203165801
Riso15150 DVSS_B.t350 DVSS_B.t66 216.934107735306
Riso15151 DVSS_B.t350 DVSS_B.t68 69.0208083006028
Riso15152 DVSS_B.t350 DVSS_B.t70 887.9834946928
Riso15153 DVSS_B.t350 DVSS_B.t72 1247.33184652899
Riso15154 DVSS_B.t350 DVSS_B.t74 159.201829390236
Riso15155 DVSS_B.t350 DVSS_B.t76 42.9365947198253
Riso15156 DVSS_B.t350 DVSS_B.t80 50.6344603178186
Riso15157 DVSS_B.t350 DVSS_B.t82 90.8665015225452
Riso15158 DVSS_B.t350 DVSS_B.t84 145.485618953261
Riso15159 DVSS_B.t350 DVSS_B.t89 110523.807786383
Riso15160 DVSS_B.t350 DVSS_B.t90 1069.31055322979
Riso15161 DVSS_B.t350 DVSS_B.t94 843.587769387361
Riso15162 DVSS_B.t350 DVSS_B.t96 1138.02219923121
Riso15163 DVSS_B.t350 VSS_A 309.067001248773
Riso15164 DVSS_B.t350 VSS_B 49.6856131888311
Riso15165 DVSS_B.t352 DVSS_B.t355 68067.497784545
Riso15166 DVSS_B.t352 DVSS_B.t356 79.6770962622026
Riso15167 DVSS_B.t352 DVSS_B.t358 1202.4735978331
Riso15168 DVSS_B.t352 DVSS_B.t36 13356.8418924837
Riso15169 DVSS_B.t352 DVSS_B.t360 853.153149722079
Riso15170 DVSS_B.t352 DVSS_B.t364 1302.09880446329
Riso15171 DVSS_B.t352 DVSS_B.t366 1282.90511942567
Riso15172 DVSS_B.t352 DVSS_B.t37 206.908701947177
Riso15173 DVSS_B.t352 DVSS_B.t509 1282.90511942567
Riso15174 DVSS_B.t352 DVSS_B.t515 256.331672081193
Riso15175 DVSS_B.t352 DVSS_B.t525 121.994744055913
Riso15176 DVSS_B.t352 DVSS_B.t529 632.628943934657
Riso15177 DVSS_B.t352 DVSS_B.t531 256.331672081193
Riso15178 DVSS_B.t352 DVSS_B.t59 26440.0307703077
Riso15179 DVSS_B.t352 DVSS_B.t60 374.8815524328
Riso15180 DVSS_B.t352 DVSS_B.t66 230.110613906647
Riso15181 DVSS_B.t352 DVSS_B.t68 76.2609636557803
Riso15182 DVSS_B.t352 DVSS_B.t70 896.825171554606
Riso15183 DVSS_B.t352 DVSS_B.t72 1250.52965467099
Riso15184 DVSS_B.t352 DVSS_B.t74 132.934950589459
Riso15185 DVSS_B.t352 DVSS_B.t76 48.0639797405734
Riso15186 DVSS_B.t352 DVSS_B.t80 56.4467987154344
Riso15187 DVSS_B.t352 DVSS_B.t82 99.4418048016921
Riso15188 DVSS_B.t352 DVSS_B.t84 121.994744055913
Riso15189 DVSS_B.t352 DVSS_B.t89 111048.527284968
Riso15190 DVSS_B.t352 DVSS_B.t90 1074.85151390555
Riso15191 DVSS_B.t352 DVSS_B.t94 853.153149722079
Riso15192 DVSS_B.t352 DVSS_B.t96 1142.9792332114
Riso15193 DVSS_B.t352 VSS_A 273.696233166198
Riso15194 DVSS_B.t352 VSS_B 43.864266765509
Riso15195 DVSS_B.t355 DVSS_B.t356 8129.13272344525
Riso15196 DVSS_B.t355 DVSS_B.t358 1292235.3169633
Riso15197 DVSS_B.t355 DVSS_B.t36 29249870.3378282
Riso15198 DVSS_B.t355 DVSS_B.t360 956467.762892916
Riso15199 DVSS_B.t355 DVSS_B.t364 1382319.2255096
Riso15200 DVSS_B.t355 DVSS_B.t366 1355325.29554276
Riso15201 DVSS_B.t355 DVSS_B.t37 467153.605348124
Riso15202 DVSS_B.t355 DVSS_B.t509 1355325.29554276
Riso15203 DVSS_B.t355 DVSS_B.t515 361539.66545694
Riso15204 DVSS_B.t355 DVSS_B.t525 24920.4283597517
Riso15205 DVSS_B.t355 DVSS_B.t529 733700.115426526
Riso15206 DVSS_B.t355 DVSS_B.t531 361539.66545694
Riso15207 DVSS_B.t355 DVSS_B.t59 28880797.9865076
Riso15208 DVSS_B.t355 DVSS_B.t60 467472.55361771
Riso15209 DVSS_B.t355 DVSS_B.t66 333360.455969984
Riso15210 DVSS_B.t355 DVSS_B.t68 147368.061774476
Riso15211 DVSS_B.t355 DVSS_B.t70 997950.048260664
Riso15212 DVSS_B.t355 DVSS_B.t72 1337663.79231823
Riso15213 DVSS_B.t355 DVSS_B.t74 45006.257911254
Riso15214 DVSS_B.t355 DVSS_B.t76 103411.918844565
Riso15215 DVSS_B.t355 DVSS_B.t80 117285.871330619
Riso15216 DVSS_B.t355 DVSS_B.t82 178487.583023573
Riso15217 DVSS_B.t355 DVSS_B.t83 356.886
Riso15218 DVSS_B.t355 DVSS_B.t84 24920.4283597517
Riso15219 DVSS_B.t355 DVSS_B.t89 121644081.27574
Riso15220 DVSS_B.t355 DVSS_B.t90 1167228.71388788
Riso15221 DVSS_B.t355 DVSS_B.t94 956467.762892916
Riso15222 DVSS_B.t355 DVSS_B.t96 1234541.34812686
Riso15223 DVSS_B.t355 VSS_A 178127.607654283
Riso15224 DVSS_B.t355 VSS_B 40893.502040985
Riso15225 DVSS_B.t356 DVSS_B.t358 2148.5023138235
Riso15226 DVSS_B.t356 DVSS_B.t36 40844.2191871777
Riso15227 DVSS_B.t356 DVSS_B.t360 1577.76162265606
Riso15228 DVSS_B.t356 DVSS_B.t364 2302.1360830073
Riso15229 DVSS_B.t356 DVSS_B.t366 2258.0213114369
Riso15230 DVSS_B.t356 DVSS_B.t37 641.600097861451
Riso15231 DVSS_B.t356 DVSS_B.t509 2258.0213114369
Riso15232 DVSS_B.t356 DVSS_B.t515 555.334925683684
Riso15233 DVSS_B.t356 DVSS_B.t525 23.2380572356631
Riso15234 DVSS_B.t356 DVSS_B.t529 1200.01731867696
Riso15235 DVSS_B.t356 DVSS_B.t531 555.334925683684
Riso15236 DVSS_B.t356 DVSS_B.t59 47408.0278772762
Riso15237 DVSS_B.t356 DVSS_B.t60 748.299945616457
Riso15238 DVSS_B.t356 DVSS_B.t66 506.670559677789
Riso15239 DVSS_B.t356 DVSS_B.t68 195.108392346295
Riso15240 DVSS_B.t356 DVSS_B.t70 1648.77196709835
Riso15241 DVSS_B.t356 DVSS_B.t72 2225.60414243765
Riso15242 DVSS_B.t356 DVSS_B.t74 42.6804252459829
Riso15243 DVSS_B.t356 DVSS_B.t76 128.642635717905
Riso15244 DVSS_B.t356 DVSS_B.t80 148.981591536301
Riso15245 DVSS_B.t356 DVSS_B.t82 245.758211211648
Riso15246 DVSS_B.t356 DVSS_B.t84 23.2380572356631
Riso15247 DVSS_B.t356 DVSS_B.t89 201476.321947978
Riso15248 DVSS_B.t356 DVSS_B.t90 1937.1746499499
Riso15249 DVSS_B.t356 DVSS_B.t94 1577.76162265606
Riso15250 DVSS_B.t356 DVSS_B.t96 2050.85512421553
Riso15251 DVSS_B.t356 VSS_A 276.967020106507
Riso15252 DVSS_B.t356 VSS_B 56.7491149336883
Riso15253 DVSS_B.t358 DVSS_B.t36 212899.680799305
Riso15254 DVSS_B.t358 DVSS_B.t360 87.6187198252492
Riso15255 DVSS_B.t358 DVSS_B.t364 46.7710700971552
Riso15256 DVSS_B.t358 DVSS_B.t366 56.2021818384737
Riso15257 DVSS_B.t358 DVSS_B.t37 3312.2307745694
Riso15258 DVSS_B.t358 DVSS_B.t509 56.2021818384737
Riso15259 DVSS_B.t358 DVSS_B.t515 452.405428141758
Riso15260 DVSS_B.t358 DVSS_B.t525 4224.04617910023
Riso15261 DVSS_B.t358 DVSS_B.t529 148.080806092254
Riso15262 DVSS_B.t358 DVSS_B.t531 452.405428141758
Riso15263 DVSS_B.t358 DVSS_B.t59 18626.7956565481
Riso15264 DVSS_B.t358 DVSS_B.t60 263.114464325832
Riso15265 DVSS_B.t358 DVSS_B.t66 494.290952997161
Riso15266 DVSS_B.t358 DVSS_B.t68 965.580995493636
Riso15267 DVSS_B.t358 DVSS_B.t70 75.4966833770685
Riso15268 DVSS_B.t358 DVSS_B.t72 36.1320071891723
Riso15269 DVSS_B.t358 DVSS_B.t74 5185.85534553092
Riso15270 DVSS_B.t358 DVSS_B.t76 1139.1324347422
Riso15271 DVSS_B.t358 DVSS_B.t80 1089.5544009286
Riso15272 DVSS_B.t358 DVSS_B.t82 826.319379644692
Riso15273 DVSS_B.t358 DVSS_B.t84 4224.04617910023
Riso15274 DVSS_B.t358 DVSS_B.t89 6262.36927038814
Riso15275 DVSS_B.t358 DVSS_B.t90 41.876057778947
Riso15276 DVSS_B.t358 DVSS_B.t94 87.6187198252492
Riso15277 DVSS_B.t358 DVSS_B.t96 36.3018354734837
Riso15278 DVSS_B.t358 VSS_A 3462.60763700354
Riso15279 DVSS_B.t358 VSS_B 457.042252325603
Riso15280 DVSS_B.t359 DVSS_B.t93 66.3487
Riso15281 DVSS_B.t36 DVSS_B.t360 154599.01011594
Riso15282 DVSS_B.t36 DVSS_B.t364 228288.655845545
Riso15283 DVSS_B.t36 DVSS_B.t366 222853.010857288
Riso15284 DVSS_B.t36 DVSS_B.t37 1365.86422144868
Riso15285 DVSS_B.t36 DVSS_B.t509 222853.010857288
Riso15286 DVSS_B.t36 DVSS_B.t515 57723.7471098692
Riso15287 DVSS_B.t36 DVSS_B.t525 68235.1643812044
Riso15288 DVSS_B.t36 DVSS_B.t529 115951.119059176
Riso15289 DVSS_B.t36 DVSS_B.t531 57723.7471098692
Riso15290 DVSS_B.t36 DVSS_B.t59 3873843.3784029
Riso15291 DVSS_B.t36 DVSS_B.t60 72550.1705777198
Riso15292 DVSS_B.t36 DVSS_B.t66 53366.5101358037
Riso15293 DVSS_B.t36 DVSS_B.t68 25078.31189469
Riso15294 DVSS_B.t36 DVSS_B.t70 161791.825895425
Riso15295 DVSS_B.t36 DVSS_B.t72 220823.72174262
Riso15296 DVSS_B.t36 DVSS_B.t74 77135.8650246703
Riso15297 DVSS_B.t36 DVSS_B.t76 18668.2422000092
Riso15298 DVSS_B.t36 DVSS_B.t80 20703.4502103063
Riso15299 DVSS_B.t36 DVSS_B.t82 29587.8963179723
Riso15300 DVSS_B.t36 DVSS_B.t84 68235.1643812044
Riso15301 DVSS_B.t36 DVSS_B.t89 19522155.4310257
Riso15302 DVSS_B.t36 DVSS_B.t90 190967.49721738
Riso15303 DVSS_B.t36 DVSS_B.t94 154599.01011594
Riso15304 DVSS_B.t36 DVSS_B.t96 202776.035216319
Riso15305 DVSS_B.t36 VSS_A 38509.4596079852
Riso15306 DVSS_B.t36 VSS_B 4638.86025336781
Riso15307 DVSS_B.t360 DVSS_B.t364 118.905914238777
Riso15308 DVSS_B.t360 DVSS_B.t366 133.513514518444
Riso15309 DVSS_B.t360 DVSS_B.t37 2403.7564237484
Riso15310 DVSS_B.t360 DVSS_B.t509 133.513514518444
Riso15311 DVSS_B.t360 DVSS_B.t515 269.205239043136
Riso15312 DVSS_B.t360 DVSS_B.t525 3078.71986459315
Riso15313 DVSS_B.t360 DVSS_B.t529 64.2054738006034
Riso15314 DVSS_B.t360 DVSS_B.t531 269.205239043136
Riso15315 DVSS_B.t360 DVSS_B.t59 14791.1899397154
Riso15316 DVSS_B.t360 DVSS_B.t60 143.016453240048
Riso15317 DVSS_B.t360 DVSS_B.t66 299.105750131553
Riso15318 DVSS_B.t360 DVSS_B.t68 651.385016963825
Riso15319 DVSS_B.t360 DVSS_B.t70 38.5500258386075
Riso15320 DVSS_B.t360 DVSS_B.t72 98.470055889031
Riso15321 DVSS_B.t360 DVSS_B.t74 3763.60495989847
Riso15322 DVSS_B.t360 DVSS_B.t76 788.742456687896
Riso15323 DVSS_B.t360 DVSS_B.t80 747.968929096234
Riso15324 DVSS_B.t360 DVSS_B.t82 547.593204201229
Riso15325 DVSS_B.t360 DVSS_B.t84 3078.71986459315
Riso15326 DVSS_B.t360 DVSS_B.t89 6584.39205989308
Riso15327 DVSS_B.t360 DVSS_B.t90 66.9277539587393
Riso15328 DVSS_B.t360 DVSS_B.t94 0.0669593939077535
Riso15329 DVSS_B.t360 DVSS_B.t96 76.9941948892923
Riso15330 DVSS_B.t360 VSS_A 2605.63634584226
Riso15331 DVSS_B.t360 VSS_B 352.012550753547
Riso15332 DVSS_B.t364 DVSS_B.t366 36.05738462325
Riso15333 DVSS_B.t364 DVSS_B.t37 3552.56647874686
Riso15334 DVSS_B.t364 DVSS_B.t509 36.05738462325
Riso15335 DVSS_B.t364 DVSS_B.t515 516.652685671715
Riso15336 DVSS_B.t364 DVSS_B.t525 4533.40638416502
Riso15337 DVSS_B.t364 DVSS_B.t529 188.859226814104
Riso15338 DVSS_B.t364 DVSS_B.t531 516.652685671715
Riso15339 DVSS_B.t364 DVSS_B.t59 19228.8311613681
Riso15340 DVSS_B.t364 DVSS_B.t60 307.916852757511
Riso15341 DVSS_B.t364 DVSS_B.t66 561.868239519592
Riso15342 DVSS_B.t364 DVSS_B.t68 1063.49516890581
Riso15343 DVSS_B.t364 DVSS_B.t70 103.960969003975
Riso15344 DVSS_B.t364 DVSS_B.t72 40.2636662390059
Riso15345 DVSS_B.t364 DVSS_B.t74 5570.80773509555
Riso15346 DVSS_B.t364 DVSS_B.t76 1244.15260662965
Riso15347 DVSS_B.t364 DVSS_B.t80 1193.41116178396
Riso15348 DVSS_B.t364 DVSS_B.t82 914.923035428985
Riso15349 DVSS_B.t364 DVSS_B.t84 4533.40638416502
Riso15350 DVSS_B.t364 DVSS_B.t89 8836.02887893756
Riso15351 DVSS_B.t364 DVSS_B.t90 61.1176455433427
Riso15352 DVSS_B.t364 DVSS_B.t94 118.905914238777
Riso15353 DVSS_B.t364 DVSS_B.t96 53.7888658786224
Riso15354 DVSS_B.t364 VSS_A 3670.58080600807
Riso15355 DVSS_B.t364 VSS_B 478.887800679363
Riso15356 DVSS_B.t365 DVSS_B.t508 66.3487
Riso15357 DVSS_B.t366 DVSS_B.t37 3468.61426668308
Riso15358 DVSS_B.t366 DVSS_B.t509 0.0669219458143594
Riso15359 DVSS_B.t366 DVSS_B.t515 524.87995083641
Riso15360 DVSS_B.t366 DVSS_B.t525 4448.12458943697
Riso15361 DVSS_B.t366 DVSS_B.t529 204.167731426459
Riso15362 DVSS_B.t366 DVSS_B.t531 524.87995083641
Riso15363 DVSS_B.t366 DVSS_B.t59 18293.5328957667
Riso15364 DVSS_B.t366 DVSS_B.t60 316.381914288853
Riso15365 DVSS_B.t366 DVSS_B.t66 569.475337688933
Riso15366 DVSS_B.t366 DVSS_B.t68 1059.24728691083
Riso15367 DVSS_B.t366 DVSS_B.t70 117.796760082434
Riso15368 DVSS_B.t366 DVSS_B.t72 48.8758658800868
Riso15369 DVSS_B.t366 DVSS_B.t74 5467.13251207964
Riso15370 DVSS_B.t366 DVSS_B.t76 1232.77234796941
Riso15371 DVSS_B.t366 DVSS_B.t80 1184.63869653332
Riso15372 DVSS_B.t366 DVSS_B.t82 914.027345142295
Riso15373 DVSS_B.t366 DVSS_B.t84 4448.12458943697
Riso15374 DVSS_B.t366 DVSS_B.t89 10158.481858611
Riso15375 DVSS_B.t366 DVSS_B.t90 71.930841701856
Riso15376 DVSS_B.t366 DVSS_B.t94 133.513514518444
Riso15377 DVSS_B.t366 DVSS_B.t96 63.9687559536165
Riso15378 DVSS_B.t366 VSS_A 3566.51757735208
Riso15379 DVSS_B.t366 VSS_B 460.578402274019
Riso15380 DVSS_B.t37 DVSS_B.t509 3468.61426668308
Riso15381 DVSS_B.t37 DVSS_B.t515 895.52864188739
Riso15382 DVSS_B.t37 DVSS_B.t525 1064.91919263715
Riso15383 DVSS_B.t37 DVSS_B.t529 1802.46419310098
Riso15384 DVSS_B.t37 DVSS_B.t531 895.52864188739
Riso15385 DVSS_B.t37 DVSS_B.t59 60408.8262950235
Riso15386 DVSS_B.t37 DVSS_B.t60 1127.19949677682
Riso15387 DVSS_B.t37 DVSS_B.t66 827.77919494209
Riso15388 DVSS_B.t37 DVSS_B.t68 388.576423607267
Riso15389 DVSS_B.t37 DVSS_B.t70 2515.83137630572
Riso15390 DVSS_B.t37 DVSS_B.t72 3435.7886399363
Riso15391 DVSS_B.t37 DVSS_B.t74 1200.34188810837
Riso15392 DVSS_B.t37 DVSS_B.t76 289.204087648065
Riso15393 DVSS_B.t37 DVSS_B.t80 320.747134139474
Riso15394 DVSS_B.t37 DVSS_B.t82 458.545066819516
Riso15395 DVSS_B.t37 DVSS_B.t84 1064.91919263715
Riso15396 DVSS_B.t37 DVSS_B.t89 303700.365180286
Riso15397 DVSS_B.t37 DVSS_B.t90 2970.60638495689
Riso15398 DVSS_B.t37 DVSS_B.t94 2403.7564237484
Riso15399 DVSS_B.t37 DVSS_B.t96 3154.49876083327
Riso15400 DVSS_B.t37 VSS_A 597.669941163351
Riso15401 DVSS_B.t37 VSS_B 72.1237042772921
Riso15402 DVSS_B.t509 DVSS_B.t515 524.87995083641
Riso15403 DVSS_B.t509 DVSS_B.t525 4448.12458943697
Riso15404 DVSS_B.t509 DVSS_B.t529 204.167731426459
Riso15405 DVSS_B.t509 DVSS_B.t531 524.87995083641
Riso15406 DVSS_B.t509 DVSS_B.t59 18293.5328957667
Riso15407 DVSS_B.t509 DVSS_B.t60 316.381914288853
Riso15408 DVSS_B.t509 DVSS_B.t66 569.475337688933
Riso15409 DVSS_B.t509 DVSS_B.t68 1059.24728691083
Riso15410 DVSS_B.t509 DVSS_B.t70 117.796760082434
Riso15411 DVSS_B.t509 DVSS_B.t72 48.8758658800868
Riso15412 DVSS_B.t509 DVSS_B.t74 5467.13251207964
Riso15413 DVSS_B.t509 DVSS_B.t76 1232.77234796941
Riso15414 DVSS_B.t509 DVSS_B.t80 1184.63869653332
Riso15415 DVSS_B.t509 DVSS_B.t82 914.027345142295
Riso15416 DVSS_B.t509 DVSS_B.t84 4448.12458943697
Riso15417 DVSS_B.t509 DVSS_B.t89 10158.481858611
Riso15418 DVSS_B.t509 DVSS_B.t90 71.930841701856
Riso15419 DVSS_B.t509 DVSS_B.t94 133.513514518444
Riso15420 DVSS_B.t509 DVSS_B.t96 63.9687559536165
Riso15421 DVSS_B.t509 VSS_A 3566.51757735208
Riso15422 DVSS_B.t509 VSS_B 460.578402274019
Riso15423 DVSS_B.t514 DVSS_B.t530 66.3487
Riso15424 DVSS_B.t515 DVSS_B.t525 1017.43269805241
Riso15425 DVSS_B.t515 DVSS_B.t529 173.820139206805
Riso15426 DVSS_B.t515 DVSS_B.t531 0.0669642434856333
Riso15427 DVSS_B.t515 DVSS_B.t59 13947.6025917908
Riso15428 DVSS_B.t515 DVSS_B.t60 75.6306133041057
Riso15429 DVSS_B.t515 DVSS_B.t66 40.6074955465765
Riso15430 DVSS_B.t515 DVSS_B.t68 147.433695886958
Riso15431 DVSS_B.t515 DVSS_B.t70 292.351600409876
Riso15432 DVSS_B.t515 DVSS_B.t72 479.234244484414
Riso15433 DVSS_B.t515 DVSS_B.t74 1202.20791521981
Riso15434 DVSS_B.t515 DVSS_B.t76 206.831086302933
Riso15435 DVSS_B.t515 DVSS_B.t80 186.866860664628
Riso15436 DVSS_B.t515 DVSS_B.t82 112.174372491623
Riso15437 DVSS_B.t515 DVSS_B.t84 1017.43269805241
Riso15438 DVSS_B.t515 DVSS_B.t89 39943.5156574438
Riso15439 DVSS_B.t515 DVSS_B.t90 389.265181236999
Riso15440 DVSS_B.t515 DVSS_B.t94 269.205239043136
Riso15441 DVSS_B.t515 DVSS_B.t96 421.974451465561
Riso15442 DVSS_B.t515 VSS_A 1098.90000988066
Riso15443 DVSS_B.t515 VSS_B 166.470708764391
Riso15444 DVSS_B.t524 DVSS_B.t83 356.886
Riso15445 DVSS_B.t525 DVSS_B.t529 2322.96078799772
Riso15446 DVSS_B.t525 DVSS_B.t531 1017.43269805241
Riso15447 DVSS_B.t525 DVSS_B.t59 92075.82662429
Riso15448 DVSS_B.t525 DVSS_B.t60 1420.40222543595
Riso15449 DVSS_B.t525 DVSS_B.t66 920.283831422959
Riso15450 DVSS_B.t525 DVSS_B.t68 320.854905089406
Riso15451 DVSS_B.t525 DVSS_B.t70 3222.0654236969
Riso15452 DVSS_B.t525 DVSS_B.t72 4378.60467983072
Riso15453 DVSS_B.t525 DVSS_B.t74 54.7946959357319
Riso15454 DVSS_B.t525 DVSS_B.t76 203.688251496711
Riso15455 DVSS_B.t525 DVSS_B.t80 238.807221358151
Riso15456 DVSS_B.t525 DVSS_B.t82 414.749328376468
Riso15457 DVSS_B.t525 DVSS_B.t84 0.735839093783104
Riso15458 DVSS_B.t525 DVSS_B.t89 394660.662990591
Riso15459 DVSS_B.t525 DVSS_B.t90 3801.99609325663
Riso15460 DVSS_B.t525 DVSS_B.t94 3078.71986459315
Riso15461 DVSS_B.t525 DVSS_B.t96 4028.8150682937
Riso15462 DVSS_B.t525 VSS_A 512.677642339564
Riso15463 DVSS_B.t525 VSS_B 96.2768659517879
Riso15464 DVSS_B.t529 DVSS_B.t531 173.820139206805
Riso15465 DVSS_B.t529 DVSS_B.t59 11270.3326320032
Riso15466 DVSS_B.t529 DVSS_B.t60 85.8747825455195
Riso15467 DVSS_B.t529 DVSS_B.t66 195.811015301425
Riso15468 DVSS_B.t529 DVSS_B.t68 466.282970277239
Riso15469 DVSS_B.t529 DVSS_B.t70 73.4089355661665
Riso15470 DVSS_B.t529 DVSS_B.t72 162.998624157148
Riso15471 DVSS_B.t529 DVSS_B.t74 2826.97511231578
Riso15472 DVSS_B.t529 DVSS_B.t76 575.716826559036
Riso15473 DVSS_B.t529 DVSS_B.t80 542.621503006612
Riso15474 DVSS_B.t529 DVSS_B.t82 386.259520063712
Riso15475 DVSS_B.t529 DVSS_B.t84 2322.96078799772
Riso15476 DVSS_B.t529 DVSS_B.t89 11758.9011704138
Riso15477 DVSS_B.t529 DVSS_B.t90 117.741717576346
Riso15478 DVSS_B.t529 DVSS_B.t94 64.2054738006034
Riso15479 DVSS_B.t529 DVSS_B.t96 132.803861239618
Riso15480 DVSS_B.t529 VSS_A 1999.57002005633
Riso15481 DVSS_B.t529 VSS_B 270.663399697794
Riso15482 DVSS_B.t530 DVSS_B.t65 66.3487
Riso15483 DVSS_B.t531 DVSS_B.t59 13947.6025917908
Riso15484 DVSS_B.t531 DVSS_B.t60 75.6306133041057
Riso15485 DVSS_B.t531 DVSS_B.t66 40.6074955465765
Riso15486 DVSS_B.t531 DVSS_B.t68 147.433695886958
Riso15487 DVSS_B.t531 DVSS_B.t70 292.351600409876
Riso15488 DVSS_B.t531 DVSS_B.t72 479.234244484414
Riso15489 DVSS_B.t531 DVSS_B.t74 1202.20791521981
Riso15490 DVSS_B.t531 DVSS_B.t76 206.831086302933
Riso15491 DVSS_B.t531 DVSS_B.t80 186.866860664628
Riso15492 DVSS_B.t531 DVSS_B.t82 112.174372491623
Riso15493 DVSS_B.t531 DVSS_B.t84 1017.43269805241
Riso15494 DVSS_B.t531 DVSS_B.t89 39943.5156574438
Riso15495 DVSS_B.t531 DVSS_B.t90 389.265181236999
Riso15496 DVSS_B.t531 DVSS_B.t94 269.205239043136
Riso15497 DVSS_B.t531 DVSS_B.t96 421.974451465561
Riso15498 DVSS_B.t531 VSS_A 1098.90000988066
Riso15499 DVSS_B.t531 VSS_B 166.470708764391
Riso15500 DVSS_B.t59 DVSS_B.t60 8151.72033113199
Riso15501 DVSS_B.t59 DVSS_B.t66 15036.8696187872
Riso15502 DVSS_B.t59 DVSS_B.t68 24685.4605453211
Riso15503 DVSS_B.t59 DVSS_B.t70 15274.2582871938
Riso15504 DVSS_B.t59 DVSS_B.t72 19088.8153689374
Riso15505 DVSS_B.t59 DVSS_B.t74 112261.842450539
Riso15506 DVSS_B.t59 DVSS_B.t76 27192.7006750482
Riso15507 DVSS_B.t59 DVSS_B.t80 26668.9694226827
Riso15508 DVSS_B.t59 DVSS_B.t82 21845.838814795
Riso15509 DVSS_B.t59 DVSS_B.t84 92075.82662429
Riso15510 DVSS_B.t59 DVSS_B.t89 1719133.72711855
Riso15511 DVSS_B.t59 DVSS_B.t90 17055.7207303611
Riso15512 DVSS_B.t59 DVSS_B.t94 14791.1899397154
Riso15513 DVSS_B.t59 DVSS_B.t96 17936.7292764332
Riso15514 DVSS_B.t59 VSS_A 63828.9047686067
Riso15515 DVSS_B.t59 VSS_B 7113.7792213636
Riso15516 DVSS_B.t60 DVSS_B.t66 87.4069242797085
Riso15517 DVSS_B.t60 DVSS_B.t68 252.299690161954
Riso15518 DVSS_B.t60 DVSS_B.t70 157.913156982994
Riso15519 DVSS_B.t60 DVSS_B.t72 281.256204015835
Riso15520 DVSS_B.t60 DVSS_B.t74 1710.02631543506
Riso15521 DVSS_B.t60 DVSS_B.t76 327.163102595158
Riso15522 DVSS_B.t60 DVSS_B.t80 303.545622349064
Riso15523 DVSS_B.t60 DVSS_B.t82 201.774937638429
Riso15524 DVSS_B.t60 DVSS_B.t84 1420.40222543595
Riso15525 DVSS_B.t60 DVSS_B.t89 22530.3477113651
Riso15526 DVSS_B.t60 DVSS_B.t90 221.81785222355
Riso15527 DVSS_B.t60 DVSS_B.t94 143.016453240048
Riso15528 DVSS_B.t60 DVSS_B.t96 243.007752228815
Riso15529 DVSS_B.t60 VSS_A 1299.31854053936
Riso15530 DVSS_B.t60 VSS_B 179.155604952756
Riso15531 DVSS_B.t65 DVSS_B.t99 66.3487
Riso15532 DVSS_B.t66 DVSS_B.t68 128.674992451353
Riso15533 DVSS_B.t66 DVSS_B.t70 323.810839270678
Riso15534 DVSS_B.t66 DVSS_B.t72 522.72276912972
Riso15535 DVSS_B.t66 DVSS_B.t74 1082.63023240449
Riso15536 DVSS_B.t66 DVSS_B.t76 183.099405969178
Riso15537 DVSS_B.t66 DVSS_B.t80 164.634914885224
Riso15538 DVSS_B.t66 DVSS_B.t82 97.0267297455866
Riso15539 DVSS_B.t66 DVSS_B.t84 920.283831422959
Riso15540 DVSS_B.t66 DVSS_B.t89 43869.1655051334
Riso15541 DVSS_B.t66 DVSS_B.t90 426.881819674908
Riso15542 DVSS_B.t66 DVSS_B.t94 299.105750131553
Riso15543 DVSS_B.t66 DVSS_B.t96 461.872991728401
Riso15544 DVSS_B.t66 VSS_A 1026.55852412479
Riso15545 DVSS_B.t66 VSS_B 157.228841033248
Riso15546 DVSS_B.t68 DVSS_B.t70 690.984813867472
Riso15547 DVSS_B.t68 DVSS_B.t72 1009.8470573387
Riso15548 DVSS_B.t68 DVSS_B.t74 360.184502745662
Riso15549 DVSS_B.t68 DVSS_B.t76 53.5821726253219
Riso15550 DVSS_B.t68 DVSS_B.t80 46.2402028310833
Riso15551 DVSS_B.t68 DVSS_B.t82 46.0335200823345
Riso15552 DVSS_B.t68 DVSS_B.t84 320.854905089406
Riso15553 DVSS_B.t68 DVSS_B.t89 88283.6761527032
Riso15554 DVSS_B.t68 DVSS_B.t90 853.747951435537
Riso15555 DVSS_B.t68 DVSS_B.t94 651.385016963825
Riso15556 DVSS_B.t68 DVSS_B.t96 912.750378633478
Riso15557 DVSS_B.t68 VSS_A 518.097108353324
Riso15558 DVSS_B.t68 VSS_B 83.543748019247
Riso15559 DVSS_B.t69 DVSS_B.t93 66.3487
Riso15560 DVSS_B.t70 DVSS_B.t72 85.2576162047381
Riso15561 DVSS_B.t70 DVSS_B.t74 3942.15408437973
Riso15562 DVSS_B.t70 DVSS_B.t76 832.707678112477
Riso15563 DVSS_B.t70 DVSS_B.t80 790.889610098672
Riso15564 DVSS_B.t70 DVSS_B.t82 582.836873695418
Riso15565 DVSS_B.t70 DVSS_B.t84 3222.0654236969
Riso15566 DVSS_B.t70 DVSS_B.t89 5600.62187897058
Riso15567 DVSS_B.t70 DVSS_B.t90 57.1423886815744
Riso15568 DVSS_B.t70 DVSS_B.t94 38.5500258386075
Riso15569 DVSS_B.t70 DVSS_B.t96 66.0321050096979
Riso15570 DVSS_B.t70 VSS_A 2711.14957372619
Riso15571 DVSS_B.t70 VSS_B 364.90704080938
Riso15572 DVSS_B.t72 DVSS_B.t74 5377.69868342895
Riso15573 DVSS_B.t72 DVSS_B.t76 1187.98941370998
Riso15574 DVSS_B.t72 DVSS_B.t80 1137.36767733672
Riso15575 DVSS_B.t72 DVSS_B.t82 865.784496571427
Riso15576 DVSS_B.t72 DVSS_B.t84 4378.60467983072
Riso15577 DVSS_B.t72 DVSS_B.t89 7129.89260432608
Riso15578 DVSS_B.t72 DVSS_B.t90 48.1911828276996
Riso15579 DVSS_B.t72 DVSS_B.t94 98.470055889031
Riso15580 DVSS_B.t72 DVSS_B.t96 41.9770570005495
Riso15581 DVSS_B.t72 VSS_A 3576.05625954142
Riso15582 DVSS_B.t72 VSS_B 470.496062172397
Riso15583 DVSS_B.t74 DVSS_B.t76 224.993310592486
Riso15584 DVSS_B.t74 DVSS_B.t80 265.144936279763
Riso15585 DVSS_B.t74 DVSS_B.t82 470.998467091223
Riso15586 DVSS_B.t74 DVSS_B.t84 54.7946959357319
Riso15587 DVSS_B.t74 DVSS_B.t89 483510.725587785
Riso15588 DVSS_B.t74 DVSS_B.t90 4663.09862657295
Riso15589 DVSS_B.t74 DVSS_B.t94 3763.60495989847
Riso15590 DVSS_B.t74 DVSS_B.t96 4943.88692178841
Riso15591 DVSS_B.t74 VSS_A 609.017047215001
Riso15592 DVSS_B.t74 VSS_B 109.596991783938
Riso15593 DVSS_B.t76 DVSS_B.t80 38.6229456499396
Riso15594 DVSS_B.t76 DVSS_B.t82 71.9013531347615
Riso15595 DVSS_B.t76 DVSS_B.t84 203.688251496711
Riso15596 DVSS_B.t76 DVSS_B.t89 104748.098993351
Riso15597 DVSS_B.t76 DVSS_B.t90 1012.86316632585
Riso15598 DVSS_B.t76 DVSS_B.t94 788.742456687896
Riso15599 DVSS_B.t76 DVSS_B.t96 1079.84577104399
Riso15600 DVSS_B.t76 VSS_A 387.463926754735
Riso15601 DVSS_B.t76 VSS_B 62.5553504710182
Riso15602 DVSS_B.t80 DVSS_B.t82 62.6162584880695
Riso15603 DVSS_B.t80 DVSS_B.t84 238.807221358151
Riso15604 DVSS_B.t80 DVSS_B.t89 100013.43206676
Riso15605 DVSS_B.t80 DVSS_B.t90 966.987108626961
Riso15606 DVSS_B.t80 DVSS_B.t94 747.968929096234
Riso15607 DVSS_B.t80 DVSS_B.t96 1031.88028186083
Riso15608 DVSS_B.t80 VSS_A 429.865108958678
Riso15609 DVSS_B.t80 VSS_B 69.4576256166422
Riso15610 DVSS_B.t82 DVSS_B.t84 414.749328376468
Riso15611 DVSS_B.t82 DVSS_B.t89 75210.3716403229
Riso15612 DVSS_B.t82 DVSS_B.t90 727.840655660984
Riso15613 DVSS_B.t82 DVSS_B.t94 547.593204201229
Riso15614 DVSS_B.t82 DVSS_B.t96 779.639221331199
Riso15615 DVSS_B.t82 VSS_A 603.845090934047
Riso15616 DVSS_B.t82 VSS_B 96.5726291751972
Riso15617 DVSS_B.t84 DVSS_B.t89 394660.662990591
Riso15618 DVSS_B.t84 DVSS_B.t90 3801.99609325663
Riso15619 DVSS_B.t84 DVSS_B.t94 3078.71986459315
Riso15620 DVSS_B.t84 DVSS_B.t96 4028.8150682937
Riso15621 DVSS_B.t84 VSS_A 512.677642339564
Riso15622 DVSS_B.t84 VSS_B 96.2768659517879
Riso15623 DVSS_B.t89 DVSS_B.t90 4666.6047454208
Riso15624 DVSS_B.t89 DVSS_B.t94 6584.39205989308
Riso15625 DVSS_B.t89 DVSS_B.t96 5433.92135345516
Riso15626 DVSS_B.t89 VSS_A 323055.658796378
Riso15627 DVSS_B.t89 VSS_B 42370.7212103935
Riso15628 DVSS_B.t90 DVSS_B.t94 66.9277539587393
Riso15629 DVSS_B.t90 DVSS_B.t96 35.9750167198669
Riso15630 DVSS_B.t90 VSS_A 3135.36726769897
Riso15631 DVSS_B.t90 VSS_B 415.614138800484
Riso15632 DVSS_B.t94 DVSS_B.t96 76.9941948892923
Riso15633 DVSS_B.t94 VSS_A 2605.63634584226
Riso15634 DVSS_B.t94 VSS_B 352.012550753547
Riso15635 DVSS_B.t96 VSS_A 3313.25269949298
Riso15636 DVSS_B.t96 VSS_B 438.421699100751
Riso15637 VSS_A VSS_B 11.351662973741
Riso15638 a_58313_15032.n376 a_58313_15032.t0 238243.320337613
Riso15639 a_58313_15032.n376 a_58313_15032.t1 7813.82838404583
Riso15640 a_58313_15032.n376 a_58313_15032.t10 238243.320337613
Riso15641 a_58313_15032.n376 a_58313_15032.t100 13204.9571280787
Riso15642 a_58313_15032.n376 a_58313_15032.t101 15798.694941774
Riso15643 a_58313_15032.n376 a_58313_15032.t102 18801.9582386251
Riso15644 a_58313_15032.n376 a_58313_15032.t103 22208.9314015515
Riso15645 a_58313_15032.n376 a_58313_15032.t104 25960.5710830138
Riso15646 a_58313_15032.n376 a_58313_15032.t105 29916.5813105305
Riso15647 a_58313_15032.n376 a_58313_15032.t106 33830.6225031134
Riso15648 a_58313_15032.n376 a_58313_15032.t107 37346.4847706252
Riso15649 a_58313_15032.n376 a_58313_15032.t108 40038.485269113
Riso15650 a_58313_15032.n376 a_58313_15032.t109 41507.4366432447
Riso15651 a_58313_15032.n376 a_58313_15032.t11 4009250.76195616
Riso15652 a_58313_15032.n376 a_58313_15032.t12 8110512.42642601
Riso15653 a_58313_15032.n376 a_58313_15032.t13 117615.534345199
Riso15654 a_58313_15032.n376 a_58313_15032.t14 58064.1759423795
Riso15655 a_58313_15032.n376 a_58313_15032.t15 8110512.42642601
Riso15656 a_58313_15032.n376 a_58313_15032.t16 4871.93910610709
Riso15657 a_58313_15032.n376 a_58313_15032.t17 58064.1759423795
Riso15658 a_58313_15032.n376 a_58313_15032.t18 117615.534345199
Riso15659 a_58313_15032.n376 a_58313_15032.t19 934.664967398074
Riso15660 a_58313_15032.n376 a_58313_15032.t2 16340595.8544472
Riso15661 a_58313_15032.n376 a_58313_15032.t20 977515.181899702
Riso15662 a_58313_15032.n376 a_58313_15032.t21 1979912.83768722
Riso15663 a_58313_15032.n376 a_58313_15032.t22 977515.181899702
Riso15664 a_58313_15032.n376 a_58313_15032.t23 1979912.83768722
Riso15665 a_58313_15032.n376 a_58313_15032.t24 4009250.76195616
Riso15666 a_58313_15032.n376 a_58313_15032.t25 934.664967398074
Riso15667 a_58313_15032.n376 a_58313_15032.t26 32386588.933735
Riso15668 a_58313_15032.n376 a_58313_15032.t27 482586.594534854
Riso15669 a_58313_15032.n376 a_58313_15032.t28 32386588.933735
Riso15670 a_58313_15032.n376 a_58313_15032.t29 16340595.8544472
Riso15671 a_58313_15032.n376 a_58313_15032.t3 7813.82838404583
Riso15672 a_58313_15032.n376 a_58313_15032.t30 271.890116183349
Riso15673 a_58313_15032.n376 a_58313_15032.t31 262.267904067166
Riso15674 a_58313_15032.n376 a_58313_15032.t32 322.097563772691
Riso15675 a_58313_15032.n376 a_58313_15032.t33 398.356601169961
Riso15676 a_58313_15032.n376 a_58313_15032.t34 497.987742925327
Riso15677 a_58313_15032.n376 a_58313_15032.t35 633.101229773124
Riso15678 a_58313_15032.n376 a_58313_15032.t36 827.181918753423
Riso15679 a_58313_15032.n376 a_58313_15032.t37 1132.9170627365
Riso15680 a_58313_15032.n376 a_58313_15032.t38 1698.32368023128
Riso15681 a_58313_15032.n376 a_58313_15032.t39 3158.97484188257
Riso15682 a_58313_15032.n376 a_58313_15032.t4 91574287.1455992
Riso15683 a_58313_15032.n376 a_58313_15032.t40 5908.78039416033
Riso15684 a_58313_15032.n376 a_58313_15032.t41 7069.3920487462
Riso15685 a_58313_15032.n376 a_58313_15032.t42 8413.25277580614
Riso15686 a_58313_15032.n376 a_58313_15032.t43 9937.76027956199
Riso15687 a_58313_15032.n376 a_58313_15032.t44 11616.4946200652
Riso15688 a_58313_15032.n376 a_58313_15032.t45 13386.6780023151
Riso15689 a_58313_15032.n376 a_58313_15032.t46 15138.0816332661
Riso15690 a_58313_15032.n376 a_58313_15032.t47 16711.3134001961
Riso15691 a_58313_15032.n376 a_58313_15032.t48 17915.8943475066
Riso15692 a_58313_15032.n376 a_58313_15032.t49 18573.2013720775
Riso15693 a_58313_15032.n376 a_58313_15032.t5 482586.594534854
Riso15694 a_58313_15032.n376 a_58313_15032.t50 24638.1490169646
Riso15695 a_58313_15032.n376 a_58313_15032.t51 23766.2030289336
Riso15696 a_58313_15032.n376 a_58313_15032.t52 22168.2746864643
Riso15697 a_58313_15032.n376 a_58313_15032.t53 20081.3152046103
Riso15698 a_58313_15032.n376 a_58313_15032.t54 17758.0030957404
Riso15699 a_58313_15032.n376 a_58313_15032.t55 15409.778840508
Riso15700 a_58313_15032.n376 a_58313_15032.t56 13182.865665303
Riso15701 a_58313_15032.n376 a_58313_15032.t57 11160.5410104116
Riso15702 a_58313_15032.n376 a_58313_15032.t58 9377.85206045346
Riso15703 a_58313_15032.n376 a_58313_15032.t59 7838.25087250197
Riso15704 a_58313_15032.n376 a_58313_15032.t6 4871.93910610709
Riso15705 a_58313_15032.n376 a_58313_15032.t60 7838.25087250197
Riso15706 a_58313_15032.n376 a_58313_15032.t61 9377.85206045346
Riso15707 a_58313_15032.n376 a_58313_15032.t62 11160.5410104116
Riso15708 a_58313_15032.n376 a_58313_15032.t63 13182.865665303
Riso15709 a_58313_15032.n376 a_58313_15032.t64 15409.778840508
Riso15710 a_58313_15032.n376 a_58313_15032.t65 17758.0030957404
Riso15711 a_58313_15032.n376 a_58313_15032.t66 20081.3152046103
Riso15712 a_58313_15032.n376 a_58313_15032.t67 22168.2746864643
Riso15713 a_58313_15032.n376 a_58313_15032.t68 23766.2030289336
Riso15714 a_58313_15032.n376 a_58313_15032.t69 24638.1490169646
Riso15715 a_58313_15032.n376 a_58313_15032.t7 60274323.0797745
Riso15716 a_58313_15032.n376 a_58313_15032.t70 31956.276394591
Riso15717 a_58313_15032.n376 a_58313_15032.t71 30825.3413160066
Riso15718 a_58313_15032.n376 a_58313_15032.t72 28752.7895291197
Riso15719 a_58313_15032.n376 a_58313_15032.t73 26045.952502502
Riso15720 a_58313_15032.n376 a_58313_15032.t74 23032.5603905044
Riso15721 a_58313_15032.n376 a_58313_15032.t75 19986.8566209144
Riso15722 a_58313_15032.n376 a_58313_15032.t76 17098.4962621632
Riso15723 a_58313_15032.n376 a_58313_15032.t77 14475.4921725779
Riso15724 a_58313_15032.n376 a_58313_15032.t78 12163.3013999993
Riso15725 a_58313_15032.n376 a_58313_15032.t79 10166.4013461136
Riso15726 a_58313_15032.n376 a_58313_15032.t8 60274323.0797745
Riso15727 a_58313_15032.n376 a_58313_15032.t80 10166.4013461136
Riso15728 a_58313_15032.n376 a_58313_15032.t81 12163.3013999993
Riso15729 a_58313_15032.n376 a_58313_15032.t82 14475.4921725779
Riso15730 a_58313_15032.n376 a_58313_15032.t83 17098.4962621632
Riso15731 a_58313_15032.n376 a_58313_15032.t84 19986.8566209144
Riso15732 a_58313_15032.n376 a_58313_15032.t85 23032.5603905044
Riso15733 a_58313_15032.n376 a_58313_15032.t86 26045.952502502
Riso15734 a_58313_15032.n376 a_58313_15032.t87 28752.7895291197
Riso15735 a_58313_15032.n376 a_58313_15032.t88 30825.3413160066
Riso15736 a_58313_15032.n376 a_58313_15032.t89 31956.276394591
Riso15737 a_58313_15032.n376 a_58313_15032.t9 91574287.1455992
Riso15738 a_58313_15032.n376 a_58313_15032.t90 41507.4366432447
Riso15739 a_58313_15032.n376 a_58313_15032.t91 40038.485269113
Riso15740 a_58313_15032.n376 a_58313_15032.t92 37346.4847706252
Riso15741 a_58313_15032.n376 a_58313_15032.t93 33830.6225031134
Riso15742 a_58313_15032.n376 a_58313_15032.t94 29916.5813105305
Riso15743 a_58313_15032.n376 a_58313_15032.t95 25960.5710830138
Riso15744 a_58313_15032.n376 a_58313_15032.t96 22208.9314015515
Riso15745 a_58313_15032.n376 a_58313_15032.t97 18801.9582386251
Riso15746 a_58313_15032.n376 a_58313_15032.t98 15798.694941774
Riso15747 a_58313_15032.n376 a_58313_15032.t99 13204.9571280787
Riso15748 a_58313_15032.t0 a_58313_15032.t1 325.526781201824
Riso15749 a_58313_15032.t0 a_58313_15032.t10 0.815243247710967
Riso15750 a_58313_15032.t0 a_58313_15032.t100 195434.262938576
Riso15751 a_58313_15032.t0 a_58313_15032.t101 233821.758858392
Riso15752 a_58313_15032.t0 a_58313_15032.t102 278270.259761323
Riso15753 a_58313_15032.t0 a_58313_15032.t103 328693.694119335
Riso15754 a_58313_15032.t0 a_58313_15032.t104 384218.216376105
Riso15755 a_58313_15032.t0 a_58313_15032.t105 442767.43660403
Riso15756 a_58313_15032.t0 a_58313_15032.t106 500695.512262611
Riso15757 a_58313_15032.t0 a_58313_15032.t107 552730.512768871
Riso15758 a_58313_15032.t0 a_58313_15032.t108 592572.303101802
Riso15759 a_58313_15032.t0 a_58313_15032.t109 614312.883272681
Riso15760 a_58313_15032.t0 a_58313_15032.t11 216.723791017763
Riso15761 a_58313_15032.t0 a_58313_15032.t12 438.421317227385
Riso15762 a_58313_15032.t0 a_58313_15032.t13 24.612835561981
Riso15763 a_58313_15032.t0 a_58313_15032.t14 40.4730679391024
Riso15764 a_58313_15032.t0 a_58313_15032.t15 438.421317227385
Riso15765 a_58313_15032.t0 a_58313_15032.t16 588.9466128431
Riso15766 a_58313_15032.t0 a_58313_15032.t17 40.4730679391024
Riso15767 a_58313_15032.t0 a_58313_15032.t18 24.612835561981
Riso15768 a_58313_15032.t0 a_58313_15032.t19 917.911754166565
Riso15769 a_58313_15032.t0 a_58313_15032.t2 883.306156519143
Riso15770 a_58313_15032.t0 a_58313_15032.t20 52.8404952887899
Riso15771 a_58313_15032.t0 a_58313_15032.t21 107.026035921722
Riso15772 a_58313_15032.t0 a_58313_15032.t22 52.8404952887899
Riso15773 a_58313_15032.t0 a_58313_15032.t23 107.026035921722
Riso15774 a_58313_15032.t0 a_58313_15032.t24 216.723791017763
Riso15775 a_58313_15032.t0 a_58313_15032.t25 917.911754166565
Riso15776 a_58313_15032.t0 a_58313_15032.t26 1750.68728512964
Riso15777 a_58313_15032.t0 a_58313_15032.t27 26.0866686749511
Riso15778 a_58313_15032.t0 a_58313_15032.t28 1750.68728512964
Riso15779 a_58313_15032.t0 a_58313_15032.t29 883.306156519143
Riso15780 a_58313_15032.t0 a_58313_15032.t3 325.526781201824
Riso15781 a_58313_15032.t0 a_58313_15032.t30 1755992.43622823
Riso15782 a_58313_15032.t0 a_58313_15032.t31 1693847.72889944
Riso15783 a_58313_15032.t0 a_58313_15032.t32 1270761.72914117
Riso15784 a_58313_15032.t0 a_58313_15032.t33 987791.034262094
Riso15785 a_58313_15032.t0 a_58313_15032.t34 784354.4818604
Riso15786 a_58313_15032.t0 a_58313_15032.t35 631199.524718184
Riso15787 a_58313_15032.t0 a_58313_15032.t36 512357.014519649
Riso15788 a_58313_15032.t0 a_58313_15032.t37 418260.6853307
Riso15789 a_58313_15032.t0 a_58313_15032.t38 342740.000713682
Riso15790 a_58313_15032.t0 a_58313_15032.t39 281569.341709203
Riso15791 a_58313_15032.t0 a_58313_15032.t4 4950.13354072675
Riso15792 a_58313_15032.t0 a_58313_15032.t40 279751.514289258
Riso15793 a_58313_15032.t0 a_58313_15032.t41 334700.733284272
Riso15794 a_58313_15032.t0 a_58313_15032.t42 398325.889121917
Riso15795 a_58313_15032.t0 a_58313_15032.t43 470503.775973581
Riso15796 a_58313_15032.t0 a_58313_15032.t44 549983.540411821
Riso15797 a_58313_15032.t0 a_58313_15032.t45 633792.96447563
Riso15798 a_58313_15032.t0 a_58313_15032.t46 716713.26023996
Riso15799 a_58313_15032.t0 a_58313_15032.t47 791197.999859255
Riso15800 a_58313_15032.t0 a_58313_15032.t48 848228.947299292
Riso15801 a_58313_15032.t0 a_58313_15032.t49 879349.182476489
Riso15802 a_58313_15032.t0 a_58313_15032.t5 26.0866686749511
Riso15803 a_58313_15032.t0 a_58313_15032.t50 822406.542963212
Riso15804 a_58313_15032.t0 a_58313_15032.t51 793301.512176463
Riso15805 a_58313_15032.t0 a_58313_15032.t52 739963.6285908
Riso15806 a_58313_15032.t0 a_58313_15032.t53 670302.180744448
Riso15807 a_58313_15032.t0 a_58313_15032.t54 592751.424867271
Riso15808 a_58313_15032.t0 a_58313_15032.t55 514369.116581111
Riso15809 a_58313_15032.t0 a_58313_15032.t56 440036.098924691
Riso15810 a_58313_15032.t0 a_58313_15032.t57 372532.122589722
Riso15811 a_58313_15032.t0 a_58313_15032.t58 313027.041444858
Riso15812 a_58313_15032.t0 a_58313_15032.t59 261636.083071588
Riso15813 a_58313_15032.t0 a_58313_15032.t6 588.9466128431
Riso15814 a_58313_15032.t0 a_58313_15032.t60 261636.083071588
Riso15815 a_58313_15032.t0 a_58313_15032.t61 313027.041444858
Riso15816 a_58313_15032.t0 a_58313_15032.t62 372532.122589722
Riso15817 a_58313_15032.t0 a_58313_15032.t63 440036.098924691
Riso15818 a_58313_15032.t0 a_58313_15032.t64 514369.116581111
Riso15819 a_58313_15032.t0 a_58313_15032.t65 592751.424867271
Riso15820 a_58313_15032.t0 a_58313_15032.t66 670302.180744448
Riso15821 a_58313_15032.t0 a_58313_15032.t67 739963.6285908
Riso15822 a_58313_15032.t0 a_58313_15032.t68 793301.512176463
Riso15823 a_58313_15032.t0 a_58313_15032.t69 822406.542963212
Riso15824 a_58313_15032.t0 a_58313_15032.t7 3258.18477677475
Riso15825 a_58313_15032.t0 a_58313_15032.t70 726820.653512536
Riso15826 a_58313_15032.t0 a_58313_15032.t71 701098.414702632
Riso15827 a_58313_15032.t0 a_58313_15032.t72 653959.836177923
Riso15828 a_58313_15032.t0 a_58313_15032.t73 592394.933172792
Riso15829 a_58313_15032.t0 a_58313_15032.t74 523857.673165166
Riso15830 a_58313_15032.t0 a_58313_15032.t75 454585.509635071
Riso15831 a_58313_15032.t0 a_58313_15032.t76 388891.999615156
Riso15832 a_58313_15032.t0 a_58313_15032.t77 329233.811564151
Riso15833 a_58313_15032.t0 a_58313_15032.t78 276644.830682268
Riso15834 a_58313_15032.t0 a_58313_15032.t79 231226.891988697
Riso15835 a_58313_15032.t0 a_58313_15032.t8 3258.18477677475
Riso15836 a_58313_15032.t0 a_58313_15032.t80 231226.891988697
Riso15837 a_58313_15032.t0 a_58313_15032.t81 276644.830682268
Riso15838 a_58313_15032.t0 a_58313_15032.t82 329233.811564151
Riso15839 a_58313_15032.t0 a_58313_15032.t83 388891.999615156
Riso15840 a_58313_15032.t0 a_58313_15032.t84 454585.509635071
Riso15841 a_58313_15032.t0 a_58313_15032.t85 523857.673165166
Riso15842 a_58313_15032.t0 a_58313_15032.t86 592394.933172792
Riso15843 a_58313_15032.t0 a_58313_15032.t87 653959.836177923
Riso15844 a_58313_15032.t0 a_58313_15032.t88 701098.414702633
Riso15845 a_58313_15032.t0 a_58313_15032.t89 726820.653512536
Riso15846 a_58313_15032.t0 a_58313_15032.t9 4950.13354072675
Riso15847 a_58313_15032.t0 a_58313_15032.t90 614312.883272681
Riso15848 a_58313_15032.t0 a_58313_15032.t91 592572.303101802
Riso15849 a_58313_15032.t0 a_58313_15032.t92 552730.512768871
Riso15850 a_58313_15032.t0 a_58313_15032.t93 500695.512262611
Riso15851 a_58313_15032.t0 a_58313_15032.t94 442767.43660403
Riso15852 a_58313_15032.t0 a_58313_15032.t95 384218.216376105
Riso15853 a_58313_15032.t0 a_58313_15032.t96 328693.694119335
Riso15854 a_58313_15032.t0 a_58313_15032.t97 278270.259761323
Riso15855 a_58313_15032.t0 a_58313_15032.t98 233821.758858392
Riso15856 a_58313_15032.t0 a_58313_15032.t99 195434.262938576
Riso15857 a_58313_15032.t1 a_58313_15032.t10 325.526781201824
Riso15858 a_58313_15032.t1 a_58313_15032.t100 6409.79058216825
Riso15859 a_58313_15032.t1 a_58313_15032.t101 7668.81142181083
Riso15860 a_58313_15032.t1 a_58313_15032.t102 9126.61916849365
Riso15861 a_58313_15032.t1 a_58313_15032.t103 10780.3908757103
Riso15862 a_58313_15032.t1 a_58313_15032.t104 12601.4664357962
Riso15863 a_58313_15032.t1 a_58313_15032.t105 14521.7450745945
Riso15864 a_58313_15032.t1 a_58313_15032.t106 16421.6516120486
Riso15865 a_58313_15032.t1 a_58313_15032.t107 18128.2789514572
Riso15866 a_58313_15032.t1 a_58313_15032.t108 19434.9972751168
Riso15867 a_58313_15032.t1 a_58313_15032.t109 20148.037884961
Riso15868 a_58313_15032.t1 a_58313_15032.t11 5478.09060804338
Riso15869 a_58313_15032.t1 a_58313_15032.t12 11081.9014792543
Riso15870 a_58313_15032.t1 a_58313_15032.t13 160.705476487102
Riso15871 a_58313_15032.t1 a_58313_15032.t14 79.3367229388598
Riso15872 a_58313_15032.t1 a_58313_15032.t15 11081.9014792543
Riso15873 a_58313_15032.t1 a_58313_15032.t16 19.3160830431666
Riso15874 a_58313_15032.t1 a_58313_15032.t17 79.3367229388598
Riso15875 a_58313_15032.t1 a_58313_15032.t18 160.705476487102
Riso15876 a_58313_15032.t1 a_58313_15032.t19 30.1053767576445
Riso15877 a_58313_15032.t1 a_58313_15032.t2 22327.1803124643
Riso15878 a_58313_15032.t1 a_58313_15032.t20 1335.64026176598
Riso15879 a_58313_15032.t1 a_58313_15032.t21 2705.2790071896
Riso15880 a_58313_15032.t1 a_58313_15032.t22 1335.64026176598
Riso15881 a_58313_15032.t1 a_58313_15032.t23 2705.2790071896
Riso15882 a_58313_15032.t1 a_58313_15032.t24 5478.09060804338
Riso15883 a_58313_15032.t1 a_58313_15032.t25 30.1053767576445
Riso15884 a_58313_15032.t1 a_58313_15032.t26 44251.8263881035
Riso15885 a_58313_15032.t1 a_58313_15032.t27 659.388311695215
Riso15886 a_58313_15032.t1 a_58313_15032.t28 44251.8263881035
Riso15887 a_58313_15032.t1 a_58313_15032.t29 22327.1803124643
Riso15888 a_58313_15032.t1 a_58313_15032.t3 0.707443483273983
Riso15889 a_58313_15032.t1 a_58313_15032.t30 57592.4794908245
Riso15890 a_58313_15032.t1 a_58313_15032.t31 55554.2772136077
Riso15891 a_58313_15032.t1 a_58313_15032.t32 41678.0376232643
Riso15892 a_58313_15032.t1 a_58313_15032.t33 32397.2550839429
Riso15893 a_58313_15032.t1 a_58313_15032.t34 25725.0079659285
Riso15894 a_58313_15032.t1 a_58313_15032.t35 20701.8805616458
Riso15895 a_58313_15032.t1 a_58313_15032.t36 16804.121841256
Riso15896 a_58313_15032.t1 a_58313_15032.t37 13717.9804677676
Riso15897 a_58313_15032.t1 a_58313_15032.t38 11241.0771564521
Riso15898 a_58313_15032.t1 a_58313_15032.t39 9234.82140530394
Riso15899 a_58313_15032.t1 a_58313_15032.t4 125123.688223934
Riso15900 a_58313_15032.t1 a_58313_15032.t40 9175.20088175206
Riso15901 a_58313_15032.t1 a_58313_15032.t41 10977.4078290694
Riso15902 a_58313_15032.t1 a_58313_15032.t42 13064.1653839885
Riso15903 a_58313_15032.t1 a_58313_15032.t43 15431.4326810644
Riso15904 a_58313_15032.t1 a_58313_15032.t44 18038.1846287987
Riso15905 a_58313_15032.t1 a_58313_15032.t45 20786.939371103
Riso15906 a_58313_15032.t1 a_58313_15032.t46 23506.5327672101
Riso15907 a_58313_15032.t1 a_58313_15032.t47 25949.4594851166
Riso15908 a_58313_15032.t1 a_58313_15032.t48 27819.9422975811
Riso15909 a_58313_15032.t1 a_58313_15032.t49 28840.613838765
Riso15910 a_58313_15032.t1 a_58313_15032.t5 659.388311695215
Riso15911 a_58313_15032.t1 a_58313_15032.t50 26973.0273214985
Riso15912 a_58313_15032.t1 a_58313_15032.t51 26018.4498107514
Riso15913 a_58313_15032.t1 a_58313_15032.t52 24269.0909279252
Riso15914 a_58313_15032.t1 a_58313_15032.t53 21984.3569942133
Riso15915 a_58313_15032.t1 a_58313_15032.t54 19440.8720536131
Riso15916 a_58313_15032.t1 a_58313_15032.t55 16870.1141224967
Riso15917 a_58313_15032.t1 a_58313_15032.t56 14432.1635331059
Riso15918 a_58313_15032.t1 a_58313_15032.t57 12218.1896614579
Riso15919 a_58313_15032.t1 a_58313_15032.t58 10266.5610013729
Riso15920 a_58313_15032.t1 a_58313_15032.t59 8581.05675029325
Riso15921 a_58313_15032.t1 a_58313_15032.t6 19.3160830431666
Riso15922 a_58313_15032.t1 a_58313_15032.t60 8581.05675029325
Riso15923 a_58313_15032.t1 a_58313_15032.t61 10266.5610013729
Riso15924 a_58313_15032.t1 a_58313_15032.t62 12218.1896614579
Riso15925 a_58313_15032.t1 a_58313_15032.t63 14432.1635331059
Riso15926 a_58313_15032.t1 a_58313_15032.t64 16870.1141224967
Riso15927 a_58313_15032.t1 a_58313_15032.t65 19440.8720536131
Riso15928 a_58313_15032.t1 a_58313_15032.t66 21984.3569942133
Riso15929 a_58313_15032.t1 a_58313_15032.t67 24269.0909279252
Riso15930 a_58313_15032.t1 a_58313_15032.t68 26018.4498107514
Riso15931 a_58313_15032.t1 a_58313_15032.t69 26973.0273214985
Riso15932 a_58313_15032.t1 a_58313_15032.t7 82356.5855003748
Riso15933 a_58313_15032.t1 a_58313_15032.t70 23838.0318259457
Riso15934 a_58313_15032.t1 a_58313_15032.t71 22994.4020468224
Riso15935 a_58313_15032.t1 a_58313_15032.t72 21448.3659928504
Riso15936 a_58313_15032.t1 a_58313_15032.t73 19429.1799527935
Riso15937 a_58313_15032.t1 a_58313_15032.t74 17181.3167730266
Riso15938 a_58313_15032.t1 a_58313_15032.t75 14909.3504620774
Riso15939 a_58313_15032.t1 a_58313_15032.t76 12754.7556868125
Riso15940 a_58313_15032.t1 a_58313_15032.t77 10798.1054752846
Riso15941 a_58313_15032.t1 a_58313_15032.t78 9073.30886432154
Riso15942 a_58313_15032.t1 a_58313_15032.t79 7583.70580638156
Riso15943 a_58313_15032.t1 a_58313_15032.t8 82356.5855003748
Riso15944 a_58313_15032.t1 a_58313_15032.t80 7583.70580638156
Riso15945 a_58313_15032.t1 a_58313_15032.t81 9073.30886432154
Riso15946 a_58313_15032.t1 a_58313_15032.t82 10798.1054752846
Riso15947 a_58313_15032.t1 a_58313_15032.t83 12754.7556868125
Riso15948 a_58313_15032.t1 a_58313_15032.t84 14909.3504620774
Riso15949 a_58313_15032.t1 a_58313_15032.t85 17181.3167730266
Riso15950 a_58313_15032.t1 a_58313_15032.t86 19429.1799527935
Riso15951 a_58313_15032.t1 a_58313_15032.t87 21448.3659928504
Riso15952 a_58313_15032.t1 a_58313_15032.t88 22994.4020468224
Riso15953 a_58313_15032.t1 a_58313_15032.t89 23838.0318259457
Riso15954 a_58313_15032.t1 a_58313_15032.t9 125123.688223934
Riso15955 a_58313_15032.t1 a_58313_15032.t90 20148.037884961
Riso15956 a_58313_15032.t1 a_58313_15032.t91 19434.9972751168
Riso15957 a_58313_15032.t1 a_58313_15032.t92 18128.2789514572
Riso15958 a_58313_15032.t1 a_58313_15032.t93 16421.6516120486
Riso15959 a_58313_15032.t1 a_58313_15032.t94 14521.7450745945
Riso15960 a_58313_15032.t1 a_58313_15032.t95 12601.4664357962
Riso15961 a_58313_15032.t1 a_58313_15032.t96 10780.3908757103
Riso15962 a_58313_15032.t1 a_58313_15032.t97 9126.61916849365
Riso15963 a_58313_15032.t1 a_58313_15032.t98 7668.81142181083
Riso15964 a_58313_15032.t1 a_58313_15032.t99 6409.79058216825
Riso15965 a_58313_15032.t10 a_58313_15032.t100 195434.262938576
Riso15966 a_58313_15032.t10 a_58313_15032.t101 233821.758858392
Riso15967 a_58313_15032.t10 a_58313_15032.t102 278270.259761323
Riso15968 a_58313_15032.t10 a_58313_15032.t103 328693.694119335
Riso15969 a_58313_15032.t10 a_58313_15032.t104 384218.216376105
Riso15970 a_58313_15032.t10 a_58313_15032.t105 442767.43660403
Riso15971 a_58313_15032.t10 a_58313_15032.t106 500695.512262611
Riso15972 a_58313_15032.t10 a_58313_15032.t107 552730.512768871
Riso15973 a_58313_15032.t10 a_58313_15032.t108 592572.303101802
Riso15974 a_58313_15032.t10 a_58313_15032.t109 614312.883272681
Riso15975 a_58313_15032.t10 a_58313_15032.t11 216.723791017763
Riso15976 a_58313_15032.t10 a_58313_15032.t12 438.421317227385
Riso15977 a_58313_15032.t10 a_58313_15032.t13 24.612835561981
Riso15978 a_58313_15032.t10 a_58313_15032.t14 40.4730679391024
Riso15979 a_58313_15032.t10 a_58313_15032.t15 438.421317227385
Riso15980 a_58313_15032.t10 a_58313_15032.t16 588.9466128431
Riso15981 a_58313_15032.t10 a_58313_15032.t17 40.4730679391024
Riso15982 a_58313_15032.t10 a_58313_15032.t18 24.612835561981
Riso15983 a_58313_15032.t10 a_58313_15032.t19 917.911754166565
Riso15984 a_58313_15032.t10 a_58313_15032.t2 883.306156519143
Riso15985 a_58313_15032.t10 a_58313_15032.t20 52.8404952887899
Riso15986 a_58313_15032.t10 a_58313_15032.t21 107.026035921722
Riso15987 a_58313_15032.t10 a_58313_15032.t22 52.8404952887899
Riso15988 a_58313_15032.t10 a_58313_15032.t23 107.026035921722
Riso15989 a_58313_15032.t10 a_58313_15032.t24 216.723791017763
Riso15990 a_58313_15032.t10 a_58313_15032.t25 917.911754166565
Riso15991 a_58313_15032.t10 a_58313_15032.t26 1750.68728512964
Riso15992 a_58313_15032.t10 a_58313_15032.t27 26.0866686749511
Riso15993 a_58313_15032.t10 a_58313_15032.t28 1750.68728512964
Riso15994 a_58313_15032.t10 a_58313_15032.t29 883.306156519143
Riso15995 a_58313_15032.t10 a_58313_15032.t3 325.526781201824
Riso15996 a_58313_15032.t10 a_58313_15032.t30 1755992.43622823
Riso15997 a_58313_15032.t10 a_58313_15032.t31 1693847.72889944
Riso15998 a_58313_15032.t10 a_58313_15032.t32 1270761.72914117
Riso15999 a_58313_15032.t10 a_58313_15032.t33 987791.034262094
Riso16000 a_58313_15032.t10 a_58313_15032.t34 784354.4818604
Riso16001 a_58313_15032.t10 a_58313_15032.t35 631199.524718184
Riso16002 a_58313_15032.t10 a_58313_15032.t36 512357.014519649
Riso16003 a_58313_15032.t10 a_58313_15032.t37 418260.6853307
Riso16004 a_58313_15032.t10 a_58313_15032.t38 342740.000713682
Riso16005 a_58313_15032.t10 a_58313_15032.t39 281569.341709203
Riso16006 a_58313_15032.t10 a_58313_15032.t4 4950.13354072675
Riso16007 a_58313_15032.t10 a_58313_15032.t40 279751.514289258
Riso16008 a_58313_15032.t10 a_58313_15032.t41 334700.733284272
Riso16009 a_58313_15032.t10 a_58313_15032.t42 398325.889121917
Riso16010 a_58313_15032.t10 a_58313_15032.t43 470503.775973581
Riso16011 a_58313_15032.t10 a_58313_15032.t44 549983.540411821
Riso16012 a_58313_15032.t10 a_58313_15032.t45 633792.96447563
Riso16013 a_58313_15032.t10 a_58313_15032.t46 716713.26023996
Riso16014 a_58313_15032.t10 a_58313_15032.t47 791197.999859255
Riso16015 a_58313_15032.t10 a_58313_15032.t48 848228.947299292
Riso16016 a_58313_15032.t10 a_58313_15032.t49 879349.182476489
Riso16017 a_58313_15032.t10 a_58313_15032.t5 26.0866686749511
Riso16018 a_58313_15032.t10 a_58313_15032.t50 822406.542963212
Riso16019 a_58313_15032.t10 a_58313_15032.t51 793301.512176463
Riso16020 a_58313_15032.t10 a_58313_15032.t52 739963.6285908
Riso16021 a_58313_15032.t10 a_58313_15032.t53 670302.180744448
Riso16022 a_58313_15032.t10 a_58313_15032.t54 592751.424867271
Riso16023 a_58313_15032.t10 a_58313_15032.t55 514369.116581111
Riso16024 a_58313_15032.t10 a_58313_15032.t56 440036.098924691
Riso16025 a_58313_15032.t10 a_58313_15032.t57 372532.122589722
Riso16026 a_58313_15032.t10 a_58313_15032.t58 313027.041444858
Riso16027 a_58313_15032.t10 a_58313_15032.t59 261636.083071588
Riso16028 a_58313_15032.t10 a_58313_15032.t6 588.9466128431
Riso16029 a_58313_15032.t10 a_58313_15032.t60 261636.083071588
Riso16030 a_58313_15032.t10 a_58313_15032.t61 313027.041444858
Riso16031 a_58313_15032.t10 a_58313_15032.t62 372532.122589722
Riso16032 a_58313_15032.t10 a_58313_15032.t63 440036.098924691
Riso16033 a_58313_15032.t10 a_58313_15032.t64 514369.116581111
Riso16034 a_58313_15032.t10 a_58313_15032.t65 592751.424867271
Riso16035 a_58313_15032.t10 a_58313_15032.t66 670302.180744448
Riso16036 a_58313_15032.t10 a_58313_15032.t67 739963.6285908
Riso16037 a_58313_15032.t10 a_58313_15032.t68 793301.512176463
Riso16038 a_58313_15032.t10 a_58313_15032.t69 822406.542963212
Riso16039 a_58313_15032.t10 a_58313_15032.t7 3258.18477677475
Riso16040 a_58313_15032.t10 a_58313_15032.t70 726820.653512536
Riso16041 a_58313_15032.t10 a_58313_15032.t71 701098.414702632
Riso16042 a_58313_15032.t10 a_58313_15032.t72 653959.836177923
Riso16043 a_58313_15032.t10 a_58313_15032.t73 592394.933172792
Riso16044 a_58313_15032.t10 a_58313_15032.t74 523857.673165166
Riso16045 a_58313_15032.t10 a_58313_15032.t75 454585.509635071
Riso16046 a_58313_15032.t10 a_58313_15032.t76 388891.999615156
Riso16047 a_58313_15032.t10 a_58313_15032.t77 329233.811564151
Riso16048 a_58313_15032.t10 a_58313_15032.t78 276644.830682268
Riso16049 a_58313_15032.t10 a_58313_15032.t79 231226.891988697
Riso16050 a_58313_15032.t10 a_58313_15032.t8 3258.18477677475
Riso16051 a_58313_15032.t10 a_58313_15032.t80 231226.891988697
Riso16052 a_58313_15032.t10 a_58313_15032.t81 276644.830682268
Riso16053 a_58313_15032.t10 a_58313_15032.t82 329233.811564151
Riso16054 a_58313_15032.t10 a_58313_15032.t83 388891.999615156
Riso16055 a_58313_15032.t10 a_58313_15032.t84 454585.509635071
Riso16056 a_58313_15032.t10 a_58313_15032.t85 523857.673165166
Riso16057 a_58313_15032.t10 a_58313_15032.t86 592394.933172792
Riso16058 a_58313_15032.t10 a_58313_15032.t87 653959.836177923
Riso16059 a_58313_15032.t10 a_58313_15032.t88 701098.414702633
Riso16060 a_58313_15032.t10 a_58313_15032.t89 726820.653512536
Riso16061 a_58313_15032.t10 a_58313_15032.t9 4950.13354072675
Riso16062 a_58313_15032.t10 a_58313_15032.t90 614312.883272681
Riso16063 a_58313_15032.t10 a_58313_15032.t91 592572.303101802
Riso16064 a_58313_15032.t10 a_58313_15032.t92 552730.512768871
Riso16065 a_58313_15032.t10 a_58313_15032.t93 500695.512262611
Riso16066 a_58313_15032.t10 a_58313_15032.t94 442767.43660403
Riso16067 a_58313_15032.t10 a_58313_15032.t95 384218.216376105
Riso16068 a_58313_15032.t10 a_58313_15032.t96 328693.694119335
Riso16069 a_58313_15032.t10 a_58313_15032.t97 278270.259761323
Riso16070 a_58313_15032.t10 a_58313_15032.t98 233821.758858392
Riso16071 a_58313_15032.t10 a_58313_15032.t99 195434.262938576
Riso16072 a_58313_15032.t100 a_58313_15032.t101 5389.17065095294
Riso16073 a_58313_15032.t100 a_58313_15032.t102 6413.62858726502
Riso16074 a_58313_15032.t100 a_58313_15032.t103 7575.79798454094
Riso16075 a_58313_15032.t100 a_58313_15032.t104 8855.53827567267
Riso16076 a_58313_15032.t100 a_58313_15032.t105 10204.9924104335
Riso16077 a_58313_15032.t100 a_58313_15032.t106 11540.1302809619
Riso16078 a_58313_15032.t100 a_58313_15032.t107 12739.4433770562
Riso16079 a_58313_15032.t100 a_58313_15032.t108 13657.7249270367
Riso16080 a_58313_15032.t100 a_58313_15032.t109 14158.8061658556
Riso16081 a_58313_15032.t100 a_58313_15032.t11 3288843.38284269
Riso16082 a_58313_15032.t100 a_58313_15032.t12 6653164.57085362
Riso16083 a_58313_15032.t100 a_58313_15032.t13 96481.6358011952
Riso16084 a_58313_15032.t100 a_58313_15032.t14 47630.8398168477
Riso16085 a_58313_15032.t100 a_58313_15032.t15 6653164.57085362
Riso16086 a_58313_15032.t100 a_58313_15032.t16 3996.51846244584
Riso16087 a_58313_15032.t100 a_58313_15032.t17 47630.8398168477
Riso16088 a_58313_15032.t100 a_58313_15032.t18 96481.6358011952
Riso16089 a_58313_15032.t100 a_58313_15032.t19 766.718490739204
Riso16090 a_58313_15032.t100 a_58313_15032.t2 13404414.8741109
Riso16091 a_58313_15032.t100 a_58313_15032.t20 801869.109342147
Riso16092 a_58313_15032.t100 a_58313_15032.t21 1624149.65325238
Riso16093 a_58313_15032.t100 a_58313_15032.t22 801869.109342147
Riso16094 a_58313_15032.t100 a_58313_15032.t23 1624149.65325238
Riso16095 a_58313_15032.t100 a_58313_15032.t24 3288843.38284269
Riso16096 a_58313_15032.t100 a_58313_15032.t25 766.718490739204
Riso16097 a_58313_15032.t100 a_58313_15032.t26 26567163.05158
Riso16098 a_58313_15032.t100 a_58313_15032.t27 395872.401682891
Riso16099 a_58313_15032.t100 a_58313_15032.t28 26567163.05158
Riso16100 a_58313_15032.t100 a_58313_15032.t29 13404414.8741109
Riso16101 a_58313_15032.t100 a_58313_15032.t3 6409.79058216825
Riso16102 a_58313_15032.t100 a_58313_15032.t30 97397.4385901322
Riso16103 a_58313_15032.t100 a_58313_15032.t31 93950.5357499598
Riso16104 a_58313_15032.t100 a_58313_15032.t32 70473.9485277659
Riso16105 a_58313_15032.t100 a_58313_15032.t33 54776.5062751287
Riso16106 a_58313_15032.t100 a_58313_15032.t34 43493.0524247303
Riso16107 a_58313_15032.t100 a_58313_15032.t35 34999.373932348
Riso16108 a_58313_15032.t100 a_58313_15032.t36 28409.0835368981
Riso16109 a_58313_15032.t100 a_58313_15032.t37 23191.3253527901
Riso16110 a_58313_15032.t100 a_58313_15032.t38 19003.7493914589
Riso16111 a_58313_15032.t100 a_58313_15032.t39 15611.9502547675
Riso16112 a_58313_15032.t100 a_58313_15032.t4 75119643.5940551
Riso16113 a_58313_15032.t100 a_58313_15032.t40 15511.122761544
Riso16114 a_58313_15032.t100 a_58313_15032.t41 18557.8411453499
Riso16115 a_58313_15032.t100 a_58313_15032.t42 22085.6061529046
Riso16116 a_58313_15032.t100 a_58313_15032.t43 26087.5865048944
Riso16117 a_58313_15032.t100 a_58313_15032.t44 30494.4272914126
Riso16118 a_58313_15032.t100 a_58313_15032.t45 35141.3306997133
Riso16119 a_58313_15032.t100 a_58313_15032.t46 39738.9354358012
Riso16120 a_58313_15032.t100 a_58313_15032.t47 43868.8217137426
Riso16121 a_58313_15032.t100 a_58313_15032.t48 47030.9637639726
Riso16122 a_58313_15032.t100 a_58313_15032.t49 48756.4585818577
Riso16123 a_58313_15032.t100 a_58313_15032.t5 395872.401682891
Riso16124 a_58313_15032.t100 a_58313_15032.t50 45599.1776188327
Riso16125 a_58313_15032.t100 a_58313_15032.t51 43985.4192169787
Riso16126 a_58313_15032.t100 a_58313_15032.t52 41028.0453387604
Riso16127 a_58313_15032.t100 a_58313_15032.t53 37165.5946314914
Riso16128 a_58313_15032.t100 a_58313_15032.t54 32865.7131167156
Riso16129 a_58313_15032.t100 a_58313_15032.t55 28519.725322362
Riso16130 a_58313_15032.t100 a_58313_15032.t56 24398.2546165891
Riso16131 a_58313_15032.t100 a_58313_15032.t57 20655.4271388493
Riso16132 a_58313_15032.t100 a_58313_15032.t58 17356.106641506
Riso16133 a_58313_15032.t100 a_58313_15032.t59 14506.6820364666
Riso16134 a_58313_15032.t100 a_58313_15032.t6 3996.51846244584
Riso16135 a_58313_15032.t100 a_58313_15032.t60 14506.6820364666
Riso16136 a_58313_15032.t100 a_58313_15032.t61 17356.106641506
Riso16137 a_58313_15032.t100 a_58313_15032.t62 20655.4271388493
Riso16138 a_58313_15032.t100 a_58313_15032.t63 24398.2546165891
Riso16139 a_58313_15032.t100 a_58313_15032.t64 28519.725322362
Riso16140 a_58313_15032.t100 a_58313_15032.t65 32865.7131167156
Riso16141 a_58313_15032.t100 a_58313_15032.t66 37165.5946314914
Riso16142 a_58313_15032.t100 a_58313_15032.t67 41028.0453387604
Riso16143 a_58313_15032.t100 a_58313_15032.t68 43985.4192169787
Riso16144 a_58313_15032.t100 a_58313_15032.t69 45599.1776188327
Riso16145 a_58313_15032.t100 a_58313_15032.t7 49443853.8235803
Riso16146 a_58313_15032.t100 a_58313_15032.t70 40299.2958347111
Riso16147 a_58313_15032.t100 a_58313_15032.t71 38873.1006566821
Riso16148 a_58313_15032.t100 a_58313_15032.t72 36259.455169292
Riso16149 a_58313_15032.t100 a_58313_15032.t73 32845.9277368381
Riso16150 a_58313_15032.t100 a_58313_15032.t74 29045.8110183605
Riso16151 a_58313_15032.t100 a_58313_15032.t75 25204.9468413196
Riso16152 a_58313_15032.t100 a_58313_15032.t76 21562.5046763661
Riso16153 a_58313_15032.t100 a_58313_15032.t77 18254.6969556973
Riso16154 a_58313_15032.t100 a_58313_15032.t78 15338.8484751087
Riso16155 a_58313_15032.t100 a_58313_15032.t79 12820.6055787772
Riso16156 a_58313_15032.t100 a_58313_15032.t8 49443853.8235803
Riso16157 a_58313_15032.t100 a_58313_15032.t80 12820.6055787772
Riso16158 a_58313_15032.t100 a_58313_15032.t81 15338.8484751087
Riso16159 a_58313_15032.t100 a_58313_15032.t82 18254.6969556973
Riso16160 a_58313_15032.t100 a_58313_15032.t83 21562.5046763661
Riso16161 a_58313_15032.t100 a_58313_15032.t84 25204.9468413196
Riso16162 a_58313_15032.t100 a_58313_15032.t85 29045.8110183605
Riso16163 a_58313_15032.t100 a_58313_15032.t86 32845.9277368381
Riso16164 a_58313_15032.t100 a_58313_15032.t87 36259.455169292
Riso16165 a_58313_15032.t100 a_58313_15032.t88 38873.1006566821
Riso16166 a_58313_15032.t100 a_58313_15032.t89 40299.2958347111
Riso16167 a_58313_15032.t100 a_58313_15032.t9 75119643.5940551
Riso16168 a_58313_15032.t100 a_58313_15032.t90 32867.6556140193
Riso16169 a_58313_15032.t100 a_58313_15032.t91 31704.4667547873
Riso16170 a_58313_15032.t100 a_58313_15032.t92 29572.8066848691
Riso16171 a_58313_15032.t100 a_58313_15032.t93 26788.7718337622
Riso16172 a_58313_15032.t100 a_58313_15032.t94 23689.4390784634
Riso16173 a_58313_15032.t100 a_58313_15032.t95 20556.8731510342
Riso16174 a_58313_15032.t100 a_58313_15032.t96 17586.1380006558
Riso16175 a_58313_15032.t100 a_58313_15032.t97 14888.3269657867
Riso16176 a_58313_15032.t100 a_58313_15032.t98 12510.1935096657
Riso16177 a_58313_15032.t100 a_58313_15032.t99 10456.3427275439
Riso16178 a_58313_15032.t101 a_58313_15032.t102 3070.78551360712
Riso16179 a_58313_15032.t101 a_58313_15032.t103 3627.22137529682
Riso16180 a_58313_15032.t101 a_58313_15032.t104 4239.94908375654
Riso16181 a_58313_15032.t101 a_58313_15032.t105 4886.05512995462
Riso16182 a_58313_15032.t101 a_58313_15032.t106 5525.30668244206
Riso16183 a_58313_15032.t101 a_58313_15032.t107 6099.52660048942
Riso16184 a_58313_15032.t101 a_58313_15032.t108 6539.19123693125
Riso16185 a_58313_15032.t101 a_58313_15032.t109 6779.10425783193
Riso16186 a_58313_15032.t101 a_58313_15032.t11 3934843.0148492
Riso16187 a_58313_15032.t101 a_58313_15032.t12 7959989.30044452
Riso16188 a_58313_15032.t101 a_58313_15032.t13 115432.705818122
Riso16189 a_58313_15032.t101 a_58313_15032.t14 56986.5620000213
Riso16190 a_58313_15032.t101 a_58313_15032.t15 7959989.30044452
Riso16191 a_58313_15032.t101 a_58313_15032.t16 4781.52071263378
Riso16192 a_58313_15032.t101 a_58313_15032.t17 56986.5620000213
Riso16193 a_58313_15032.t101 a_58313_15032.t18 115432.705818122
Riso16194 a_58313_15032.t101 a_58313_15032.t19 917.318505763941
Riso16195 a_58313_15032.t101 a_58313_15032.t2 16037330.4824102
Riso16196 a_58313_15032.t101 a_58313_15032.t20 959373.462469684
Riso16197 a_58313_15032.t101 a_58313_15032.t21 1943167.60460817
Riso16198 a_58313_15032.t101 a_58313_15032.t22 959373.462469684
Riso16199 a_58313_15032.t101 a_58313_15032.t23 1943167.60460817
Riso16200 a_58313_15032.t101 a_58313_15032.t24 3934843.0148492
Riso16201 a_58313_15032.t101 a_58313_15032.t25 917.318505763941
Riso16202 a_58313_15032.t101 a_58313_15032.t26 31785525.7271366
Riso16203 a_58313_15032.t101 a_58313_15032.t27 473630.262438072
Riso16204 a_58313_15032.t101 a_58313_15032.t28 31785525.7271366
Riso16205 a_58313_15032.t101 a_58313_15032.t29 16037330.4824102
Riso16206 a_58313_15032.t101 a_58313_15032.t3 7668.81142181083
Riso16207 a_58313_15032.t101 a_58313_15032.t30 116528.391987256
Riso16208 a_58313_15032.t101 a_58313_15032.t31 112404.443235463
Riso16209 a_58313_15032.t101 a_58313_15032.t32 84316.5489545556
Riso16210 a_58313_15032.t101 a_58313_15032.t33 65535.7911595764
Riso16211 a_58313_15032.t101 a_58313_15032.t34 52036.0240991465
Riso16212 a_58313_15032.t101 a_58313_15032.t35 41874.0043263356
Riso16213 a_58313_15032.t101 a_58313_15032.t36 33989.2390426966
Riso16214 a_58313_15032.t101 a_58313_15032.t37 27746.6008401551
Riso16215 a_58313_15032.t101 a_58313_15032.t38 22736.494823385
Riso16216 a_58313_15032.t101 a_58313_15032.t39 18678.4733285316
Riso16217 a_58313_15032.t101 a_58313_15032.t4 89874758.5294083
Riso16218 a_58313_15032.t101 a_58313_15032.t40 18557.8411453499
Riso16219 a_58313_15032.t101 a_58313_15032.t41 22203.0005996652
Riso16220 a_58313_15032.t101 a_58313_15032.t42 26423.6945890543
Riso16221 a_58313_15032.t101 a_58313_15032.t43 31211.7500239043
Riso16222 a_58313_15032.t101 a_58313_15032.t44 36484.1891971544
Riso16223 a_58313_15032.t101 a_58313_15032.t45 42043.844458399
Riso16224 a_58313_15032.t101 a_58313_15032.t46 47544.5177270654
Riso16225 a_58313_15032.t101 a_58313_15032.t47 52485.6025648704
Riso16226 a_58313_15032.t101 a_58313_15032.t48 56268.857378164
Riso16227 a_58313_15032.t101 a_58313_15032.t49 58333.2765191707
Riso16228 a_58313_15032.t101 a_58313_15032.t5 473630.262438072
Riso16229 a_58313_15032.t101 a_58313_15032.t50 54555.8376152429
Riso16230 a_58313_15032.t101 a_58313_15032.t51 52625.1023274772
Riso16231 a_58313_15032.t101 a_58313_15032.t52 49086.8365627672
Riso16232 a_58313_15032.t101 a_58313_15032.t53 44465.7173982055
Riso16233 a_58313_15032.t101 a_58313_15032.t54 39321.2465999425
Riso16234 a_58313_15032.t101 a_58313_15032.t55 34121.6132563652
Riso16235 a_58313_15032.t101 a_58313_15032.t56 29190.5969902459
Riso16236 a_58313_15032.t101 a_58313_15032.t57 24712.5976323559
Riso16237 a_58313_15032.t101 a_58313_15032.t58 20765.2195722007
Riso16238 a_58313_15032.t101 a_58313_15032.t59 17356.106641506
Riso16239 a_58313_15032.t101 a_58313_15032.t6 4781.52071263378
Riso16240 a_58313_15032.t101 a_58313_15032.t60 17356.106641506
Riso16241 a_58313_15032.t101 a_58313_15032.t61 20765.2195722007
Riso16242 a_58313_15032.t101 a_58313_15032.t62 24712.5976323559
Riso16243 a_58313_15032.t101 a_58313_15032.t63 29190.5969902459
Riso16244 a_58313_15032.t101 a_58313_15032.t64 34121.6132563652
Riso16245 a_58313_15032.t101 a_58313_15032.t65 39321.2465999425
Riso16246 a_58313_15032.t101 a_58313_15032.t66 44465.7173982055
Riso16247 a_58313_15032.t101 a_58313_15032.t67 49086.8365627672
Riso16248 a_58313_15032.t101 a_58313_15032.t68 52625.1023274772
Riso16249 a_58313_15032.t101 a_58313_15032.t69 54555.8376152429
Riso16250 a_58313_15032.t101 a_58313_15032.t7 59155690.9823961
Riso16251 a_58313_15032.t101 a_58313_15032.t70 48214.944969953
Riso16252 a_58313_15032.t101 a_58313_15032.t71 46508.6143604278
Riso16253 a_58313_15032.t101 a_58313_15032.t72 43381.5926411813
Riso16254 a_58313_15032.t101 a_58313_15032.t73 39297.5749455811
Riso16255 a_58313_15032.t101 a_58313_15032.t74 34751.0335069345
Riso16256 a_58313_15032.t101 a_58313_15032.t75 30155.7409317826
Riso16257 a_58313_15032.t101 a_58313_15032.t76 25797.8447228816
Riso16258 a_58313_15032.t101 a_58313_15032.t77 21840.3123660541
Riso16259 a_58313_15032.t101 a_58313_15032.t78 18351.7284808934
Riso16260 a_58313_15032.t101 a_58313_15032.t79 15338.8484751087
Riso16261 a_58313_15032.t101 a_58313_15032.t8 59155690.9823961
Riso16262 a_58313_15032.t101 a_58313_15032.t80 15338.8484751087
Riso16263 a_58313_15032.t101 a_58313_15032.t81 18351.7284808934
Riso16264 a_58313_15032.t101 a_58313_15032.t82 21840.3123660541
Riso16265 a_58313_15032.t101 a_58313_15032.t83 25797.8447228816
Riso16266 a_58313_15032.t101 a_58313_15032.t84 30155.7409317826
Riso16267 a_58313_15032.t101 a_58313_15032.t85 34751.0335069345
Riso16268 a_58313_15032.t101 a_58313_15032.t86 39297.5749455811
Riso16269 a_58313_15032.t101 a_58313_15032.t87 43381.5926411813
Riso16270 a_58313_15032.t101 a_58313_15032.t88 46508.6143604278
Riso16271 a_58313_15032.t101 a_58313_15032.t89 48214.944969953
Riso16272 a_58313_15032.t101 a_58313_15032.t9 89874758.5294083
Riso16273 a_58313_15032.t101 a_58313_15032.t90 39323.5706455284
Riso16274 a_58313_15032.t101 a_58313_15032.t91 37931.9064569639
Riso16275 a_58313_15032.t101 a_58313_15032.t92 35381.5424658088
Riso16276 a_58313_15032.t101 a_58313_15032.t93 32050.6632442188
Riso16277 a_58313_15032.t101 a_58313_15032.t94 28342.5548233368
Riso16278 a_58313_15032.t101 a_58313_15032.t95 24594.6855199814
Riso16279 a_58313_15032.t101 a_58313_15032.t96 21040.4340416609
Riso16280 a_58313_15032.t101 a_58313_15032.t97 17812.714849766
Riso16281 a_58313_15032.t101 a_58313_15032.t98 14967.4647940735
Riso16282 a_58313_15032.t101 a_58313_15032.t99 12510.1935096657
Riso16283 a_58313_15032.t102 a_58313_15032.t103 2328.27695116229
Riso16284 a_58313_15032.t102 a_58313_15032.t104 2721.58070997368
Riso16285 a_58313_15032.t102 a_58313_15032.t105 3136.30968836324
Riso16286 a_58313_15032.t102 a_58313_15032.t106 3546.63883612016
Riso16287 a_58313_15032.t102 a_58313_15032.t107 3915.22483122737
Riso16288 a_58313_15032.t102 a_58313_15032.t108 4197.44114320665
Riso16289 a_58313_15032.t102 a_58313_15032.t109 4351.43890045715
Riso16290 a_58313_15032.t102 a_58313_15032.t11 4682839.5834848
Riso16291 a_58313_15032.t102 a_58313_15032.t12 9473148.69730973
Riso16292 a_58313_15032.t102 a_58313_15032.t13 137375.961885629
Riso16293 a_58313_15032.t102 a_58313_15032.t14 67819.4599513489
Riso16294 a_58313_15032.t102 a_58313_15032.t15 9473148.69730973
Riso16295 a_58313_15032.t102 a_58313_15032.t16 5690.46703461231
Riso16296 a_58313_15032.t102 a_58313_15032.t17 67819.4599513489
Riso16297 a_58313_15032.t102 a_58313_15032.t18 137375.961885629
Riso16298 a_58313_15032.t102 a_58313_15032.t19 1091.69676992034
Riso16299 a_58313_15032.t102 a_58313_15032.t2 19085957.3591745
Riso16300 a_58313_15032.t102 a_58313_15032.t20 1141746.1912569
Riso16301 a_58313_15032.t102 a_58313_15032.t21 2312555.32733197
Riso16302 a_58313_15032.t102 a_58313_15032.t22 1141746.1912569
Riso16303 a_58313_15032.t102 a_58313_15032.t23 2312555.32733197
Riso16304 a_58313_15032.t102 a_58313_15032.t24 4682839.5834848
Riso16305 a_58313_15032.t102 a_58313_15032.t25 1091.69676992034
Riso16306 a_58313_15032.t102 a_58313_15032.t26 37827816.1276567
Riso16307 a_58313_15032.t102 a_58313_15032.t27 563665.318415835
Riso16308 a_58313_15032.t102 a_58313_15032.t28 37827816.1276567
Riso16309 a_58313_15032.t102 a_58313_15032.t29 19085957.3591745
Riso16310 a_58313_15032.t102 a_58313_15032.t3 9126.61916849365
Riso16311 a_58313_15032.t102 a_58313_15032.t30 138679.9332371
Riso16312 a_58313_15032.t102 a_58313_15032.t31 133772.039737339
Riso16313 a_58313_15032.t102 a_58313_15032.t32 100344.75873553
Riso16314 a_58313_15032.t102 a_58313_15032.t33 77993.8604459978
Riso16315 a_58313_15032.t102 a_58313_15032.t34 61927.8462950296
Riso16316 a_58313_15032.t102 a_58313_15032.t35 49834.0706956749
Riso16317 a_58313_15032.t102 a_58313_15032.t36 40450.4457740778
Riso16318 a_58313_15032.t102 a_58313_15032.t37 33021.1091601605
Riso16319 a_58313_15032.t102 a_58313_15032.t38 27058.6037478105
Riso16320 a_58313_15032.t102 a_58313_15032.t39 22229.1699902201
Riso16321 a_58313_15032.t102 a_58313_15032.t4 106959559.812015
Riso16322 a_58313_15032.t102 a_58313_15032.t40 22085.6061529047
Riso16323 a_58313_15032.t102 a_58313_15032.t41 26423.6945890543
Riso16324 a_58313_15032.t102 a_58313_15032.t42 31446.7241759272
Riso16325 a_58313_15032.t102 a_58313_15032.t43 37144.9681550697
Riso16326 a_58313_15032.t102 a_58313_15032.t44 43419.6751176693
Riso16327 a_58313_15032.t102 a_58313_15032.t45 50036.1966992511
Riso16328 a_58313_15032.t102 a_58313_15032.t46 56582.5240676163
Riso16329 a_58313_15032.t102 a_58313_15032.t47 62462.8876746295
Riso16330 a_58313_15032.t102 a_58313_15032.t48 66965.32279777
Riso16331 a_58313_15032.t102 a_58313_15032.t49 69422.1790519909
Riso16332 a_58313_15032.t102 a_58313_15032.t5 563665.318415835
Riso16333 a_58313_15032.t102 a_58313_15032.t50 64926.665417329
Riso16334 a_58313_15032.t102 a_58313_15032.t51 62628.9057362794
Riso16335 a_58313_15032.t102 a_58313_15032.t52 58418.0310159044
Riso16336 a_58313_15032.t102 a_58313_15032.t53 52918.4571670505
Riso16337 a_58313_15032.t102 a_58313_15032.t54 46796.0448117736
Riso16338 a_58313_15032.t102 a_58313_15032.t55 40607.9837508817
Riso16339 a_58313_15032.t102 a_58313_15032.t56 34739.602707305
Riso16340 a_58313_15032.t102 a_58313_15032.t57 29410.3551188214
Riso16341 a_58313_15032.t102 a_58313_15032.t58 24712.5976323559
Riso16342 a_58313_15032.t102 a_58313_15032.t59 20655.4271388493
Riso16343 a_58313_15032.t102 a_58313_15032.t6 5690.46703461231
Riso16344 a_58313_15032.t102 a_58313_15032.t60 20655.4271388493
Riso16345 a_58313_15032.t102 a_58313_15032.t61 24712.5976323559
Riso16346 a_58313_15032.t102 a_58313_15032.t62 29410.3551188214
Riso16347 a_58313_15032.t102 a_58313_15032.t63 34739.602707305
Riso16348 a_58313_15032.t102 a_58313_15032.t64 40607.9837508817
Riso16349 a_58313_15032.t102 a_58313_15032.t65 46796.0448117736
Riso16350 a_58313_15032.t102 a_58313_15032.t66 52918.4571670505
Riso16351 a_58313_15032.t102 a_58313_15032.t67 58418.0310159044
Riso16352 a_58313_15032.t102 a_58313_15032.t68 62628.9057362794
Riso16353 a_58313_15032.t102 a_58313_15032.t69 64926.665417329
Riso16354 a_58313_15032.t102 a_58313_15032.t7 70400930.9330414
Riso16355 a_58313_15032.t102 a_58313_15032.t70 57380.3966178026
Riso16356 a_58313_15032.t102 a_58313_15032.t71 55349.6999697681
Riso16357 a_58313_15032.t102 a_58313_15032.t72 51628.2450019222
Riso16358 a_58313_15032.t102 a_58313_15032.t73 46767.8732787209
Riso16359 a_58313_15032.t102 a_58313_15032.t74 41357.0540575977
Riso16360 a_58313_15032.t102 a_58313_15032.t75 35888.2163206393
Riso16361 a_58313_15032.t102 a_58313_15032.t76 30701.9029681757
Riso16362 a_58313_15032.t102 a_58313_15032.t77 25992.0608973394
Riso16363 a_58313_15032.t102 a_58313_15032.t78 21840.3123660541
Riso16364 a_58313_15032.t102 a_58313_15032.t79 18254.6969556973
Riso16365 a_58313_15032.t102 a_58313_15032.t8 70400930.9330414
Riso16366 a_58313_15032.t102 a_58313_15032.t80 18254.6969556973
Riso16367 a_58313_15032.t102 a_58313_15032.t81 21840.3123660541
Riso16368 a_58313_15032.t102 a_58313_15032.t82 25992.0608973394
Riso16369 a_58313_15032.t102 a_58313_15032.t83 30701.9029681757
Riso16370 a_58313_15032.t102 a_58313_15032.t84 35888.2163206393
Riso16371 a_58313_15032.t102 a_58313_15032.t85 41357.0540575977
Riso16372 a_58313_15032.t102 a_58313_15032.t86 46767.8732787209
Riso16373 a_58313_15032.t102 a_58313_15032.t87 51628.2450019222
Riso16374 a_58313_15032.t102 a_58313_15032.t88 55349.6999697681
Riso16375 a_58313_15032.t102 a_58313_15032.t89 57380.3966178026
Riso16376 a_58313_15032.t102 a_58313_15032.t9 106959559.812015
Riso16377 a_58313_15032.t102 a_58313_15032.t90 46798.8106483325
Riso16378 a_58313_15032.t102 a_58313_15032.t91 45142.5971413298
Riso16379 a_58313_15032.t102 a_58313_15032.t92 42107.4200313395
Riso16380 a_58313_15032.t102 a_58313_15032.t93 38143.3551352801
Riso16381 a_58313_15032.t102 a_58313_15032.t94 33730.3514073982
Riso16382 a_58313_15032.t102 a_58313_15032.t95 29270.0284259608
Riso16383 a_58313_15032.t102 a_58313_15032.t96 25040.1291772415
Riso16384 a_58313_15032.t102 a_58313_15032.t97 21198.8345845123
Riso16385 a_58313_15032.t102 a_58313_15032.t98 17812.714849766
Riso16386 a_58313_15032.t102 a_58313_15032.t99 14888.3269657867
Riso16387 a_58313_15032.t103 a_58313_15032.t104 1951.2334314775
Riso16388 a_58313_15032.t103 a_58313_15032.t105 2248.57278454928
Riso16389 a_58313_15032.t103 a_58313_15032.t106 2542.75768528687
Riso16390 a_58313_15032.t103 a_58313_15032.t107 2807.01489191389
Riso16391 a_58313_15032.t103 a_58313_15032.t108 3009.34947667349
Riso16392 a_58313_15032.t103 a_58313_15032.t109 3119.75795040294
Riso16393 a_58313_15032.t103 a_58313_15032.t11 5531384.6437779
Riso16394 a_58313_15032.t103 a_58313_15032.t12 11189712.6302007
Riso16395 a_58313_15032.t103 a_58313_15032.t13 162268.912366396
Riso16396 a_58313_15032.t103 a_58313_15032.t14 80108.5564936305
Riso16397 a_58313_15032.t103 a_58313_15032.t15 11189712.6302007
Riso16398 a_58313_15032.t103 a_58313_15032.t16 6721.59731505375
Riso16399 a_58313_15032.t103 a_58313_15032.t17 80108.5564936305
Riso16400 a_58313_15032.t103 a_58313_15032.t18 162268.912366396
Riso16401 a_58313_15032.t103 a_58313_15032.t19 1289.51561144566
Riso16402 a_58313_15032.t103 a_58313_15032.t2 22544392.0438067
Riso16403 a_58313_15032.t103 a_58313_15032.t20 1348634.14319878
Riso16404 a_58313_15032.t103 a_58313_15032.t21 2731597.52697992
Riso16405 a_58313_15032.t103 a_58313_15032.t22 1348634.14319878
Riso16406 a_58313_15032.t103 a_58313_15032.t23 2731597.52697992
Riso16407 a_58313_15032.t103 a_58313_15032.t24 5531384.6437779
Riso16408 a_58313_15032.t103 a_58313_15032.t25 1289.51561144566
Riso16409 a_58313_15032.t103 a_58313_15032.t26 44682333.7647763
Riso16410 a_58313_15032.t103 a_58313_15032.t27 665803.222794861
Riso16411 a_58313_15032.t103 a_58313_15032.t28 44682333.7647763
Riso16412 a_58313_15032.t103 a_58313_15032.t29 22544392.0438067
Riso16413 a_58313_15032.t103 a_58313_15032.t3 10780.3908757103
Riso16414 a_58313_15032.t103 a_58313_15032.t30 163809.167372117
Riso16415 a_58313_15032.t103 a_58313_15032.t31 158011.94834424
Riso16416 a_58313_15032.t103 a_58313_15032.t32 118527.540322076
Riso16417 a_58313_15032.t103 a_58313_15032.t33 92126.5899223705
Riso16418 a_58313_15032.t103 a_58313_15032.t34 73149.364164991
Riso16419 a_58313_15032.t103 a_58313_15032.t35 58864.1589080163
Riso16420 a_58313_15032.t103 a_58313_15032.t36 47780.1920394207
Riso16421 a_58313_15032.t103 a_58313_15032.t37 39004.6365827254
Riso16422 a_58313_15032.t103 a_58313_15032.t38 31961.7066919319
Riso16423 a_58313_15032.t103 a_58313_15032.t39 26257.1645549153
Riso16424 a_58313_15032.t103 a_58313_15032.t4 126340963.874989
Riso16425 a_58313_15032.t103 a_58313_15032.t40 26087.5865048944
Riso16426 a_58313_15032.t103 a_58313_15032.t41 31211.7500239043
Riso16427 a_58313_15032.t103 a_58313_15032.t42 37144.9681550697
Riso16428 a_58313_15032.t103 a_58313_15032.t43 43875.7516211293
Riso16429 a_58313_15032.t103 a_58313_15032.t44 51287.4549516332
Riso16430 a_58313_15032.t103 a_58313_15032.t45 59102.9107705043
Riso16431 a_58313_15032.t103 a_58313_15032.t46 66835.4529669577
Riso16432 a_58313_15032.t103 a_58313_15032.t47 73781.3567024553
Riso16433 a_58313_15032.t103 a_58313_15032.t48 79099.6470379983
Riso16434 a_58313_15032.t103 a_58313_15032.t49 82001.6932674902
Riso16435 a_58313_15032.t103 a_58313_15032.t5 665803.222794861
Riso16436 a_58313_15032.t103 a_58313_15032.t50 76691.5786156109
Riso16437 a_58313_15032.t103 a_58313_15032.t51 73977.4577519208
Riso16438 a_58313_15032.t103 a_58313_15032.t52 69003.5594686443
Riso16439 a_58313_15032.t103 a_58313_15032.t53 62507.4457768241
Riso16440 a_58313_15032.t103 a_58313_15032.t54 55275.6333089596
Riso16441 a_58313_15032.t103 a_58313_15032.t55 47966.276386358
Riso16442 a_58313_15032.t103 a_58313_15032.t56 41034.5264919655
Riso16443 a_58313_15032.t103 a_58313_15032.t57 34739.602707305
Riso16444 a_58313_15032.t103 a_58313_15032.t58 29190.5969902459
Riso16445 a_58313_15032.t103 a_58313_15032.t59 24398.2546165891
Riso16446 a_58313_15032.t103 a_58313_15032.t6 6721.59731505375
Riso16447 a_58313_15032.t103 a_58313_15032.t60 24398.2546165891
Riso16448 a_58313_15032.t103 a_58313_15032.t61 29190.5969902459
Riso16449 a_58313_15032.t103 a_58313_15032.t62 34739.602707305
Riso16450 a_58313_15032.t103 a_58313_15032.t63 41034.5264919655
Riso16451 a_58313_15032.t103 a_58313_15032.t64 47966.276386358
Riso16452 a_58313_15032.t103 a_58313_15032.t65 55275.6333089596
Riso16453 a_58313_15032.t103 a_58313_15032.t66 62507.4457768241
Riso16454 a_58313_15032.t103 a_58313_15032.t67 69003.5594686443
Riso16455 a_58313_15032.t103 a_58313_15032.t68 73977.4577519208
Riso16456 a_58313_15032.t103 a_58313_15032.t69 76691.5786156109
Riso16457 a_58313_15032.t103 a_58313_15032.t7 83157798.0258092
Riso16458 a_58313_15032.t103 a_58313_15032.t70 67777.9024985106
Riso16459 a_58313_15032.t103 a_58313_15032.t71 65379.2373179385
Riso16460 a_58313_15032.t103 a_58313_15032.t72 60983.4431646963
Riso16461 a_58313_15032.t103 a_58313_15032.t73 55242.3570067201
Riso16462 a_58313_15032.t103 a_58313_15032.t74 48851.0805565226
Riso16463 a_58313_15032.t103 a_58313_15032.t75 42391.2724554272
Riso16464 a_58313_15032.t103 a_58313_15032.t76 36265.1830337843
Riso16465 a_58313_15032.t103 a_58313_15032.t77 30701.9029681757
Riso16466 a_58313_15032.t103 a_58313_15032.t78 25797.8447228816
Riso16467 a_58313_15032.t103 a_58313_15032.t79 21562.5046763661
Riso16468 a_58313_15032.t103 a_58313_15032.t8 83157798.0258092
Riso16469 a_58313_15032.t103 a_58313_15032.t80 21562.5046763661
Riso16470 a_58313_15032.t103 a_58313_15032.t81 25797.8447228816
Riso16471 a_58313_15032.t103 a_58313_15032.t82 30701.9029681757
Riso16472 a_58313_15032.t103 a_58313_15032.t83 36265.1830337843
Riso16473 a_58313_15032.t103 a_58313_15032.t84 42391.2724554272
Riso16474 a_58313_15032.t103 a_58313_15032.t85 48851.0805565226
Riso16475 a_58313_15032.t103 a_58313_15032.t86 55242.3570067201
Riso16476 a_58313_15032.t103 a_58313_15032.t87 60983.4431646963
Riso16477 a_58313_15032.t103 a_58313_15032.t88 65379.2373179385
Riso16478 a_58313_15032.t103 a_58313_15032.t89 67777.9024985106
Riso16479 a_58313_15032.t103 a_58313_15032.t9 126340963.874989
Riso16480 a_58313_15032.t103 a_58313_15032.t90 55278.9003236834
Riso16481 a_58313_15032.t103 a_58313_15032.t91 53322.5757910728
Riso16482 a_58313_15032.t103 a_58313_15032.t92 49737.4151725976
Riso16483 a_58313_15032.t103 a_58313_15032.t93 45055.0494194906
Riso16484 a_58313_15032.t103 a_58313_15032.t94 39842.3957254738
Riso16485 a_58313_15032.t103 a_58313_15032.t95 34573.8483823568
Riso16486 a_58313_15032.t103 a_58313_15032.t96 29577.4782671793
Riso16487 a_58313_15032.t103 a_58313_15032.t97 25040.1291772415
Riso16488 a_58313_15032.t103 a_58313_15032.t98 21040.4340416609
Riso16489 a_58313_15032.t103 a_58313_15032.t99 17586.1380006558
Riso16490 a_58313_15032.t104 a_58313_15032.t105 1703.79784890931
Riso16491 a_58313_15032.t104 a_58313_15032.t106 1926.70884583254
Riso16492 a_58313_15032.t104 a_58313_15032.t107 2126.94290687945
Riso16493 a_58313_15032.t104 a_58313_15032.t108 2280.25670336501
Riso16494 a_58313_15032.t104 a_58313_15032.t109 2363.91586767323
Riso16495 a_58313_15032.t104 a_58313_15032.t11 6465772.78464895
Riso16496 a_58313_15032.t104 a_58313_15032.t12 13079932.7929182
Riso16497 a_58313_15032.t104 a_58313_15032.t13 189680.158756169
Riso16498 a_58313_15032.t104 a_58313_15032.t14 93640.8797707952
Riso16499 a_58313_15032.t104 a_58313_15032.t15 13079932.7929182
Riso16500 a_58313_15032.t104 a_58313_15032.t16 7857.04191407686
Riso16501 a_58313_15032.t104 a_58313_15032.t17 93640.8797707952
Riso16502 a_58313_15032.t104 a_58313_15032.t18 189680.158756169
Riso16503 a_58313_15032.t104 a_58313_15032.t19 1507.34680063231
Riso16504 a_58313_15032.t104 a_58313_15032.t2 26352699.3530038
Riso16505 a_58313_15032.t104 a_58313_15032.t20 1576451.91956626
Riso16506 a_58313_15032.t104 a_58313_15032.t21 3193032.14041145
Riso16507 a_58313_15032.t104 a_58313_15032.t22 1576451.91956626
Riso16508 a_58313_15032.t104 a_58313_15032.t23 3193032.14041145
Riso16509 a_58313_15032.t104 a_58313_15032.t24 6465772.78464895
Riso16510 a_58313_15032.t104 a_58313_15032.t25 1507.34680063231
Riso16511 a_58313_15032.t104 a_58313_15032.t26 52230288.8366069
Riso16512 a_58313_15032.t104 a_58313_15032.t27 778273.910624001
Riso16513 a_58313_15032.t104 a_58313_15032.t28 52230288.8366069
Riso16514 a_58313_15032.t104 a_58313_15032.t29 26352699.3530038
Riso16515 a_58313_15032.t104 a_58313_15032.t3 12601.4664357962
Riso16516 a_58313_15032.t104 a_58313_15032.t30 191480.601057468
Riso16517 a_58313_15032.t104 a_58313_15032.t31 184704.087863929
Riso16518 a_58313_15032.t104 a_58313_15032.t32 138549.783426818
Riso16519 a_58313_15032.t104 a_58313_15032.t33 107689.057301887
Riso16520 a_58313_15032.t104 a_58313_15032.t34 85506.1071488495
Riso16521 a_58313_15032.t104 a_58313_15032.t35 68807.7762024436
Riso16522 a_58313_15032.t104 a_58313_15032.t36 55851.4522545996
Riso16523 a_58313_15032.t104 a_58313_15032.t37 45593.487694875
Riso16524 a_58313_15032.t104 a_58313_15032.t38 37360.8321583798
Riso16525 a_58313_15032.t104 a_58313_15032.t39 30692.6512825669
Riso16526 a_58313_15032.t104 a_58313_15032.t4 147683088.126608
Riso16527 a_58313_15032.t104 a_58313_15032.t40 30494.4272914126
Riso16528 a_58313_15032.t104 a_58313_15032.t41 36484.1891971544
Riso16529 a_58313_15032.t104 a_58313_15032.t42 43419.6751176693
Riso16530 a_58313_15032.t104 a_58313_15032.t43 51287.4549516332
Riso16531 a_58313_15032.t104 a_58313_15032.t44 59951.1789138008
Riso16532 a_58313_15032.t104 a_58313_15032.t45 69086.8591797042
Riso16533 a_58313_15032.t104 a_58313_15032.t46 78125.6196546637
Riso16534 a_58313_15032.t104 a_58313_15032.t47 86244.8589102976
Riso16535 a_58313_15032.t104 a_58313_15032.t48 92461.540469606
Riso16536 a_58313_15032.t104 a_58313_15032.t49 95853.8143284757
Riso16537 a_58313_15032.t104 a_58313_15032.t5 778273.910624001
Riso16538 a_58313_15032.t104 a_58313_15032.t50 89646.6895287012
Riso16539 a_58313_15032.t104 a_58313_15032.t51 86474.0862937344
Riso16540 a_58313_15032.t104 a_58313_15032.t52 80659.9731512326
Riso16541 a_58313_15032.t104 a_58313_15032.t53 73066.5046402687
Riso16542 a_58313_15032.t104 a_58313_15032.t54 64613.0595718624
Riso16543 a_58313_15032.t104 a_58313_15032.t55 56068.9708658626
Riso16544 a_58313_15032.t104 a_58313_15032.t56 47966.276386358
Riso16545 a_58313_15032.t104 a_58313_15032.t57 40607.9837508817
Riso16546 a_58313_15032.t104 a_58313_15032.t58 34121.6132563652
Riso16547 a_58313_15032.t104 a_58313_15032.t59 28519.7253223621
Riso16548 a_58313_15032.t104 a_58313_15032.t6 7857.04191407686
Riso16549 a_58313_15032.t104 a_58313_15032.t60 28519.7253223621
Riso16550 a_58313_15032.t104 a_58313_15032.t61 34121.6132563652
Riso16551 a_58313_15032.t104 a_58313_15032.t62 40607.9837508817
Riso16552 a_58313_15032.t104 a_58313_15032.t63 47966.276386358
Riso16553 a_58313_15032.t104 a_58313_15032.t64 56068.9708658626
Riso16554 a_58313_15032.t104 a_58313_15032.t65 64613.0595718624
Riso16555 a_58313_15032.t104 a_58313_15032.t66 73066.5046402687
Riso16556 a_58313_15032.t104 a_58313_15032.t67 80659.9731512326
Riso16557 a_58313_15032.t104 a_58313_15032.t68 86474.0862937344
Riso16558 a_58313_15032.t104 a_58313_15032.t69 89646.6895287012
Riso16559 a_58313_15032.t104 a_58313_15032.t7 97205213.8719787
Riso16560 a_58313_15032.t104 a_58313_15032.t70 79227.2723012347
Riso16561 a_58313_15032.t104 a_58313_15032.t71 76423.4130430517
Riso16562 a_58313_15032.t104 a_58313_15032.t72 71285.0601651834
Riso16563 a_58313_15032.t104 a_58313_15032.t73 64574.1620763435
Riso16564 a_58313_15032.t104 a_58313_15032.t74 57103.2404188992
Riso16565 a_58313_15032.t104 a_58313_15032.t75 49552.2104139438
Riso16566 a_58313_15032.t104 a_58313_15032.t76 42391.2724554272
Riso16567 a_58313_15032.t104 a_58313_15032.t77 35888.2163206393
Riso16568 a_58313_15032.t104 a_58313_15032.t78 30155.7409317826
Riso16569 a_58313_15032.t104 a_58313_15032.t79 25204.9468413196
Riso16570 a_58313_15032.t104 a_58313_15032.t8 97205213.8719787
Riso16571 a_58313_15032.t104 a_58313_15032.t80 25204.9468413196
Riso16572 a_58313_15032.t104 a_58313_15032.t81 30155.7409317826
Riso16573 a_58313_15032.t104 a_58313_15032.t82 35888.2163206393
Riso16574 a_58313_15032.t104 a_58313_15032.t83 42391.2724554272
Riso16575 a_58313_15032.t104 a_58313_15032.t84 49552.2104139438
Riso16576 a_58313_15032.t104 a_58313_15032.t85 57103.2404188992
Riso16577 a_58313_15032.t104 a_58313_15032.t86 64574.1620763435
Riso16578 a_58313_15032.t104 a_58313_15032.t87 71285.0601651834
Riso16579 a_58313_15032.t104 a_58313_15032.t88 76423.4130430517
Riso16580 a_58313_15032.t104 a_58313_15032.t89 79227.2723012347
Riso16581 a_58313_15032.t104 a_58313_15032.t9 147683088.126608
Riso16582 a_58313_15032.t104 a_58313_15032.t90 64616.8784664517
Riso16583 a_58313_15032.t104 a_58313_15032.t91 62330.0821694119
Riso16584 a_58313_15032.t104 a_58313_15032.t92 58139.2989481424
Riso16585 a_58313_15032.t104 a_58313_15032.t93 52665.9654152327
Riso16586 a_58313_15032.t104 a_58313_15032.t94 46572.7651478301
Riso16587 a_58313_15032.t104 a_58313_15032.t95 40414.2294068599
Riso16588 a_58313_15032.t104 a_58313_15032.t96 34573.8483823568
Riso16589 a_58313_15032.t104 a_58313_15032.t97 29270.0284259608
Riso16590 a_58313_15032.t104 a_58313_15032.t98 24594.6855199814
Riso16591 a_58313_15032.t104 a_58313_15032.t99 20556.8731510342
Riso16592 a_58313_15032.t105 a_58313_15032.t106 1506.45823511695
Riso16593 a_58313_15032.t105 a_58313_15032.t107 1663.01756730017
Riso16594 a_58313_15032.t105 a_58313_15032.t108 1782.89080698154
Riso16595 a_58313_15032.t105 a_58313_15032.t109 1848.3023699625
Riso16596 a_58313_15032.t105 a_58313_15032.t11 7451061.71311963
Riso16597 a_58313_15032.t105 a_58313_15032.t12 15073122.6861047
Riso16598 a_58313_15032.t105 a_58313_15032.t13 218584.632606028
Riso16599 a_58313_15032.t105 a_58313_15032.t14 107910.376266167
Riso16600 a_58313_15032.t105 a_58313_15032.t15 15073122.6861047
Riso16601 a_58313_15032.t105 a_58313_15032.t16 9054.33984988583
Riso16602 a_58313_15032.t105 a_58313_15032.t17 107910.376266167
Riso16603 a_58313_15032.t105 a_58313_15032.t18 218584.632606028
Riso16604 a_58313_15032.t105 a_58313_15032.t19 1737.04434236387
Riso16605 a_58313_15032.t105 a_58313_15032.t2 30368464.1768896
Riso16606 a_58313_15032.t105 a_58313_15032.t20 1816680.06774721
Riso16607 a_58313_15032.t105 a_58313_15032.t21 3679603.40126179
Riso16608 a_58313_15032.t105 a_58313_15032.t22 1816680.06774721
Riso16609 a_58313_15032.t105 a_58313_15032.t23 3679603.40126179
Riso16610 a_58313_15032.t105 a_58313_15032.t24 7451061.71311963
Riso16611 a_58313_15032.t105 a_58313_15032.t25 1737.04434236387
Riso16612 a_58313_15032.t105 a_58313_15032.t26 60189418.7094839
Riso16613 a_58313_15032.t105 a_58313_15032.t27 896871.438405368
Riso16614 a_58313_15032.t105 a_58313_15032.t28 60189418.7094839
Riso16615 a_58313_15032.t105 a_58313_15032.t29 30368464.1768896
Riso16616 a_58313_15032.t105 a_58313_15032.t3 14521.7450745945
Riso16617 a_58313_15032.t105 a_58313_15032.t30 220659.435904057
Riso16618 a_58313_15032.t105 a_58313_15032.t31 212850.281501863
Riso16619 a_58313_15032.t105 a_58313_15032.t32 159662.738088103
Riso16620 a_58313_15032.t105 a_58313_15032.t33 124099.289985738
Riso16621 a_58313_15032.t105 a_58313_15032.t34 98535.9836224573
Riso16622 a_58313_15032.t105 a_58313_15032.t35 79293.0719811505
Riso16623 a_58313_15032.t105 a_58313_15032.t36 64362.394314939
Riso16624 a_58313_15032.t105 a_58313_15032.t37 52541.2664264106
Riso16625 a_58313_15032.t105 a_58313_15032.t38 43054.0749477801
Riso16626 a_58313_15032.t105 a_58313_15032.t39 35369.7611194489
Riso16627 a_58313_15032.t105 a_58313_15032.t4 170187824.45124
Riso16628 a_58313_15032.t105 a_58313_15032.t40 35141.3306997133
Riso16629 a_58313_15032.t105 a_58313_15032.t41 42043.844458399
Riso16630 a_58313_15032.t105 a_58313_15032.t42 50036.1966992512
Riso16631 a_58313_15032.t105 a_58313_15032.t43 59102.9107705044
Riso16632 a_58313_15032.t105 a_58313_15032.t44 69086.8591797043
Riso16633 a_58313_15032.t105 a_58313_15032.t45 79614.6831103857
Riso16634 a_58313_15032.t105 a_58313_15032.t46 90030.8180956621
Riso16635 a_58313_15032.t105 a_58313_15032.t47 99387.3103158873
Riso16636 a_58313_15032.t105 a_58313_15032.t48 106551.322954747
Riso16637 a_58313_15032.t105 a_58313_15032.t49 110460.529589761
Riso16638 a_58313_15032.t105 a_58313_15032.t5 896871.438405368
Riso16639 a_58313_15032.t105 a_58313_15032.t50 103307.530020403
Riso16640 a_58313_15032.t105 a_58313_15032.t51 99651.4685901123
Riso16641 a_58313_15032.t105 a_58313_15032.t52 92951.3698896609
Riso16642 a_58313_15032.t105 a_58313_15032.t53 84200.7681632666
Riso16643 a_58313_15032.t105 a_58313_15032.t54 74459.1420667377
Riso16644 a_58313_15032.t105 a_58313_15032.t55 64613.0595718625
Riso16645 a_58313_15032.t105 a_58313_15032.t56 55275.6333089597
Riso16646 a_58313_15032.t105 a_58313_15032.t57 46796.0448117737
Riso16647 a_58313_15032.t105 a_58313_15032.t58 39321.2465999426
Riso16648 a_58313_15032.t105 a_58313_15032.t59 32865.7131167157
Riso16649 a_58313_15032.t105 a_58313_15032.t6 9054.33984988583
Riso16650 a_58313_15032.t105 a_58313_15032.t60 32865.7131167157
Riso16651 a_58313_15032.t105 a_58313_15032.t61 39321.2465999426
Riso16652 a_58313_15032.t105 a_58313_15032.t62 46796.0448117737
Riso16653 a_58313_15032.t105 a_58313_15032.t63 55275.6333089597
Riso16654 a_58313_15032.t105 a_58313_15032.t64 64613.0595718625
Riso16655 a_58313_15032.t105 a_58313_15032.t65 74459.1420667377
Riso16656 a_58313_15032.t105 a_58313_15032.t66 84200.7681632666
Riso16657 a_58313_15032.t105 a_58313_15032.t67 92951.3698896609
Riso16658 a_58313_15032.t105 a_58313_15032.t68 99651.4685901123
Riso16659 a_58313_15032.t105 a_58313_15032.t69 103307.530020403
Riso16660 a_58313_15032.t105 a_58313_15032.t7 112017862.600538
Riso16661 a_58313_15032.t105 a_58313_15032.t70 91300.3464458556
Riso16662 a_58313_15032.t105 a_58313_15032.t71 88069.2201654481
Riso16663 a_58313_15032.t105 a_58313_15032.t72 82147.8576814954
Riso16664 a_58313_15032.t105 a_58313_15032.t73 74414.317163474
Riso16665 a_58313_15032.t105 a_58313_15032.t74 65804.9366334834
Riso16666 a_58313_15032.t105 a_58313_15032.t75 57103.2404188992
Riso16667 a_58313_15032.t105 a_58313_15032.t76 48851.0805565226
Riso16668 a_58313_15032.t105 a_58313_15032.t77 41357.0540575977
Riso16669 a_58313_15032.t105 a_58313_15032.t78 34751.0335069345
Riso16670 a_58313_15032.t105 a_58313_15032.t79 29045.8110183605
Riso16671 a_58313_15032.t105 a_58313_15032.t8 112017862.600538
Riso16672 a_58313_15032.t105 a_58313_15032.t80 29045.8110183605
Riso16673 a_58313_15032.t105 a_58313_15032.t81 34751.0335069345
Riso16674 a_58313_15032.t105 a_58313_15032.t82 41357.0540575977
Riso16675 a_58313_15032.t105 a_58313_15032.t83 48851.0805565226
Riso16676 a_58313_15032.t105 a_58313_15032.t84 57103.2404188992
Riso16677 a_58313_15032.t105 a_58313_15032.t85 65804.9366334834
Riso16678 a_58313_15032.t105 a_58313_15032.t86 74414.317163474
Riso16679 a_58313_15032.t105 a_58313_15032.t87 82147.8576814954
Riso16680 a_58313_15032.t105 a_58313_15032.t88 88069.2201654481
Riso16681 a_58313_15032.t105 a_58313_15032.t89 91300.3464458556
Riso16682 a_58313_15032.t105 a_58313_15032.t9 170187824.45124
Riso16683 a_58313_15032.t105 a_58313_15032.t90 74463.5429048446
Riso16684 a_58313_15032.t105 a_58313_15032.t91 71828.2723962625
Riso16685 a_58313_15032.t105 a_58313_15032.t92 66998.875285043
Riso16686 a_58313_15032.t105 a_58313_15032.t93 60691.4860079218
Riso16687 a_58313_15032.t105 a_58313_15032.t94 53669.7713985554
Riso16688 a_58313_15032.t105 a_58313_15032.t95 46572.7651478301
Riso16689 a_58313_15032.t105 a_58313_15032.t96 39842.3957254738
Riso16690 a_58313_15032.t105 a_58313_15032.t97 33730.3514073982
Riso16691 a_58313_15032.t105 a_58313_15032.t98 28342.5548233368
Riso16692 a_58313_15032.t105 a_58313_15032.t99 23689.4390784634
Riso16693 a_58313_15032.t106 a_58313_15032.t107 1325.31583504357
Riso16694 a_58313_15032.t106 a_58313_15032.t108 1420.84693818497
Riso16695 a_58313_15032.t106 a_58313_15032.t109 1472.97566004467
Riso16696 a_58313_15032.t106 a_58313_15032.t11 8425897.7804801
Riso16697 a_58313_15032.t106 a_58313_15032.t12 17045166.9675648
Riso16698 a_58313_15032.t106 a_58313_15032.t13 247182.460920871
Riso16699 a_58313_15032.t106 a_58313_15032.t14 122028.488674426
Riso16700 a_58313_15032.t106 a_58313_15032.t15 17045166.9675648
Riso16701 a_58313_15032.t106 a_58313_15032.t16 10238.9357359011
Riso16702 a_58313_15032.t106 a_58313_15032.t17 122028.488674426
Riso16703 a_58313_15032.t106 a_58313_15032.t18 247182.460920871
Riso16704 a_58313_15032.t106 a_58313_15032.t19 1964.30503899174
Riso16705 a_58313_15032.t106 a_58313_15032.t2 34341626.0335214
Riso16706 a_58313_15032.t106 a_58313_15032.t20 2054359.6523595
Riso16707 a_58313_15032.t106 a_58313_15032.t21 4161012.66174562
Riso16708 a_58313_15032.t106 a_58313_15032.t22 2054359.6523595
Riso16709 a_58313_15032.t106 a_58313_15032.t23 4161012.66174562
Riso16710 a_58313_15032.t106 a_58313_15032.t24 8425897.7804801
Riso16711 a_58313_15032.t106 a_58313_15032.t25 1964.30503899174
Riso16712 a_58313_15032.t106 a_58313_15032.t26 68064110.731985
Riso16713 a_58313_15032.t106 a_58313_15032.t27 1014210.77333579
Riso16714 a_58313_15032.t106 a_58313_15032.t28 68064110.731985
Riso16715 a_58313_15032.t106 a_58313_15032.t29 34341626.0335214
Riso16716 a_58313_15032.t106 a_58313_15032.t3 16421.6516120486
Riso16717 a_58313_15032.t106 a_58313_15032.t30 249528.714539064
Riso16718 a_58313_15032.t106 a_58313_15032.t31 240697.874146344
Riso16719 a_58313_15032.t106 a_58313_15032.t32 180551.706894756
Riso16720 a_58313_15032.t106 a_58313_15032.t33 140335.427662454
Riso16721 a_58313_15032.t106 a_58313_15032.t34 111427.627050786
Riso16722 a_58313_15032.t106 a_58313_15032.t35 89667.1299926323
Riso16723 a_58313_15032.t106 a_58313_15032.t36 72783.0443881229
Riso16724 a_58313_15032.t106 a_58313_15032.t37 59415.3366608679
Riso16725 a_58313_15032.t106 a_58313_15032.t38 48686.918523889
Riso16726 a_58313_15032.t106 a_58313_15032.t39 39997.2518262365
Riso16727 a_58313_15032.t106 a_58313_15032.t4 192453809.60723
Riso16728 a_58313_15032.t106 a_58313_15032.t40 39738.9354358012
Riso16729 a_58313_15032.t106 a_58313_15032.t41 47544.5177270654
Riso16730 a_58313_15032.t106 a_58313_15032.t42 56582.5240676163
Riso16731 a_58313_15032.t106 a_58313_15032.t43 66835.4529669577
Riso16732 a_58313_15032.t106 a_58313_15032.t44 78125.6196546638
Riso16733 a_58313_15032.t106 a_58313_15032.t45 90030.818095662
Riso16734 a_58313_15032.t106 a_58313_15032.t46 101809.715121718
Riso16735 a_58313_15032.t106 a_58313_15032.t47 112390.334376643
Riso16736 a_58313_15032.t106 a_58313_15032.t48 120491.6279261
Riso16737 a_58313_15032.t106 a_58313_15032.t49 124912.283233706
Riso16738 a_58313_15032.t106 a_58313_15032.t5 1014210.77333579
Riso16739 a_58313_15032.t106 a_58313_15032.t50 116823.44361383
Riso16740 a_58313_15032.t106 a_58313_15032.t51 112689.052962287
Riso16741 a_58313_15032.t106 a_58313_15032.t52 105112.368062506
Riso16742 a_58313_15032.t106 a_58313_15032.t53 95216.9090657747
Riso16743 a_58313_15032.t106 a_58313_15032.t54 84200.7681632665
Riso16744 a_58313_15032.t106 a_58313_15032.t55 73066.5046402687
Riso16745 a_58313_15032.t106 a_58313_15032.t56 62507.4457768241
Riso16746 a_58313_15032.t106 a_58313_15032.t57 52918.4571670505
Riso16747 a_58313_15032.t106 a_58313_15032.t58 44465.7173982055
Riso16748 a_58313_15032.t106 a_58313_15032.t59 37165.5946314915
Riso16749 a_58313_15032.t106 a_58313_15032.t6 10238.9357359011
Riso16750 a_58313_15032.t106 a_58313_15032.t60 37165.5946314915
Riso16751 a_58313_15032.t106 a_58313_15032.t61 44465.7173982055
Riso16752 a_58313_15032.t106 a_58313_15032.t62 52918.4571670505
Riso16753 a_58313_15032.t106 a_58313_15032.t63 62507.4457768241
Riso16754 a_58313_15032.t106 a_58313_15032.t64 73066.5046402687
Riso16755 a_58313_15032.t106 a_58313_15032.t65 84200.7681632665
Riso16756 a_58313_15032.t106 a_58313_15032.t66 95216.9090657747
Riso16757 a_58313_15032.t106 a_58313_15032.t67 105112.368062506
Riso16758 a_58313_15032.t106 a_58313_15032.t68 112689.052962287
Riso16759 a_58313_15032.t106 a_58313_15032.t69 116823.44361383
Riso16760 a_58313_15032.t106 a_58313_15032.t7 126673364.978054
Riso16761 a_58313_15032.t106 a_58313_15032.t70 103245.338193973
Riso16762 a_58313_15032.t106 a_58313_15032.t71 99591.4777372008
Riso16763 a_58313_15032.t106 a_58313_15032.t72 92895.4125411353
Riso16764 a_58313_15032.t106 a_58313_15032.t73 84150.0787357109
Riso16765 a_58313_15032.t106 a_58313_15032.t74 74414.317163474
Riso16766 a_58313_15032.t106 a_58313_15032.t75 64574.1620763435
Riso16767 a_58313_15032.t106 a_58313_15032.t76 55242.3570067201
Riso16768 a_58313_15032.t106 a_58313_15032.t77 46767.8732787209
Riso16769 a_58313_15032.t106 a_58313_15032.t78 39297.5749455811
Riso16770 a_58313_15032.t106 a_58313_15032.t79 32845.9277368381
Riso16771 a_58313_15032.t106 a_58313_15032.t8 126673364.978054
Riso16772 a_58313_15032.t106 a_58313_15032.t80 32845.9277368381
Riso16773 a_58313_15032.t106 a_58313_15032.t81 39297.5749455811
Riso16774 a_58313_15032.t106 a_58313_15032.t82 46767.8732787209
Riso16775 a_58313_15032.t106 a_58313_15032.t83 55242.3570067201
Riso16776 a_58313_15032.t106 a_58313_15032.t84 64574.1620763435
Riso16777 a_58313_15032.t106 a_58313_15032.t85 74414.317163474
Riso16778 a_58313_15032.t106 a_58313_15032.t86 84150.0787357109
Riso16779 a_58313_15032.t106 a_58313_15032.t87 92895.4125411353
Riso16780 a_58313_15032.t106 a_58313_15032.t88 99591.4777372008
Riso16781 a_58313_15032.t106 a_58313_15032.t89 103245.338193973
Riso16782 a_58313_15032.t106 a_58313_15032.t9 192453809.60723
Riso16783 a_58313_15032.t106 a_58313_15032.t90 84205.7447710931
Riso16784 a_58313_15032.t106 a_58313_15032.t91 81225.6969894286
Riso16785 a_58313_15032.t106 a_58313_15032.t92 75764.4609982099
Riso16786 a_58313_15032.t106 a_58313_15032.t93 68631.8644157466
Riso16787 a_58313_15032.t106 a_58313_15032.t94 60691.4860079218
Riso16788 a_58313_15032.t106 a_58313_15032.t95 52665.9654152327
Riso16789 a_58313_15032.t106 a_58313_15032.t96 45055.0494194906
Riso16790 a_58313_15032.t106 a_58313_15032.t97 38143.3551352801
Riso16791 a_58313_15032.t106 a_58313_15032.t98 32050.6632442188
Riso16792 a_58313_15032.t106 a_58313_15032.t99 26788.7718337622
Riso16793 a_58313_15032.t107 a_58313_15032.t108 1146.07004535564
Riso16794 a_58313_15032.t107 a_58313_15032.t109 1188.11761925013
Riso16795 a_58313_15032.t107 a_58313_15032.t11 9301562.89936982
Riso16796 a_58313_15032.t107 a_58313_15032.t12 18816593.413507
Riso16797 a_58313_15032.t107 a_58313_15032.t13 272871.00648229
Riso16798 a_58313_15032.t107 a_58313_15032.t14 134710.352830264
Riso16799 a_58313_15032.t107 a_58313_15032.t15 18816593.413507
Riso16800 a_58313_15032.t107 a_58313_15032.t16 11303.0216187435
Riso16801 a_58313_15032.t107 a_58313_15032.t17 134710.352830264
Riso16802 a_58313_15032.t107 a_58313_15032.t18 272871.00648229
Riso16803 a_58313_15032.t107 a_58313_15032.t19 2168.4463008866
Riso16804 a_58313_15032.t107 a_58313_15032.t2 37910594.5668421
Riso16805 a_58313_15032.t107 a_58313_15032.t20 2267859.87940867
Riso16806 a_58313_15032.t107 a_58313_15032.t21 4593447.72588681
Riso16807 a_58313_15032.t107 a_58313_15032.t22 2267859.87940867
Riso16808 a_58313_15032.t107 a_58313_15032.t23 4593447.72588681
Riso16809 a_58313_15032.t107 a_58313_15032.t24 9301562.89936982
Riso16810 a_58313_15032.t107 a_58313_15032.t25 2168.4463008866
Riso16811 a_58313_15032.t107 a_58313_15032.t26 75137703.2640854
Riso16812 a_58313_15032.t107 a_58313_15032.t27 1119613.0723608
Riso16813 a_58313_15032.t107 a_58313_15032.t28 75137703.2640854
Riso16814 a_58313_15032.t107 a_58313_15032.t29 37910594.5668421
Riso16815 a_58313_15032.t107 a_58313_15032.t3 18128.2789514572
Riso16816 a_58313_15032.t107 a_58313_15032.t30 275461.095535834
Riso16817 a_58313_15032.t107 a_58313_15032.t31 265712.506185808
Riso16818 a_58313_15032.t107 a_58313_15032.t32 199315.6221478
Riso16819 a_58313_15032.t107 a_58313_15032.t33 154919.848474342
Riso16820 a_58313_15032.t107 a_58313_15032.t34 123007.79201731
Riso16821 a_58313_15032.t107 a_58313_15032.t35 98985.8257673896
Riso16822 a_58313_15032.t107 a_58313_15032.t36 80347.0541681761
Riso16823 a_58313_15032.t107 a_58313_15032.t37 65590.1015579144
Riso16824 a_58313_15032.t107 a_58313_15032.t38 53746.7278650801
Riso16825 a_58313_15032.t107 a_58313_15032.t39 44153.9837482428
Riso16826 a_58313_15032.t107 a_58313_15032.t4 212454656.099921
Riso16827 a_58313_15032.t107 a_58313_15032.t40 43868.8217137426
Riso16828 a_58313_15032.t107 a_58313_15032.t41 52485.6025648702
Riso16829 a_58313_15032.t107 a_58313_15032.t42 62462.8876746294
Riso16830 a_58313_15032.t107 a_58313_15032.t43 73781.3567024553
Riso16831 a_58313_15032.t107 a_58313_15032.t44 86244.8589102976
Riso16832 a_58313_15032.t107 a_58313_15032.t45 99387.3103158872
Riso16833 a_58313_15032.t107 a_58313_15032.t46 112390.334376643
Riso16834 a_58313_15032.t107 a_58313_15032.t47 124070.549123845
Riso16835 a_58313_15032.t107 a_58313_15032.t48 133013.773155247
Riso16836 a_58313_15032.t107 a_58313_15032.t49 137893.847002736
Riso16837 a_58313_15032.t107 a_58313_15032.t5 1119613.0723608
Riso16838 a_58313_15032.t107 a_58313_15032.t50 128964.371181002
Riso16839 a_58313_15032.t107 a_58313_15032.t51 124400.312169395
Riso16840 a_58313_15032.t107 a_58313_15032.t52 116036.216971457
Riso16841 a_58313_15032.t107 a_58313_15032.t53 105112.368062506
Riso16842 a_58313_15032.t107 a_58313_15032.t54 92951.3698896608
Riso16843 a_58313_15032.t107 a_58313_15032.t55 80659.9731512325
Riso16844 a_58313_15032.t107 a_58313_15032.t56 69003.5594686442
Riso16845 a_58313_15032.t107 a_58313_15032.t57 58418.0310159044
Riso16846 a_58313_15032.t107 a_58313_15032.t58 49086.8365627672
Riso16847 a_58313_15032.t107 a_58313_15032.t59 41028.0453387604
Riso16848 a_58313_15032.t107 a_58313_15032.t6 11303.0216187435
Riso16849 a_58313_15032.t107 a_58313_15032.t60 41028.0453387604
Riso16850 a_58313_15032.t107 a_58313_15032.t61 49086.8365627672
Riso16851 a_58313_15032.t107 a_58313_15032.t62 58418.0310159044
Riso16852 a_58313_15032.t107 a_58313_15032.t63 69003.5594686442
Riso16853 a_58313_15032.t107 a_58313_15032.t64 80659.9731512325
Riso16854 a_58313_15032.t107 a_58313_15032.t65 92951.3698896608
Riso16855 a_58313_15032.t107 a_58313_15032.t66 105112.368062506
Riso16856 a_58313_15032.t107 a_58313_15032.t67 116036.216971457
Riso16857 a_58313_15032.t107 a_58313_15032.t68 124400.312169395
Riso16858 a_58313_15032.t107 a_58313_15032.t69 128964.371181002
Riso16859 a_58313_15032.t107 a_58313_15032.t7 139837949.939034
Riso16860 a_58313_15032.t107 a_58313_15032.t70 113975.155205743
Riso16861 a_58313_15032.t107 a_58313_15032.t71 109941.565699955
Riso16862 a_58313_15032.t107 a_58313_15032.t72 102549.608994312
Riso16863 a_58313_15032.t107 a_58313_15032.t73 92895.4125411353
Riso16864 a_58313_15032.t107 a_58313_15032.t74 82147.8576814954
Riso16865 a_58313_15032.t107 a_58313_15032.t75 71285.0601651834
Riso16866 a_58313_15032.t107 a_58313_15032.t76 60983.4431646963
Riso16867 a_58313_15032.t107 a_58313_15032.t77 51628.2450019222
Riso16868 a_58313_15032.t107 a_58313_15032.t78 43381.5926411813
Riso16869 a_58313_15032.t107 a_58313_15032.t79 36259.455169292
Riso16870 a_58313_15032.t107 a_58313_15032.t8 139837949.939034
Riso16871 a_58313_15032.t107 a_58313_15032.t80 36259.455169292
Riso16872 a_58313_15032.t107 a_58313_15032.t81 43381.5926411813
Riso16873 a_58313_15032.t107 a_58313_15032.t82 51628.2450019222
Riso16874 a_58313_15032.t107 a_58313_15032.t83 60983.4431646963
Riso16875 a_58313_15032.t107 a_58313_15032.t84 71285.0601651834
Riso16876 a_58313_15032.t107 a_58313_15032.t85 82147.8576814954
Riso16877 a_58313_15032.t107 a_58313_15032.t86 92895.4125411353
Riso16878 a_58313_15032.t107 a_58313_15032.t87 102549.608994312
Riso16879 a_58313_15032.t107 a_58313_15032.t88 109941.565699955
Riso16880 a_58313_15032.t107 a_58313_15032.t89 113975.155205743
Riso16881 a_58313_15032.t107 a_58313_15032.t9 212454656.099921
Riso16882 a_58313_15032.t107 a_58313_15032.t90 92956.8636936363
Riso16883 a_58313_15032.t107 a_58313_15032.t91 89667.1131404675
Riso16884 a_58313_15032.t107 a_58313_15032.t92 83638.3158058611
Riso16885 a_58313_15032.t107 a_58313_15032.t93 75764.4609982099
Riso16886 a_58313_15032.t107 a_58313_15032.t94 66998.875285043
Riso16887 a_58313_15032.t107 a_58313_15032.t95 58139.2989481424
Riso16888 a_58313_15032.t107 a_58313_15032.t96 49737.4151725976
Riso16889 a_58313_15032.t107 a_58313_15032.t97 42107.4200313395
Riso16890 a_58313_15032.t107 a_58313_15032.t98 35381.5424658088
Riso16891 a_58313_15032.t107 a_58313_15032.t99 29572.8066848691
Riso16892 a_58313_15032.t108 a_58313_15032.t109 965.886756736616
Riso16893 a_58313_15032.t108 a_58313_15032.t11 9972035.96037162
Riso16894 a_58313_15032.t108 a_58313_15032.t12 20172926.6577229
Riso16895 a_58313_15032.t108 a_58313_15032.t13 292540.029952231
Riso16896 a_58313_15032.t108 a_58313_15032.t14 144420.51268059
Riso16897 a_58313_15032.t108 a_58313_15032.t15 20172926.6577229
Riso16898 a_58313_15032.t108 a_58313_15032.t16 12117.7633546515
Riso16899 a_58313_15032.t108 a_58313_15032.t17 144420.51268059
Riso16900 a_58313_15032.t108 a_58313_15032.t18 292540.029952231
Riso16901 a_58313_15032.t108 a_58313_15032.t19 2324.75173522087
Riso16902 a_58313_15032.t108 a_58313_15032.t2 40643257.0944858
Riso16903 a_58313_15032.t108 a_58313_15032.t20 2431331.21984043
Riso16904 a_58313_15032.t108 a_58313_15032.t21 4924551.54044424
Riso16905 a_58313_15032.t108 a_58313_15032.t22 2431331.21984043
Riso16906 a_58313_15032.t108 a_58313_15032.t23 4924551.54044424
Riso16907 a_58313_15032.t108 a_58313_15032.t24 9972035.96037162
Riso16908 a_58313_15032.t108 a_58313_15032.t25 2324.75173522087
Riso16909 a_58313_15032.t108 a_58313_15032.t26 80553761.4522779
Riso16910 a_58313_15032.t108 a_58313_15032.t27 1200316.75752475
Riso16911 a_58313_15032.t108 a_58313_15032.t28 80553761.4522779
Riso16912 a_58313_15032.t108 a_58313_15032.t29 40643257.0944858
Riso16913 a_58313_15032.t108 a_58313_15032.t3 19434.9972751168
Riso16914 a_58313_15032.t108 a_58313_15032.t30 295316.817193464
Riso16915 a_58313_15032.t108 a_58313_15032.t31 284865.532327355
Riso16916 a_58313_15032.t108 a_58313_15032.t32 213682.643769077
Riso16917 a_58313_15032.t108 a_58313_15032.t33 166086.744418633
Riso16918 a_58313_15032.t108 a_58313_15032.t34 131874.410641854
Riso16919 a_58313_15032.t108 a_58313_15032.t35 106120.898691807
Riso16920 a_58313_15032.t108 a_58313_15032.t36 86138.611558415
Riso16921 a_58313_15032.t108 a_58313_15032.t37 70317.951773918
Riso16922 a_58313_15032.t108 a_58313_15032.t38 57620.8868145373
Riso16923 a_58313_15032.t108 a_58313_15032.t39 47336.6807809226
Riso16924 a_58313_15032.t108 a_58313_15032.t4 227768762.464676
Riso16925 a_58313_15032.t108 a_58313_15032.t40 47030.9637639726
Riso16926 a_58313_15032.t108 a_58313_15032.t41 56268.857378164
Riso16927 a_58313_15032.t108 a_58313_15032.t42 66965.3227977699
Riso16928 a_58313_15032.t108 a_58313_15032.t43 79099.6470379983
Riso16929 a_58313_15032.t108 a_58313_15032.t44 92461.540469606
Riso16930 a_58313_15032.t108 a_58313_15032.t45 106551.322954746
Riso16931 a_58313_15032.t108 a_58313_15032.t46 120491.6279261
Riso16932 a_58313_15032.t108 a_58313_15032.t47 133013.773155247
Riso16933 a_58313_15032.t108 a_58313_15032.t48 142601.640549967
Riso16934 a_58313_15032.t108 a_58313_15032.t49 147833.478728443
Riso16935 a_58313_15032.t108 a_58313_15032.t5 1200316.75752475
Riso16936 a_58313_15032.t108 a_58313_15032.t50 138260.350538597
Riso16937 a_58313_15032.t108 a_58313_15032.t51 133367.306102796
Riso16938 a_58313_15032.t108 a_58313_15032.t52 124400.312169395
Riso16939 a_58313_15032.t108 a_58313_15032.t53 112689.052962287
Riso16940 a_58313_15032.t108 a_58313_15032.t54 99651.4685901123
Riso16941 a_58313_15032.t108 a_58313_15032.t55 86474.0862937344
Riso16942 a_58313_15032.t108 a_58313_15032.t56 73977.4577519209
Riso16943 a_58313_15032.t108 a_58313_15032.t57 62628.9057362794
Riso16944 a_58313_15032.t108 a_58313_15032.t58 52625.1023274772
Riso16945 a_58313_15032.t108 a_58313_15032.t59 43985.4192169787
Riso16946 a_58313_15032.t108 a_58313_15032.t6 12117.7633546515
Riso16947 a_58313_15032.t108 a_58313_15032.t60 43985.4192169787
Riso16948 a_58313_15032.t108 a_58313_15032.t61 52625.1023274772
Riso16949 a_58313_15032.t108 a_58313_15032.t62 62628.9057362794
Riso16950 a_58313_15032.t108 a_58313_15032.t63 73977.4577519209
Riso16951 a_58313_15032.t108 a_58313_15032.t64 86474.0862937344
Riso16952 a_58313_15032.t108 a_58313_15032.t65 99651.4685901123
Riso16953 a_58313_15032.t108 a_58313_15032.t66 112689.052962287
Riso16954 a_58313_15032.t108 a_58313_15032.t67 124400.312169395
Riso16955 a_58313_15032.t108 a_58313_15032.t68 133367.306102796
Riso16956 a_58313_15032.t108 a_58313_15032.t69 138260.350538597
Riso16957 a_58313_15032.t108 a_58313_15032.t7 149917716.033633
Riso16958 a_58313_15032.t108 a_58313_15032.t70 122190.685436058
Riso16959 a_58313_15032.t108 a_58313_15032.t71 117866.347683763
Riso16960 a_58313_15032.t108 a_58313_15032.t72 109941.565699955
Riso16961 a_58313_15032.t108 a_58313_15032.t73 99591.4777372008
Riso16962 a_58313_15032.t108 a_58313_15032.t74 88069.2201654481
Riso16963 a_58313_15032.t108 a_58313_15032.t75 76423.4130430518
Riso16964 a_58313_15032.t108 a_58313_15032.t76 65379.2373179385
Riso16965 a_58313_15032.t108 a_58313_15032.t77 55349.6999697681
Riso16966 a_58313_15032.t108 a_58313_15032.t78 46508.6143604278
Riso16967 a_58313_15032.t108 a_58313_15032.t79 38873.1006566821
Riso16968 a_58313_15032.t108 a_58313_15032.t8 149917716.033633
Riso16969 a_58313_15032.t108 a_58313_15032.t80 38873.1006566821
Riso16970 a_58313_15032.t108 a_58313_15032.t81 46508.6143604278
Riso16971 a_58313_15032.t108 a_58313_15032.t82 55349.6999697681
Riso16972 a_58313_15032.t108 a_58313_15032.t83 65379.2373179385
Riso16973 a_58313_15032.t108 a_58313_15032.t84 76423.4130430518
Riso16974 a_58313_15032.t108 a_58313_15032.t85 88069.2201654481
Riso16975 a_58313_15032.t108 a_58313_15032.t86 99591.4777372008
Riso16976 a_58313_15032.t108 a_58313_15032.t87 109941.565699955
Riso16977 a_58313_15032.t108 a_58313_15032.t88 117866.347683763
Riso16978 a_58313_15032.t108 a_58313_15032.t89 122190.685436058
Riso16979 a_58313_15032.t108 a_58313_15032.t9 227768762.464676
Riso16980 a_58313_15032.t108 a_58313_15032.t90 99657.358397169
Riso16981 a_58313_15032.t108 a_58313_15032.t91 96130.4768212701
Riso16982 a_58313_15032.t108 a_58313_15032.t92 89667.1131404675
Riso16983 a_58313_15032.t108 a_58313_15032.t93 81225.6969894287
Riso16984 a_58313_15032.t108 a_58313_15032.t94 71828.2723962625
Riso16985 a_58313_15032.t108 a_58313_15032.t95 62330.0821694119
Riso16986 a_58313_15032.t108 a_58313_15032.t96 53322.5757910728
Riso16987 a_58313_15032.t108 a_58313_15032.t97 45142.5971413298
Riso16988 a_58313_15032.t108 a_58313_15032.t98 37931.9064569639
Riso16989 a_58313_15032.t108 a_58313_15032.t99 31704.4667547873
Riso16990 a_58313_15032.t109 a_58313_15032.t11 10337894.854094
Riso16991 a_58313_15032.t109 a_58313_15032.t12 20913040.7787978
Riso16992 a_58313_15032.t109 a_58313_15032.t13 303272.880510849
Riso16993 a_58313_15032.t109 a_58313_15032.t14 149719.082522307
Riso16994 a_58313_15032.t109 a_58313_15032.t15 20913040.7787978
Riso16995 a_58313_15032.t109 a_58313_15032.t16 12562.3457361171
Riso16996 a_58313_15032.t109 a_58313_15032.t17 149719.082522307
Riso16997 a_58313_15032.t109 a_58313_15032.t18 303272.880510849
Riso16998 a_58313_15032.t109 a_58313_15032.t19 2410.0433548467
Riso16999 a_58313_15032.t109 a_58313_15032.t2 42134396.6307807
Riso17000 a_58313_15032.t109 a_58313_15032.t20 2520533.07931011
Riso17001 a_58313_15032.t109 a_58313_15032.t21 5105225.87674084
Riso17002 a_58313_15032.t109 a_58313_15032.t22 2520533.07931011
Riso17003 a_58313_15032.t109 a_58313_15032.t23 5105225.87674084
Riso17004 a_58313_15032.t109 a_58313_15032.t24 10337894.854094
Riso17005 a_58313_15032.t109 a_58313_15032.t25 2410.0433548467
Riso17006 a_58313_15032.t109 a_58313_15032.t26 83509156.9369337
Riso17007 a_58313_15032.t109 a_58313_15032.t27 1244354.56111568
Riso17008 a_58313_15032.t109 a_58313_15032.t28 83509156.9369337
Riso17009 a_58313_15032.t109 a_58313_15032.t29 42134396.6307807
Riso17010 a_58313_15032.t109 a_58313_15032.t3 20148.037884961
Riso17011 a_58313_15032.t109 a_58313_15032.t30 306151.54386968
Riso17012 a_58313_15032.t109 a_58313_15032.t31 295316.817193464
Riso17013 a_58313_15032.t109 a_58313_15032.t32 221522.336281991
Riso17014 a_58313_15032.t109 a_58313_15032.t33 172180.21548276
Riso17015 a_58313_15032.t109 a_58313_15032.t34 136712.683004635
Riso17016 a_58313_15032.t109 a_58313_15032.t35 110014.313712621
Riso17017 a_58313_15032.t109 a_58313_15032.t36 89298.9067335209
Riso17018 a_58313_15032.t109 a_58313_15032.t37 72897.8109067035
Riso17019 a_58313_15032.t109 a_58313_15032.t38 59734.9098675072
Riso17020 a_58313_15032.t109 a_58313_15032.t39 49073.3918930588
Riso17021 a_58313_15032.t109 a_58313_15032.t4 236125253.334845
Riso17022 a_58313_15032.t109 a_58313_15032.t40 48756.4585818577
Riso17023 a_58313_15032.t109 a_58313_15032.t41 58333.2765191707
Riso17024 a_58313_15032.t109 a_58313_15032.t42 69422.1790519909
Riso17025 a_58313_15032.t109 a_58313_15032.t43 82001.6932674902
Riso17026 a_58313_15032.t109 a_58313_15032.t44 95853.8143284758
Riso17027 a_58313_15032.t109 a_58313_15032.t45 110460.529589761
Riso17028 a_58313_15032.t109 a_58313_15032.t46 124912.283233706
Riso17029 a_58313_15032.t109 a_58313_15032.t47 137893.847002736
Riso17030 a_58313_15032.t109 a_58313_15032.t48 147833.478728443
Riso17031 a_58313_15032.t109 a_58313_15032.t49 153257.265124486
Riso17032 a_58313_15032.t109 a_58313_15032.t5 1244354.56111568
Riso17033 a_58313_15032.t109 a_58313_15032.t50 143332.913362752
Riso17034 a_58313_15032.t109 a_58313_15032.t51 138260.350538597
Riso17035 a_58313_15032.t109 a_58313_15032.t52 128964.371181002
Riso17036 a_58313_15032.t109 a_58313_15032.t53 116823.44361383
Riso17037 a_58313_15032.t109 a_58313_15032.t54 103307.530020403
Riso17038 a_58313_15032.t109 a_58313_15032.t55 89646.6895287012
Riso17039 a_58313_15032.t109 a_58313_15032.t56 76691.578615611
Riso17040 a_58313_15032.t109 a_58313_15032.t57 64926.6654173291
Riso17041 a_58313_15032.t109 a_58313_15032.t58 54555.8376152429
Riso17042 a_58313_15032.t109 a_58313_15032.t59 45599.1776188327
Riso17043 a_58313_15032.t109 a_58313_15032.t6 12562.3457361171
Riso17044 a_58313_15032.t109 a_58313_15032.t60 45599.1776188327
Riso17045 a_58313_15032.t109 a_58313_15032.t61 54555.8376152429
Riso17046 a_58313_15032.t109 a_58313_15032.t62 64926.6654173291
Riso17047 a_58313_15032.t109 a_58313_15032.t63 76691.578615611
Riso17048 a_58313_15032.t109 a_58313_15032.t64 89646.6895287012
Riso17049 a_58313_15032.t109 a_58313_15032.t65 103307.530020403
Riso17050 a_58313_15032.t109 a_58313_15032.t66 116823.44361383
Riso17051 a_58313_15032.t109 a_58313_15032.t67 128964.371181002
Riso17052 a_58313_15032.t109 a_58313_15032.t68 138260.350538597
Riso17053 a_58313_15032.t109 a_58313_15032.t69 143332.913362752
Riso17054 a_58313_15032.t109 a_58313_15032.t7 155417969.939196
Riso17055 a_58313_15032.t109 a_58313_15032.t70 126673.676589969
Riso17056 a_58313_15032.t109 a_58313_15032.t71 122190.685436058
Riso17057 a_58313_15032.t109 a_58313_15032.t72 113975.155205743
Riso17058 a_58313_15032.t109 a_58313_15032.t73 103245.338193973
Riso17059 a_58313_15032.t109 a_58313_15032.t74 91300.3464458556
Riso17060 a_58313_15032.t109 a_58313_15032.t75 79227.2723012347
Riso17061 a_58313_15032.t109 a_58313_15032.t76 67777.9024985106
Riso17062 a_58313_15032.t109 a_58313_15032.t77 57380.3966178026
Riso17063 a_58313_15032.t109 a_58313_15032.t78 48214.944969953
Riso17064 a_58313_15032.t109 a_58313_15032.t79 40299.2958347111
Riso17065 a_58313_15032.t109 a_58313_15032.t8 155417969.939196
Riso17066 a_58313_15032.t109 a_58313_15032.t80 40299.2958347111
Riso17067 a_58313_15032.t109 a_58313_15032.t81 48214.944969953
Riso17068 a_58313_15032.t109 a_58313_15032.t82 57380.3966178026
Riso17069 a_58313_15032.t109 a_58313_15032.t83 67777.9024985106
Riso17070 a_58313_15032.t109 a_58313_15032.t84 79227.2723012347
Riso17071 a_58313_15032.t109 a_58313_15032.t85 91300.3464458556
Riso17072 a_58313_15032.t109 a_58313_15032.t86 103245.338193973
Riso17073 a_58313_15032.t109 a_58313_15032.t87 113975.155205743
Riso17074 a_58313_15032.t109 a_58313_15032.t88 122190.685436058
Riso17075 a_58313_15032.t109 a_58313_15032.t89 126673.676589969
Riso17076 a_58313_15032.t109 a_58313_15032.t9 236125253.334845
Riso17077 a_58313_15032.t109 a_58313_15032.t90 103313.635915559
Riso17078 a_58313_15032.t109 a_58313_15032.t91 99657.358397169
Riso17079 a_58313_15032.t109 a_58313_15032.t92 92956.8636936363
Riso17080 a_58313_15032.t109 a_58313_15032.t93 84205.7447710931
Riso17081 a_58313_15032.t109 a_58313_15032.t94 74463.5429048446
Riso17082 a_58313_15032.t109 a_58313_15032.t95 64616.8784664517
Riso17083 a_58313_15032.t109 a_58313_15032.t96 55278.9003236834
Riso17084 a_58313_15032.t109 a_58313_15032.t97 46798.8106483325
Riso17085 a_58313_15032.t109 a_58313_15032.t98 39323.5706455284
Riso17086 a_58313_15032.t109 a_58313_15032.t99 32867.6556140193
Riso17087 a_58313_15032.t11 a_58313_15032.t12 26.5520801486953
Riso17088 a_58313_15032.t11 a_58313_15032.t13 414.19431861064
Riso17089 a_58313_15032.t11 a_58313_15032.t14 681.096444775882
Riso17090 a_58313_15032.t11 a_58313_15032.t15 26.5520801486953
Riso17091 a_58313_15032.t11 a_58313_15032.t16 9911.02144205603
Riso17092 a_58313_15032.t11 a_58313_15032.t17 681.096444775882
Riso17093 a_58313_15032.t11 a_58313_15032.t18 414.19431861064
Riso17094 a_58313_15032.t11 a_58313_15032.t19 15446.9741043976
Riso17095 a_58313_15032.t11 a_58313_15032.t2 53.4956101406176
Riso17096 a_58313_15032.t11 a_58313_15032.t20 53.7959242294991
Riso17097 a_58313_15032.t11 a_58313_15032.t21 26.5813152686799
Riso17098 a_58313_15032.t11 a_58313_15032.t22 53.7959242294991
Riso17099 a_58313_15032.t11 a_58313_15032.t23 26.5813152686799
Riso17100 a_58313_15032.t11 a_58313_15032.t24 0.816215427278121
Riso17101 a_58313_15032.t11 a_58313_15032.t25 15446.9741043976
Riso17102 a_58313_15032.t11 a_58313_15032.t26 106.026753908855
Riso17103 a_58313_15032.t11 a_58313_15032.t27 108.576381875046
Riso17104 a_58313_15032.t11 a_58313_15032.t28 106.026753908855
Riso17105 a_58313_15032.t11 a_58313_15032.t29 53.4956101406176
Riso17106 a_58313_15032.t11 a_58313_15032.t3 5478.09060804338
Riso17107 a_58313_15032.t11 a_58313_15032.t30 29550520.0437965
Riso17108 a_58313_15032.t11 a_58313_15032.t31 28504724.8674349
Riso17109 a_58313_15032.t11 a_58313_15032.t32 21384869.9875579
Riso17110 a_58313_15032.t11 a_58313_15032.t33 16622929.6634914
Riso17111 a_58313_15032.t11 a_58313_15032.t34 13199420.6577806
Riso17112 a_58313_15032.t11 a_58313_15032.t35 10622069.7891408
Riso17113 a_58313_15032.t11 a_58313_15032.t36 8622142.05185498
Riso17114 a_58313_15032.t11 a_58313_15032.t37 7038652.6219584
Riso17115 a_58313_15032.t11 a_58313_15032.t38 5767761.32513144
Riso17116 a_58313_15032.t11 a_58313_15032.t39 4738357.81079355
Riso17117 a_58313_15032.t11 a_58313_15032.t4 299.794597925429
Riso17118 a_58313_15032.t11 a_58313_15032.t40 4707766.70772214
Riso17119 a_58313_15032.t11 a_58313_15032.t41 5632473.42274131
Riso17120 a_58313_15032.t11 a_58313_15032.t42 6703182.15933958
Riso17121 a_58313_15032.t11 a_58313_15032.t43 7917819.56216936
Riso17122 a_58313_15032.t11 a_58313_15032.t44 9255335.78584586
Riso17123 a_58313_15032.t11 a_58313_15032.t45 10665713.1966826
Riso17124 a_58313_15032.t11 a_58313_15032.t46 12061128.0125259
Riso17125 a_58313_15032.t11 a_58313_15032.t47 13314586.0261632
Riso17126 a_58313_15032.t11 a_58313_15032.t48 14274324.8727972
Riso17127 a_58313_15032.t11 a_58313_15032.t49 14798028.229599
Riso17128 a_58313_15032.t11 a_58313_15032.t5 108.576381875046
Riso17129 a_58313_15032.t11 a_58313_15032.t50 13839775.4629196
Riso17130 a_58313_15032.t11 a_58313_15032.t51 13349984.7452064
Riso17131 a_58313_15032.t11 a_58313_15032.t52 12452394.2058204
Riso17132 a_58313_15032.t11 a_58313_15032.t53 11280104.412087
Riso17133 a_58313_15032.t11 a_58313_15032.t54 9975050.29073635
Riso17134 a_58313_15032.t11 a_58313_15032.t55 8656002.48375131
Riso17135 a_58313_15032.t11 a_58313_15032.t56 7405097.70600065
Riso17136 a_58313_15032.t11 a_58313_15032.t57 6269114.67750473
Riso17137 a_58313_15032.t11 a_58313_15032.t58 5267740.1517374
Riso17138 a_58313_15032.t11 a_58313_15032.t59 4402913.22301717
Riso17139 a_58313_15032.t11 a_58313_15032.t6 9911.02144205603
Riso17140 a_58313_15032.t11 a_58313_15032.t60 4402913.22301717
Riso17141 a_58313_15032.t11 a_58313_15032.t61 5267740.1517374
Riso17142 a_58313_15032.t11 a_58313_15032.t62 6269114.67750473
Riso17143 a_58313_15032.t11 a_58313_15032.t63 7405097.70600065
Riso17144 a_58313_15032.t11 a_58313_15032.t64 8656002.48375131
Riso17145 a_58313_15032.t11 a_58313_15032.t65 9975050.29073635
Riso17146 a_58313_15032.t11 a_58313_15032.t66 11280104.412087
Riso17147 a_58313_15032.t11 a_58313_15032.t67 12452394.2058204
Riso17148 a_58313_15032.t11 a_58313_15032.t68 13349984.7452064
Riso17149 a_58313_15032.t11 a_58313_15032.t69 13839775.4629196
Riso17150 a_58313_15032.t11 a_58313_15032.t7 197.325221043742
Riso17151 a_58313_15032.t11 a_58313_15032.t70 12231219.1366843
Riso17152 a_58313_15032.t11 a_58313_15032.t71 11798355.3510315
Riso17153 a_58313_15032.t11 a_58313_15032.t72 11005089.1154875
Riso17154 a_58313_15032.t11 a_58313_15032.t73 9969051.11058858
Riso17155 a_58313_15032.t11 a_58313_15032.t74 8815679.58471088
Riso17156 a_58313_15032.t11 a_58313_15032.t75 7649940.81805072
Riso17157 a_58313_15032.t11 a_58313_15032.t76 6544425.01710535
Riso17158 a_58313_15032.t11 a_58313_15032.t77 5540473.94909022
Riso17159 a_58313_15032.t11 a_58313_15032.t78 4655486.23412553
Riso17160 a_58313_15032.t11 a_58313_15032.t79 3891175.59131029
Riso17161 a_58313_15032.t11 a_58313_15032.t8 197.325221043742
Riso17162 a_58313_15032.t11 a_58313_15032.t80 3891175.59131029
Riso17163 a_58313_15032.t11 a_58313_15032.t81 4655486.23412553
Riso17164 a_58313_15032.t11 a_58313_15032.t82 5540473.94909022
Riso17165 a_58313_15032.t11 a_58313_15032.t83 6544425.01710535
Riso17166 a_58313_15032.t11 a_58313_15032.t84 7649940.81805072
Riso17167 a_58313_15032.t11 a_58313_15032.t85 8815679.58471088
Riso17168 a_58313_15032.t11 a_58313_15032.t86 9969051.11058858
Riso17169 a_58313_15032.t11 a_58313_15032.t87 11005089.1154875
Riso17170 a_58313_15032.t11 a_58313_15032.t88 11798355.3510315
Riso17171 a_58313_15032.t11 a_58313_15032.t89 12231219.1366843
Riso17172 a_58313_15032.t11 a_58313_15032.t9 299.794597925429
Riso17173 a_58313_15032.t11 a_58313_15032.t90 10337894.854094
Riso17174 a_58313_15032.t11 a_58313_15032.t91 9972035.96037162
Riso17175 a_58313_15032.t11 a_58313_15032.t92 9301562.89936982
Riso17176 a_58313_15032.t11 a_58313_15032.t93 8425897.7804801
Riso17177 a_58313_15032.t11 a_58313_15032.t94 7451061.71311963
Riso17178 a_58313_15032.t11 a_58313_15032.t95 6465772.78464895
Riso17179 a_58313_15032.t11 a_58313_15032.t96 5531384.6437779
Riso17180 a_58313_15032.t11 a_58313_15032.t97 4682839.5834848
Riso17181 a_58313_15032.t11 a_58313_15032.t98 3934843.0148492
Riso17182 a_58313_15032.t11 a_58313_15032.t99 3288843.38284269
Riso17183 a_58313_15032.t12 a_58313_15032.t13 837.894251944369
Riso17184 a_58313_15032.t12 a_58313_15032.t14 1377.8238147055
Riso17185 a_58313_15032.t12 a_58313_15032.t15 0.816151268289667
Riso17186 a_58313_15032.t12 a_58313_15032.t16 20049.4973592397
Riso17187 a_58313_15032.t12 a_58313_15032.t17 1377.8238147055
Riso17188 a_58313_15032.t12 a_58313_15032.t18 837.894251944369
Riso17189 a_58313_15032.t12 a_58313_15032.t19 31248.4508609961
Riso17190 a_58313_15032.t12 a_58313_15032.t2 26.4109734619289
Riso17191 a_58313_15032.t12 a_58313_15032.t20 108.826446101751
Riso17192 a_58313_15032.t12 a_58313_15032.t21 53.7726624243845
Riso17193 a_58313_15032.t12 a_58313_15032.t22 108.826446101751
Riso17194 a_58313_15032.t12 a_58313_15032.t23 53.7726624243845
Riso17195 a_58313_15032.t12 a_58313_15032.t24 26.5520801486953
Riso17196 a_58313_15032.t12 a_58313_15032.t25 31248.4508609961
Riso17197 a_58313_15032.t12 a_58313_15032.t26 52.3457864370644
Riso17198 a_58313_15032.t12 a_58313_15032.t27 219.644553733096
Riso17199 a_58313_15032.t12 a_58313_15032.t28 52.3457864370644
Riso17200 a_58313_15032.t12 a_58313_15032.t29 26.4109734619289
Riso17201 a_58313_15032.t12 a_58313_15032.t3 11081.9014792543
Riso17202 a_58313_15032.t12 a_58313_15032.t30 59779214.1855515
Riso17203 a_58313_15032.t12 a_58313_15032.t31 57663623.1993597
Riso17204 a_58313_15032.t12 a_58313_15032.t32 43260515.2607038
Riso17205 a_58313_15032.t12 a_58313_15032.t33 33627349.7479044
Riso17206 a_58313_15032.t12 a_58313_15032.t34 26701763.4023772
Riso17207 a_58313_15032.t12 a_58313_15032.t35 21487912.3642435
Riso17208 a_58313_15032.t12 a_58313_15032.t36 17442159.2476946
Riso17209 a_58313_15032.t12 a_58313_15032.t37 14238839.8594046
Riso17210 a_58313_15032.t12 a_58313_15032.t38 11667890.7550581
Riso17211 a_58313_15032.t12 a_58313_15032.t39 9585459.27582315
Riso17212 a_58313_15032.t12 a_58313_15032.t4 148.009661896096
Riso17213 a_58313_15032.t12 a_58313_15032.t40 9523575.01456595
Riso17214 a_58313_15032.t12 a_58313_15032.t41 11394210.140243
Riso17215 a_58313_15032.t12 a_58313_15032.t42 13560200.0044006
Riso17216 a_58313_15032.t12 a_58313_15032.t43 16017350.3135636
Riso17217 a_58313_15032.t12 a_58313_15032.t44 18723078.2903743
Riso17218 a_58313_15032.t12 a_58313_15032.t45 21576200.7802636
Riso17219 a_58313_15032.t12 a_58313_15032.t46 24399054.6938443
Riso17220 a_58313_15032.t12 a_58313_15032.t47 26934737.1440608
Riso17221 a_58313_15032.t12 a_58313_15032.t48 28876240.5081333
Riso17222 a_58313_15032.t12 a_58313_15032.t49 29935666.0305794
Riso17223 a_58313_15032.t12 a_58313_15032.t5 219.644553733096
Riso17224 a_58313_15032.t12 a_58313_15032.t50 27997168.9314311
Riso17225 a_58313_15032.t12 a_58313_15032.t51 27006346.9703666
Riso17226 a_58313_15032.t12 a_58313_15032.t52 25190566.5027011
Riso17227 a_58313_15032.t12 a_58313_15032.t53 22819083.2745459
Riso17228 a_58313_15032.t12 a_58313_15032.t54 20179024.4962798
Riso17229 a_58313_15032.t12 a_58313_15032.t55 17510657.1965545
Riso17230 a_58313_15032.t12 a_58313_15032.t56 14980139.8139819
Riso17231 a_58313_15032.t12 a_58313_15032.t57 12682103.3438636
Riso17232 a_58313_15032.t12 a_58313_15032.t58 10656373.0972527
Riso17233 a_58313_15032.t12 a_58313_15032.t59 8906871.76432259
Riso17234 a_58313_15032.t12 a_58313_15032.t6 20049.4973592397
Riso17235 a_58313_15032.t12 a_58313_15032.t60 8906871.76432259
Riso17236 a_58313_15032.t12 a_58313_15032.t61 10656373.0972527
Riso17237 a_58313_15032.t12 a_58313_15032.t62 12682103.3438636
Riso17238 a_58313_15032.t12 a_58313_15032.t63 14980139.8139819
Riso17239 a_58313_15032.t12 a_58313_15032.t64 17510657.1965545
Riso17240 a_58313_15032.t12 a_58313_15032.t65 20179024.4962798
Riso17241 a_58313_15032.t12 a_58313_15032.t66 22819083.2745459
Riso17242 a_58313_15032.t12 a_58313_15032.t67 25190566.5027011
Riso17243 a_58313_15032.t12 a_58313_15032.t68 27006346.9703666
Riso17244 a_58313_15032.t12 a_58313_15032.t69 27997168.9314311
Riso17245 a_58313_15032.t12 a_58313_15032.t7 97.4201651809657
Riso17246 a_58313_15032.t12 a_58313_15032.t70 24743140.4739613
Riso17247 a_58313_15032.t12 a_58313_15032.t71 23867478.8301948
Riso17248 a_58313_15032.t12 a_58313_15032.t72 22262741.1764929
Riso17249 a_58313_15032.t12 a_58313_15032.t73 20166888.4568983
Riso17250 a_58313_15032.t12 a_58313_15032.t74 17833675.9320842
Riso17251 a_58313_15032.t12 a_58313_15032.t75 15475445.1018553
Riso17252 a_58313_15032.t12 a_58313_15032.t76 13239042.2990526
Riso17253 a_58313_15032.t12 a_58313_15032.t77 11208099.8372028
Riso17254 a_58313_15032.t12 a_58313_15032.t78 9417814.24879187
Riso17255 a_58313_15032.t12 a_58313_15032.t79 7871652.30127174
Riso17256 a_58313_15032.t12 a_58313_15032.t8 97.4201651809657
Riso17257 a_58313_15032.t12 a_58313_15032.t80 7871652.30127174
Riso17258 a_58313_15032.t12 a_58313_15032.t81 9417814.24879187
Riso17259 a_58313_15032.t12 a_58313_15032.t82 11208099.8372028
Riso17260 a_58313_15032.t12 a_58313_15032.t83 13239042.2990526
Riso17261 a_58313_15032.t12 a_58313_15032.t84 15475445.1018553
Riso17262 a_58313_15032.t12 a_58313_15032.t85 17833675.9320842
Riso17263 a_58313_15032.t12 a_58313_15032.t86 20166888.4568983
Riso17264 a_58313_15032.t12 a_58313_15032.t87 22262741.1764929
Riso17265 a_58313_15032.t12 a_58313_15032.t88 23867478.8301948
Riso17266 a_58313_15032.t12 a_58313_15032.t89 24743140.4739613
Riso17267 a_58313_15032.t12 a_58313_15032.t9 148.009661896096
Riso17268 a_58313_15032.t12 a_58313_15032.t90 20913040.7787978
Riso17269 a_58313_15032.t12 a_58313_15032.t91 20172926.6577229
Riso17270 a_58313_15032.t12 a_58313_15032.t92 18816593.413507
Riso17271 a_58313_15032.t12 a_58313_15032.t93 17045166.9675648
Riso17272 a_58313_15032.t12 a_58313_15032.t94 15073122.6861047
Riso17273 a_58313_15032.t12 a_58313_15032.t95 13079932.7929182
Riso17274 a_58313_15032.t12 a_58313_15032.t96 11189712.6302007
Riso17275 a_58313_15032.t12 a_58313_15032.t97 9473148.69730973
Riso17276 a_58313_15032.t12 a_58313_15032.t98 7959989.30044452
Riso17277 a_58313_15032.t12 a_58313_15032.t99 6653164.57085362
Riso17278 a_58313_15032.t13 a_58313_15032.t14 19.9806714643726
Riso17279 a_58313_15032.t13 a_58313_15032.t15 837.894251944369
Riso17280 a_58313_15032.t13 a_58313_15032.t16 290.750105699399
Riso17281 a_58313_15032.t13 a_58313_15032.t17 19.9806714643726
Riso17282 a_58313_15032.t13 a_58313_15032.t18 0.812164452778362
Riso17283 a_58313_15032.t13 a_58313_15032.t19 453.153025633836
Riso17284 a_58313_15032.t13 a_58313_15032.t2 1688.14134297809
Riso17285 a_58313_15032.t13 a_58313_15032.t20 100.986757560896
Riso17286 a_58313_15032.t13 a_58313_15032.t21 204.544114949347
Riso17287 a_58313_15032.t13 a_58313_15032.t22 100.986757560896
Riso17288 a_58313_15032.t13 a_58313_15032.t23 204.544114949347
Riso17289 a_58313_15032.t13 a_58313_15032.t24 414.19431861064
Riso17290 a_58313_15032.t13 a_58313_15032.t25 453.153025633836
Riso17291 a_58313_15032.t13 a_58313_15032.t26 3345.84737448207
Riso17292 a_58313_15032.t13 a_58313_15032.t27 49.8558552612126
Riso17293 a_58313_15032.t13 a_58313_15032.t28 3345.84737448207
Riso17294 a_58313_15032.t13 a_58313_15032.t29 1688.14134297809
Riso17295 a_58313_15032.t13 a_58313_15032.t3 160.705476487102
Riso17296 a_58313_15032.t13 a_58313_15032.t30 866895.191019153
Riso17297 a_58313_15032.t13 a_58313_15032.t31 836215.703557165
Riso17298 a_58313_15032.t13 a_58313_15032.t32 627347.367332558
Riso17299 a_58313_15032.t13 a_58313_15032.t33 487650.903083021
Riso17300 a_58313_15032.t13 a_58313_15032.t34 387218.711396959
Riso17301 a_58313_15032.t13 a_58313_15032.t35 311609.447320336
Riso17302 a_58313_15032.t13 a_58313_15032.t36 252939.490403527
Riso17303 a_58313_15032.t13 a_58313_15032.t37 206486.183667384
Riso17304 a_58313_15032.t13 a_58313_15032.t38 169203.267769643
Riso17305 a_58313_15032.t13 a_58313_15032.t39 139004.646734374
Riso17306 a_58313_15032.t13 a_58313_15032.t4 9460.50813943607
Riso17307 a_58313_15032.t13 a_58313_15032.t40 138107.224959688
Riso17308 a_58313_15032.t13 a_58313_15032.t41 165234.456668815
Riso17309 a_58313_15032.t13 a_58313_15032.t42 196644.809290818
Riso17310 a_58313_15032.t13 a_58313_15032.t43 232277.458793586
Riso17311 a_58313_15032.t13 a_58313_15032.t44 271514.886104401
Riso17312 a_58313_15032.t13 a_58313_15032.t45 312889.772000298
Riso17313 a_58313_15032.t13 a_58313_15032.t46 353825.714634757
Riso17314 a_58313_15032.t13 a_58313_15032.t47 390597.20706725
Riso17315 a_58313_15032.t13 a_58313_15032.t48 418752.142734984
Riso17316 a_58313_15032.t13 a_58313_15032.t49 434115.524525195
Riso17317 a_58313_15032.t13 a_58313_15032.t5 49.8558552612126
Riso17318 a_58313_15032.t13 a_58313_15032.t50 406004.184556086
Riso17319 a_58313_15032.t13 a_58313_15032.t51 391635.665248741
Riso17320 a_58313_15032.t13 a_58313_15032.t52 365303.914709503
Riso17321 a_58313_15032.t13 a_58313_15032.t53 330913.576293725
Riso17322 a_58313_15032.t13 a_58313_15032.t54 292628.458463589
Riso17323 a_58313_15032.t13 a_58313_15032.t55 253932.821334192
Riso17324 a_58313_15032.t13 a_58313_15032.t56 217236.230727741
Riso17325 a_58313_15032.t13 a_58313_15032.t57 183910.988971489
Riso17326 a_58313_15032.t13 a_58313_15032.t58 154534.627421499
Riso17327 a_58313_15032.t13 a_58313_15032.t59 129164.031423179
Riso17328 a_58313_15032.t13 a_58313_15032.t6 290.750105699399
Riso17329 a_58313_15032.t13 a_58313_15032.t60 129164.031423179
Riso17330 a_58313_15032.t13 a_58313_15032.t61 154534.627421499
Riso17331 a_58313_15032.t13 a_58313_15032.t62 183910.988971489
Riso17332 a_58313_15032.t13 a_58313_15032.t63 217236.230727741
Riso17333 a_58313_15032.t13 a_58313_15032.t64 253932.821334192
Riso17334 a_58313_15032.t13 a_58313_15032.t65 292628.458463589
Riso17335 a_58313_15032.t13 a_58313_15032.t66 330913.576293725
Riso17336 a_58313_15032.t13 a_58313_15032.t67 365303.914709503
Riso17337 a_58313_15032.t13 a_58313_15032.t68 391635.665248741
Riso17338 a_58313_15032.t13 a_58313_15032.t69 406004.184556086
Riso17339 a_58313_15032.t13 a_58313_15032.t7 6226.91960668579
Riso17340 a_58313_15032.t13 a_58313_15032.t70 358815.514386148
Riso17341 a_58313_15032.t13 a_58313_15032.t71 346117.00574425
Riso17342 a_58313_15032.t13 a_58313_15032.t72 322845.716989542
Riso17343 a_58313_15032.t13 a_58313_15032.t73 292452.466284348
Riso17344 a_58313_15032.t13 a_58313_15032.t74 258617.114901025
Riso17345 a_58313_15032.t13 a_58313_15032.t75 224418.957667091
Riso17346 a_58313_15032.t13 a_58313_15032.t76 191987.503668487
Riso17347 a_58313_15032.t13 a_58313_15032.t77 162535.556576152
Riso17348 a_58313_15032.t13 a_58313_15032.t78 136573.522978203
Riso17349 a_58313_15032.t13 a_58313_15032.t79 114151.676603949
Riso17350 a_58313_15032.t13 a_58313_15032.t8 6226.91960668579
Riso17351 a_58313_15032.t13 a_58313_15032.t80 114151.676603949
Riso17352 a_58313_15032.t13 a_58313_15032.t81 136573.522978203
Riso17353 a_58313_15032.t13 a_58313_15032.t82 162535.556576152
Riso17354 a_58313_15032.t13 a_58313_15032.t83 191987.503668487
Riso17355 a_58313_15032.t13 a_58313_15032.t84 224418.957667091
Riso17356 a_58313_15032.t13 a_58313_15032.t85 258617.114901025
Riso17357 a_58313_15032.t13 a_58313_15032.t86 292452.466284348
Riso17358 a_58313_15032.t13 a_58313_15032.t87 322845.716989542
Riso17359 a_58313_15032.t13 a_58313_15032.t88 346117.00574425
Riso17360 a_58313_15032.t13 a_58313_15032.t89 358815.514386148
Riso17361 a_58313_15032.t13 a_58313_15032.t9 9460.50813943607
Riso17362 a_58313_15032.t13 a_58313_15032.t90 303272.880510849
Riso17363 a_58313_15032.t13 a_58313_15032.t91 292540.029952231
Riso17364 a_58313_15032.t13 a_58313_15032.t92 272871.00648229
Riso17365 a_58313_15032.t13 a_58313_15032.t93 247182.460920871
Riso17366 a_58313_15032.t13 a_58313_15032.t94 218584.632606028
Riso17367 a_58313_15032.t13 a_58313_15032.t95 189680.158756169
Riso17368 a_58313_15032.t13 a_58313_15032.t96 162268.912366396
Riso17369 a_58313_15032.t13 a_58313_15032.t97 137375.961885629
Riso17370 a_58313_15032.t13 a_58313_15032.t98 115432.705818122
Riso17371 a_58313_15032.t13 a_58313_15032.t99 96481.6358011952
Riso17372 a_58313_15032.t14 a_58313_15032.t15 1377.8238147055
Riso17373 a_58313_15032.t14 a_58313_15032.t16 143.536866848272
Riso17374 a_58313_15032.t14 a_58313_15032.t17 0.799771350023131
Riso17375 a_58313_15032.t14 a_58313_15032.t18 19.9806714643726
Riso17376 a_58313_15032.t14 a_58313_15032.t19 223.711579900658
Riso17377 a_58313_15032.t14 a_58313_15032.t2 2775.96049805408
Riso17378 a_58313_15032.t14 a_58313_15032.t20 166.061479971259
Riso17379 a_58313_15032.t14 a_58313_15032.t21 336.350025174515
Riso17380 a_58313_15032.t14 a_58313_15032.t22 166.061479971259
Riso17381 a_58313_15032.t14 a_58313_15032.t23 336.350025174515
Riso17382 a_58313_15032.t14 a_58313_15032.t24 681.096444775882
Riso17383 a_58313_15032.t14 a_58313_15032.t25 223.711579900658
Riso17384 a_58313_15032.t14 a_58313_15032.t26 5501.87351474677
Riso17385 a_58313_15032.t14 a_58313_15032.t27 81.9824035336266
Riso17386 a_58313_15032.t14 a_58313_15032.t28 5501.87351474677
Riso17387 a_58313_15032.t14 a_58313_15032.t29 2775.96049805408
Riso17388 a_58313_15032.t14 a_58313_15032.t3 79.3367229388598
Riso17389 a_58313_15032.t14 a_58313_15032.t30 427966.893788066
Riso17390 a_58313_15032.t14 a_58313_15032.t31 412821.112512383
Riso17391 a_58313_15032.t14 a_58313_15032.t32 309707.455878024
Riso17392 a_58313_15032.t14 a_58313_15032.t33 240742.415470124
Riso17393 a_58313_15032.t14 a_58313_15032.t34 191161.273992478
Riso17394 a_58313_15032.t14 a_58313_15032.t35 153834.660321416
Riso17395 a_58313_15032.t14 a_58313_15032.t36 124870.606211428
Riso17396 a_58313_15032.t14 a_58313_15032.t37 101937.640847208
Riso17397 a_58313_15032.t14 a_58313_15032.t38 83531.8936779804
Riso17398 a_58313_15032.t14 a_58313_15032.t39 68623.5054725353
Riso17399 a_58313_15032.t14 a_58313_15032.t4 15556.7523986257
Riso17400 a_58313_15032.t14 a_58313_15032.t40 68180.4682826781
Riso17401 a_58313_15032.t14 a_58313_15032.t41 81572.5798226846
Riso17402 a_58313_15032.t14 a_58313_15032.t42 97079.172988374
Riso17403 a_58313_15032.t14 a_58313_15032.t43 114670.220306575
Riso17404 a_58313_15032.t14 a_58313_15032.t44 134040.86633208
Riso17405 a_58313_15032.t14 a_58313_15032.t45 154466.728167679
Riso17406 a_58313_15032.t14 a_58313_15032.t46 174675.893468227
Riso17407 a_58313_15032.t14 a_58313_15032.t47 192829.162236259
Riso17408 a_58313_15032.t14 a_58313_15032.t48 206728.628385515
Riso17409 a_58313_15032.t14 a_58313_15032.t49 214313.188607964
Riso17410 a_58313_15032.t14 a_58313_15032.t5 81.9824035336266
Riso17411 a_58313_15032.t14 a_58313_15032.t50 200435.244686443
Riso17412 a_58313_15032.t14 a_58313_15032.t51 193341.825966391
Riso17413 a_58313_15032.t14 a_58313_15032.t52 180342.425804727
Riso17414 a_58313_15032.t14 a_58313_15032.t53 163364.679866585
Riso17415 a_58313_15032.t14 a_58313_15032.t54 144464.167871806
Riso17416 a_58313_15032.t14 a_58313_15032.t55 125360.991620535
Riso17417 a_58313_15032.t14 a_58313_15032.t56 107244.700219735
Riso17418 a_58313_15032.t14 a_58313_15032.t57 90792.7688364355
Riso17419 a_58313_15032.t14 a_58313_15032.t58 76290.3118686398
Riso17420 a_58313_15032.t14 a_58313_15032.t59 63765.4123474089
Riso17421 a_58313_15032.t14 a_58313_15032.t6 143.536866848272
Riso17422 a_58313_15032.t14 a_58313_15032.t60 63765.4123474089
Riso17423 a_58313_15032.t14 a_58313_15032.t61 76290.3118686398
Riso17424 a_58313_15032.t14 a_58313_15032.t62 90792.7688364355
Riso17425 a_58313_15032.t14 a_58313_15032.t63 107244.700219735
Riso17426 a_58313_15032.t14 a_58313_15032.t64 125360.991620535
Riso17427 a_58313_15032.t14 a_58313_15032.t65 144464.167871806
Riso17428 a_58313_15032.t14 a_58313_15032.t66 163364.679866585
Riso17429 a_58313_15032.t14 a_58313_15032.t67 180342.425804727
Riso17430 a_58313_15032.t14 a_58313_15032.t68 193341.825966391
Riso17431 a_58313_15032.t14 a_58313_15032.t69 200435.244686443
Riso17432 a_58313_15032.t14 a_58313_15032.t7 10239.4760513501
Riso17433 a_58313_15032.t14 a_58313_15032.t70 177139.2467344
Riso17434 a_58313_15032.t14 a_58313_15032.t71 170870.275173
Riso17435 a_58313_15032.t14 a_58313_15032.t72 159381.756992285
Riso17436 a_58313_15032.t14 a_58313_15032.t73 144377.284443381
Riso17437 a_58313_15032.t14 a_58313_15032.t74 127673.523271602
Riso17438 a_58313_15032.t14 a_58313_15032.t75 110790.652912756
Riso17439 a_58313_15032.t14 a_58313_15032.t76 94779.9646858482
Riso17440 a_58313_15032.t14 a_58313_15032.t77 80240.1928152736
Riso17441 a_58313_15032.t14 a_58313_15032.t78 67423.3136925813
Riso17442 a_58313_15032.t14 a_58313_15032.t79 56354.1463408729
Riso17443 a_58313_15032.t14 a_58313_15032.t8 10239.4760513501
Riso17444 a_58313_15032.t14 a_58313_15032.t80 56354.1463408729
Riso17445 a_58313_15032.t14 a_58313_15032.t81 67423.3136925813
Riso17446 a_58313_15032.t14 a_58313_15032.t82 80240.1928152736
Riso17447 a_58313_15032.t14 a_58313_15032.t83 94779.9646858482
Riso17448 a_58313_15032.t14 a_58313_15032.t84 110790.652912756
Riso17449 a_58313_15032.t14 a_58313_15032.t85 127673.523271602
Riso17450 a_58313_15032.t14 a_58313_15032.t86 144377.284443381
Riso17451 a_58313_15032.t14 a_58313_15032.t87 159381.756992285
Riso17452 a_58313_15032.t14 a_58313_15032.t88 170870.275173
Riso17453 a_58313_15032.t14 a_58313_15032.t89 177139.246734401
Riso17454 a_58313_15032.t14 a_58313_15032.t9 15556.7523986257
Riso17455 a_58313_15032.t14 a_58313_15032.t90 149719.082522307
Riso17456 a_58313_15032.t14 a_58313_15032.t91 144420.51268059
Riso17457 a_58313_15032.t14 a_58313_15032.t92 134710.352830264
Riso17458 a_58313_15032.t14 a_58313_15032.t93 122028.488674426
Riso17459 a_58313_15032.t14 a_58313_15032.t94 107910.376266167
Riso17460 a_58313_15032.t14 a_58313_15032.t95 93640.8797707952
Riso17461 a_58313_15032.t14 a_58313_15032.t96 80108.5564936305
Riso17462 a_58313_15032.t14 a_58313_15032.t97 67819.4599513489
Riso17463 a_58313_15032.t14 a_58313_15032.t98 56986.5620000213
Riso17464 a_58313_15032.t14 a_58313_15032.t99 47630.8398168477
Riso17465 a_58313_15032.t15 a_58313_15032.t16 20049.4973592397
Riso17466 a_58313_15032.t15 a_58313_15032.t17 1377.8238147055
Riso17467 a_58313_15032.t15 a_58313_15032.t18 837.894251944369
Riso17468 a_58313_15032.t15 a_58313_15032.t19 31248.4508609961
Riso17469 a_58313_15032.t15 a_58313_15032.t2 26.4109734619289
Riso17470 a_58313_15032.t15 a_58313_15032.t20 108.826446101751
Riso17471 a_58313_15032.t15 a_58313_15032.t21 53.7726624243845
Riso17472 a_58313_15032.t15 a_58313_15032.t22 108.826446101751
Riso17473 a_58313_15032.t15 a_58313_15032.t23 53.7726624243845
Riso17474 a_58313_15032.t15 a_58313_15032.t24 26.5520801486953
Riso17475 a_58313_15032.t15 a_58313_15032.t25 31248.4508609961
Riso17476 a_58313_15032.t15 a_58313_15032.t26 52.3457864370644
Riso17477 a_58313_15032.t15 a_58313_15032.t27 219.644553733096
Riso17478 a_58313_15032.t15 a_58313_15032.t28 52.3457864370644
Riso17479 a_58313_15032.t15 a_58313_15032.t29 26.4109734619289
Riso17480 a_58313_15032.t15 a_58313_15032.t3 11081.9014792543
Riso17481 a_58313_15032.t15 a_58313_15032.t30 59779214.1855515
Riso17482 a_58313_15032.t15 a_58313_15032.t31 57663623.1993597
Riso17483 a_58313_15032.t15 a_58313_15032.t32 43260515.2607038
Riso17484 a_58313_15032.t15 a_58313_15032.t33 33627349.7479044
Riso17485 a_58313_15032.t15 a_58313_15032.t34 26701763.4023772
Riso17486 a_58313_15032.t15 a_58313_15032.t35 21487912.3642435
Riso17487 a_58313_15032.t15 a_58313_15032.t36 17442159.2476946
Riso17488 a_58313_15032.t15 a_58313_15032.t37 14238839.8594046
Riso17489 a_58313_15032.t15 a_58313_15032.t38 11667890.7550581
Riso17490 a_58313_15032.t15 a_58313_15032.t39 9585459.27582315
Riso17491 a_58313_15032.t15 a_58313_15032.t4 148.009661896096
Riso17492 a_58313_15032.t15 a_58313_15032.t40 9523575.01456595
Riso17493 a_58313_15032.t15 a_58313_15032.t41 11394210.140243
Riso17494 a_58313_15032.t15 a_58313_15032.t42 13560200.0044006
Riso17495 a_58313_15032.t15 a_58313_15032.t43 16017350.3135636
Riso17496 a_58313_15032.t15 a_58313_15032.t44 18723078.2903743
Riso17497 a_58313_15032.t15 a_58313_15032.t45 21576200.7802636
Riso17498 a_58313_15032.t15 a_58313_15032.t46 24399054.6938443
Riso17499 a_58313_15032.t15 a_58313_15032.t47 26934737.1440608
Riso17500 a_58313_15032.t15 a_58313_15032.t48 28876240.5081333
Riso17501 a_58313_15032.t15 a_58313_15032.t49 29935666.0305794
Riso17502 a_58313_15032.t15 a_58313_15032.t5 219.644553733096
Riso17503 a_58313_15032.t15 a_58313_15032.t50 27997168.9314311
Riso17504 a_58313_15032.t15 a_58313_15032.t51 27006346.9703666
Riso17505 a_58313_15032.t15 a_58313_15032.t52 25190566.5027011
Riso17506 a_58313_15032.t15 a_58313_15032.t53 22819083.2745459
Riso17507 a_58313_15032.t15 a_58313_15032.t54 20179024.4962798
Riso17508 a_58313_15032.t15 a_58313_15032.t55 17510657.1965545
Riso17509 a_58313_15032.t15 a_58313_15032.t56 14980139.8139819
Riso17510 a_58313_15032.t15 a_58313_15032.t57 12682103.3438636
Riso17511 a_58313_15032.t15 a_58313_15032.t58 10656373.0972527
Riso17512 a_58313_15032.t15 a_58313_15032.t59 8906871.76432259
Riso17513 a_58313_15032.t15 a_58313_15032.t6 20049.4973592397
Riso17514 a_58313_15032.t15 a_58313_15032.t60 8906871.76432259
Riso17515 a_58313_15032.t15 a_58313_15032.t61 10656373.0972527
Riso17516 a_58313_15032.t15 a_58313_15032.t62 12682103.3438636
Riso17517 a_58313_15032.t15 a_58313_15032.t63 14980139.8139819
Riso17518 a_58313_15032.t15 a_58313_15032.t64 17510657.1965545
Riso17519 a_58313_15032.t15 a_58313_15032.t65 20179024.4962798
Riso17520 a_58313_15032.t15 a_58313_15032.t66 22819083.2745459
Riso17521 a_58313_15032.t15 a_58313_15032.t67 25190566.5027011
Riso17522 a_58313_15032.t15 a_58313_15032.t68 27006346.9703666
Riso17523 a_58313_15032.t15 a_58313_15032.t69 27997168.9314311
Riso17524 a_58313_15032.t15 a_58313_15032.t7 97.4201651809657
Riso17525 a_58313_15032.t15 a_58313_15032.t70 24743140.4739613
Riso17526 a_58313_15032.t15 a_58313_15032.t71 23867478.8301948
Riso17527 a_58313_15032.t15 a_58313_15032.t72 22262741.1764929
Riso17528 a_58313_15032.t15 a_58313_15032.t73 20166888.4568983
Riso17529 a_58313_15032.t15 a_58313_15032.t74 17833675.9320842
Riso17530 a_58313_15032.t15 a_58313_15032.t75 15475445.1018553
Riso17531 a_58313_15032.t15 a_58313_15032.t76 13239042.2990526
Riso17532 a_58313_15032.t15 a_58313_15032.t77 11208099.8372028
Riso17533 a_58313_15032.t15 a_58313_15032.t78 9417814.24879187
Riso17534 a_58313_15032.t15 a_58313_15032.t79 7871652.30127174
Riso17535 a_58313_15032.t15 a_58313_15032.t8 97.4201651809657
Riso17536 a_58313_15032.t15 a_58313_15032.t80 7871652.30127174
Riso17537 a_58313_15032.t15 a_58313_15032.t81 9417814.24879187
Riso17538 a_58313_15032.t15 a_58313_15032.t82 11208099.8372028
Riso17539 a_58313_15032.t15 a_58313_15032.t83 13239042.2990526
Riso17540 a_58313_15032.t15 a_58313_15032.t84 15475445.1018553
Riso17541 a_58313_15032.t15 a_58313_15032.t85 17833675.9320842
Riso17542 a_58313_15032.t15 a_58313_15032.t86 20166888.4568983
Riso17543 a_58313_15032.t15 a_58313_15032.t87 22262741.1764929
Riso17544 a_58313_15032.t15 a_58313_15032.t88 23867478.8301948
Riso17545 a_58313_15032.t15 a_58313_15032.t89 24743140.4739613
Riso17546 a_58313_15032.t15 a_58313_15032.t9 148.009661896096
Riso17547 a_58313_15032.t15 a_58313_15032.t90 20913040.7787978
Riso17548 a_58313_15032.t15 a_58313_15032.t91 20172926.6577229
Riso17549 a_58313_15032.t15 a_58313_15032.t92 18816593.413507
Riso17550 a_58313_15032.t15 a_58313_15032.t93 17045166.9675648
Riso17551 a_58313_15032.t15 a_58313_15032.t94 15073122.6861047
Riso17552 a_58313_15032.t15 a_58313_15032.t95 13079932.7929182
Riso17553 a_58313_15032.t15 a_58313_15032.t96 11189712.6302007
Riso17554 a_58313_15032.t15 a_58313_15032.t97 9473148.69730973
Riso17555 a_58313_15032.t15 a_58313_15032.t98 7959989.30044452
Riso17556 a_58313_15032.t15 a_58313_15032.t99 6653164.57085362
Riso17557 a_58313_15032.t16 a_58313_15032.t17 143.536866848272
Riso17558 a_58313_15032.t16 a_58313_15032.t18 290.750105699399
Riso17559 a_58313_15032.t16 a_58313_15032.t19 18.770768325182
Riso17560 a_58313_15032.t16 a_58313_15032.t2 40394.5788141173
Riso17561 a_58313_15032.t16 a_58313_15032.t20 2416.45496951063
Riso17562 a_58313_15032.t16 a_58313_15032.t21 4894.42036749674
Riso17563 a_58313_15032.t16 a_58313_15032.t22 2416.45496951063
Riso17564 a_58313_15032.t16 a_58313_15032.t23 4894.42036749674
Riso17565 a_58313_15032.t16 a_58313_15032.t24 9911.02144205603
Riso17566 a_58313_15032.t16 a_58313_15032.t25 18.770768325182
Riso17567 a_58313_15032.t16 a_58313_15032.t26 80060.8882844458
Riso17568 a_58313_15032.t16 a_58313_15032.t27 1192.97254526182
Riso17569 a_58313_15032.t16 a_58313_15032.t28 80060.8882844458
Riso17570 a_58313_15032.t16 a_58313_15032.t29 40394.5788141173
Riso17571 a_58313_15032.t16 a_58313_15032.t3 19.3160830431666
Riso17572 a_58313_15032.t16 a_58313_15032.t30 35909.0370633066
Riso17573 a_58313_15032.t16 a_58313_15032.t31 34638.2134807456
Riso17574 a_58313_15032.t16 a_58313_15032.t32 25986.3477136475
Riso17575 a_58313_15032.t16 a_58313_15032.t33 20199.7594797779
Riso17576 a_58313_15032.t16 a_58313_15032.t34 16039.5987925742
Riso17577 a_58313_15032.t16 a_58313_15032.t35 12907.6678576883
Riso17578 a_58313_15032.t16 a_58313_15032.t36 10477.4067612441
Riso17579 a_58313_15032.t16 a_58313_15032.t37 8553.19085765813
Riso17580 a_58313_15032.t16 a_58313_15032.t38 7008.83621978524
Riso17581 a_58313_15032.t16 a_58313_15032.t39 5757.93136617616
Riso17582 a_58313_15032.t16 a_58313_15032.t4 226375.145214963
Riso17583 a_58313_15032.t16 a_58313_15032.t40 5720.75783920031
Riso17584 a_58313_15032.t16 a_58313_15032.t41 6844.43781684872
Riso17585 a_58313_15032.t16 a_58313_15032.t42 8145.53572137051
Riso17586 a_58313_15032.t16 a_58313_15032.t43 9621.53206431302
Riso17587 a_58313_15032.t16 a_58313_15032.t44 11246.8476113014
Riso17588 a_58313_15032.t16 a_58313_15032.t45 12960.7022116241
Riso17589 a_58313_15032.t16 a_58313_15032.t46 14656.3746487431
Riso17590 a_58313_15032.t16 a_58313_15032.t47 16179.5448062325
Riso17591 a_58313_15032.t16 a_58313_15032.t48 17345.7949352927
Riso17592 a_58313_15032.t16 a_58313_15032.t49 17982.1858760174
Riso17593 a_58313_15032.t16 a_58313_15032.t5 1192.97254526182
Riso17594 a_58313_15032.t16 a_58313_15032.t50 16817.7415933547
Riso17595 a_58313_15032.t16 a_58313_15032.t51 16222.5604253225
Riso17596 a_58313_15032.t16 a_58313_15032.t52 15131.8313315972
Riso17597 a_58313_15032.t16 a_58313_15032.t53 13707.2947214217
Riso17598 a_58313_15032.t16 a_58313_15032.t54 12121.4262919069
Riso17599 a_58313_15032.t16 a_58313_15032.t55 10518.5530930902
Riso17600 a_58313_15032.t16 a_58313_15032.t56 8998.48556262566
Riso17601 a_58313_15032.t16 a_58313_15032.t57 7618.06800607879
Riso17602 a_58313_15032.t16 a_58313_15032.t58 6401.2232633556
Riso17603 a_58313_15032.t16 a_58313_15032.t59 5350.30767233608
Riso17604 a_58313_15032.t16 a_58313_15032.t6 0.712804839762107
Riso17605 a_58313_15032.t16 a_58313_15032.t60 5350.30767233608
Riso17606 a_58313_15032.t16 a_58313_15032.t61 6401.2232633556
Riso17607 a_58313_15032.t16 a_58313_15032.t62 7618.06800607879
Riso17608 a_58313_15032.t16 a_58313_15032.t63 8998.48556262566
Riso17609 a_58313_15032.t16 a_58313_15032.t64 10518.5530930902
Riso17610 a_58313_15032.t16 a_58313_15032.t65 12121.4262919069
Riso17611 a_58313_15032.t16 a_58313_15032.t66 13707.2947214217
Riso17612 a_58313_15032.t16 a_58313_15032.t67 15131.8313315972
Riso17613 a_58313_15032.t16 a_58313_15032.t68 16222.5604253225
Riso17614 a_58313_15032.t16 a_58313_15032.t69 16817.7415933547
Riso17615 a_58313_15032.t16 a_58313_15032.t7 149000.435222861
Riso17616 a_58313_15032.t16 a_58313_15032.t70 14863.0650376937
Riso17617 a_58313_15032.t16 a_58313_15032.t71 14337.0600232529
Riso17618 a_58313_15032.t16 a_58313_15032.t72 13373.1031585006
Riso17619 a_58313_15032.t16 a_58313_15032.t73 12114.1362414457
Riso17620 a_58313_15032.t16 a_58313_15032.t74 10712.5886270848
Riso17621 a_58313_15032.t16 a_58313_15032.t75 9296.01265765719
Riso17622 a_58313_15032.t16 a_58313_15032.t76 7952.61809771772
Riso17623 a_58313_15032.t16 a_58313_15032.t77 6732.64240667503
Riso17624 a_58313_15032.t16 a_58313_15032.t78 5657.2279432362
Riso17625 a_58313_15032.t16 a_58313_15032.t79 4728.45717507187
Riso17626 a_58313_15032.t16 a_58313_15032.t8 149000.435222861
Riso17627 a_58313_15032.t16 a_58313_15032.t80 4728.45717507187
Riso17628 a_58313_15032.t16 a_58313_15032.t81 5657.2279432362
Riso17629 a_58313_15032.t16 a_58313_15032.t82 6732.64240667503
Riso17630 a_58313_15032.t16 a_58313_15032.t83 7952.61809771772
Riso17631 a_58313_15032.t16 a_58313_15032.t84 9296.01265765719
Riso17632 a_58313_15032.t16 a_58313_15032.t85 10712.5886270848
Riso17633 a_58313_15032.t16 a_58313_15032.t86 12114.1362414457
Riso17634 a_58313_15032.t16 a_58313_15032.t87 13373.1031585006
Riso17635 a_58313_15032.t16 a_58313_15032.t88 14337.0600232529
Riso17636 a_58313_15032.t16 a_58313_15032.t89 14863.0650376937
Riso17637 a_58313_15032.t16 a_58313_15032.t9 226375.145214963
Riso17638 a_58313_15032.t16 a_58313_15032.t90 12562.3457361171
Riso17639 a_58313_15032.t16 a_58313_15032.t91 12117.7633546515
Riso17640 a_58313_15032.t16 a_58313_15032.t92 11303.0216187435
Riso17641 a_58313_15032.t16 a_58313_15032.t93 10238.9357359011
Riso17642 a_58313_15032.t16 a_58313_15032.t94 9054.33984988583
Riso17643 a_58313_15032.t16 a_58313_15032.t95 7857.04191407686
Riso17644 a_58313_15032.t16 a_58313_15032.t96 6721.59731505375
Riso17645 a_58313_15032.t16 a_58313_15032.t97 5690.46703461231
Riso17646 a_58313_15032.t16 a_58313_15032.t98 4781.52071263378
Riso17647 a_58313_15032.t16 a_58313_15032.t99 3996.51846244584
Riso17648 a_58313_15032.t17 a_58313_15032.t18 19.9806714643726
Riso17649 a_58313_15032.t17 a_58313_15032.t19 223.711579900658
Riso17650 a_58313_15032.t17 a_58313_15032.t2 2775.96049805408
Riso17651 a_58313_15032.t17 a_58313_15032.t20 166.061479971259
Riso17652 a_58313_15032.t17 a_58313_15032.t21 336.350025174515
Riso17653 a_58313_15032.t17 a_58313_15032.t22 166.061479971259
Riso17654 a_58313_15032.t17 a_58313_15032.t23 336.350025174515
Riso17655 a_58313_15032.t17 a_58313_15032.t24 681.096444775882
Riso17656 a_58313_15032.t17 a_58313_15032.t25 223.711579900658
Riso17657 a_58313_15032.t17 a_58313_15032.t26 5501.87351474677
Riso17658 a_58313_15032.t17 a_58313_15032.t27 81.9824035336266
Riso17659 a_58313_15032.t17 a_58313_15032.t28 5501.87351474677
Riso17660 a_58313_15032.t17 a_58313_15032.t29 2775.96049805408
Riso17661 a_58313_15032.t17 a_58313_15032.t3 79.3367229388598
Riso17662 a_58313_15032.t17 a_58313_15032.t30 427966.893788066
Riso17663 a_58313_15032.t17 a_58313_15032.t31 412821.112512383
Riso17664 a_58313_15032.t17 a_58313_15032.t32 309707.455878024
Riso17665 a_58313_15032.t17 a_58313_15032.t33 240742.415470124
Riso17666 a_58313_15032.t17 a_58313_15032.t34 191161.273992478
Riso17667 a_58313_15032.t17 a_58313_15032.t35 153834.660321416
Riso17668 a_58313_15032.t17 a_58313_15032.t36 124870.606211428
Riso17669 a_58313_15032.t17 a_58313_15032.t37 101937.640847208
Riso17670 a_58313_15032.t17 a_58313_15032.t38 83531.8936779804
Riso17671 a_58313_15032.t17 a_58313_15032.t39 68623.5054725353
Riso17672 a_58313_15032.t17 a_58313_15032.t4 15556.7523986257
Riso17673 a_58313_15032.t17 a_58313_15032.t40 68180.4682826781
Riso17674 a_58313_15032.t17 a_58313_15032.t41 81572.5798226846
Riso17675 a_58313_15032.t17 a_58313_15032.t42 97079.172988374
Riso17676 a_58313_15032.t17 a_58313_15032.t43 114670.220306575
Riso17677 a_58313_15032.t17 a_58313_15032.t44 134040.86633208
Riso17678 a_58313_15032.t17 a_58313_15032.t45 154466.728167679
Riso17679 a_58313_15032.t17 a_58313_15032.t46 174675.893468227
Riso17680 a_58313_15032.t17 a_58313_15032.t47 192829.162236259
Riso17681 a_58313_15032.t17 a_58313_15032.t48 206728.628385515
Riso17682 a_58313_15032.t17 a_58313_15032.t49 214313.188607964
Riso17683 a_58313_15032.t17 a_58313_15032.t5 81.9824035336266
Riso17684 a_58313_15032.t17 a_58313_15032.t50 200435.244686443
Riso17685 a_58313_15032.t17 a_58313_15032.t51 193341.825966391
Riso17686 a_58313_15032.t17 a_58313_15032.t52 180342.425804727
Riso17687 a_58313_15032.t17 a_58313_15032.t53 163364.679866585
Riso17688 a_58313_15032.t17 a_58313_15032.t54 144464.167871806
Riso17689 a_58313_15032.t17 a_58313_15032.t55 125360.991620535
Riso17690 a_58313_15032.t17 a_58313_15032.t56 107244.700219735
Riso17691 a_58313_15032.t17 a_58313_15032.t57 90792.7688364355
Riso17692 a_58313_15032.t17 a_58313_15032.t58 76290.3118686398
Riso17693 a_58313_15032.t17 a_58313_15032.t59 63765.4123474089
Riso17694 a_58313_15032.t17 a_58313_15032.t6 143.536866848272
Riso17695 a_58313_15032.t17 a_58313_15032.t60 63765.4123474089
Riso17696 a_58313_15032.t17 a_58313_15032.t61 76290.3118686398
Riso17697 a_58313_15032.t17 a_58313_15032.t62 90792.7688364355
Riso17698 a_58313_15032.t17 a_58313_15032.t63 107244.700219735
Riso17699 a_58313_15032.t17 a_58313_15032.t64 125360.991620535
Riso17700 a_58313_15032.t17 a_58313_15032.t65 144464.167871806
Riso17701 a_58313_15032.t17 a_58313_15032.t66 163364.679866585
Riso17702 a_58313_15032.t17 a_58313_15032.t67 180342.425804727
Riso17703 a_58313_15032.t17 a_58313_15032.t68 193341.825966391
Riso17704 a_58313_15032.t17 a_58313_15032.t69 200435.244686443
Riso17705 a_58313_15032.t17 a_58313_15032.t7 10239.4760513501
Riso17706 a_58313_15032.t17 a_58313_15032.t70 177139.2467344
Riso17707 a_58313_15032.t17 a_58313_15032.t71 170870.275173
Riso17708 a_58313_15032.t17 a_58313_15032.t72 159381.756992285
Riso17709 a_58313_15032.t17 a_58313_15032.t73 144377.284443381
Riso17710 a_58313_15032.t17 a_58313_15032.t74 127673.523271602
Riso17711 a_58313_15032.t17 a_58313_15032.t75 110790.652912756
Riso17712 a_58313_15032.t17 a_58313_15032.t76 94779.9646858482
Riso17713 a_58313_15032.t17 a_58313_15032.t77 80240.1928152736
Riso17714 a_58313_15032.t17 a_58313_15032.t78 67423.3136925813
Riso17715 a_58313_15032.t17 a_58313_15032.t79 56354.1463408729
Riso17716 a_58313_15032.t17 a_58313_15032.t8 10239.4760513501
Riso17717 a_58313_15032.t17 a_58313_15032.t80 56354.1463408729
Riso17718 a_58313_15032.t17 a_58313_15032.t81 67423.3136925813
Riso17719 a_58313_15032.t17 a_58313_15032.t82 80240.1928152736
Riso17720 a_58313_15032.t17 a_58313_15032.t83 94779.9646858482
Riso17721 a_58313_15032.t17 a_58313_15032.t84 110790.652912756
Riso17722 a_58313_15032.t17 a_58313_15032.t85 127673.523271602
Riso17723 a_58313_15032.t17 a_58313_15032.t86 144377.284443381
Riso17724 a_58313_15032.t17 a_58313_15032.t87 159381.756992285
Riso17725 a_58313_15032.t17 a_58313_15032.t88 170870.275173
Riso17726 a_58313_15032.t17 a_58313_15032.t89 177139.246734401
Riso17727 a_58313_15032.t17 a_58313_15032.t9 15556.7523986257
Riso17728 a_58313_15032.t17 a_58313_15032.t90 149719.082522307
Riso17729 a_58313_15032.t17 a_58313_15032.t91 144420.51268059
Riso17730 a_58313_15032.t17 a_58313_15032.t92 134710.352830264
Riso17731 a_58313_15032.t17 a_58313_15032.t93 122028.488674426
Riso17732 a_58313_15032.t17 a_58313_15032.t94 107910.376266167
Riso17733 a_58313_15032.t17 a_58313_15032.t95 93640.8797707952
Riso17734 a_58313_15032.t17 a_58313_15032.t96 80108.5564936305
Riso17735 a_58313_15032.t17 a_58313_15032.t97 67819.4599513489
Riso17736 a_58313_15032.t17 a_58313_15032.t98 56986.5620000213
Riso17737 a_58313_15032.t17 a_58313_15032.t99 47630.8398168477
Riso17738 a_58313_15032.t18 a_58313_15032.t19 453.153025633836
Riso17739 a_58313_15032.t18 a_58313_15032.t2 1688.14134297809
Riso17740 a_58313_15032.t18 a_58313_15032.t20 100.986757560896
Riso17741 a_58313_15032.t18 a_58313_15032.t21 204.544114949347
Riso17742 a_58313_15032.t18 a_58313_15032.t22 100.986757560896
Riso17743 a_58313_15032.t18 a_58313_15032.t23 204.544114949347
Riso17744 a_58313_15032.t18 a_58313_15032.t24 414.19431861064
Riso17745 a_58313_15032.t18 a_58313_15032.t25 453.153025633836
Riso17746 a_58313_15032.t18 a_58313_15032.t26 3345.84737448207
Riso17747 a_58313_15032.t18 a_58313_15032.t27 49.8558552612126
Riso17748 a_58313_15032.t18 a_58313_15032.t28 3345.84737448207
Riso17749 a_58313_15032.t18 a_58313_15032.t29 1688.14134297809
Riso17750 a_58313_15032.t18 a_58313_15032.t3 160.705476487102
Riso17751 a_58313_15032.t18 a_58313_15032.t30 866895.191019153
Riso17752 a_58313_15032.t18 a_58313_15032.t31 836215.703557165
Riso17753 a_58313_15032.t18 a_58313_15032.t32 627347.367332558
Riso17754 a_58313_15032.t18 a_58313_15032.t33 487650.903083021
Riso17755 a_58313_15032.t18 a_58313_15032.t34 387218.711396959
Riso17756 a_58313_15032.t18 a_58313_15032.t35 311609.447320336
Riso17757 a_58313_15032.t18 a_58313_15032.t36 252939.490403527
Riso17758 a_58313_15032.t18 a_58313_15032.t37 206486.183667384
Riso17759 a_58313_15032.t18 a_58313_15032.t38 169203.267769643
Riso17760 a_58313_15032.t18 a_58313_15032.t39 139004.646734374
Riso17761 a_58313_15032.t18 a_58313_15032.t4 9460.50813943607
Riso17762 a_58313_15032.t18 a_58313_15032.t40 138107.224959688
Riso17763 a_58313_15032.t18 a_58313_15032.t41 165234.456668815
Riso17764 a_58313_15032.t18 a_58313_15032.t42 196644.809290818
Riso17765 a_58313_15032.t18 a_58313_15032.t43 232277.458793586
Riso17766 a_58313_15032.t18 a_58313_15032.t44 271514.886104401
Riso17767 a_58313_15032.t18 a_58313_15032.t45 312889.772000298
Riso17768 a_58313_15032.t18 a_58313_15032.t46 353825.714634757
Riso17769 a_58313_15032.t18 a_58313_15032.t47 390597.20706725
Riso17770 a_58313_15032.t18 a_58313_15032.t48 418752.142734984
Riso17771 a_58313_15032.t18 a_58313_15032.t49 434115.524525195
Riso17772 a_58313_15032.t18 a_58313_15032.t5 49.8558552612126
Riso17773 a_58313_15032.t18 a_58313_15032.t50 406004.184556086
Riso17774 a_58313_15032.t18 a_58313_15032.t51 391635.665248741
Riso17775 a_58313_15032.t18 a_58313_15032.t52 365303.914709503
Riso17776 a_58313_15032.t18 a_58313_15032.t53 330913.576293725
Riso17777 a_58313_15032.t18 a_58313_15032.t54 292628.458463589
Riso17778 a_58313_15032.t18 a_58313_15032.t55 253932.821334192
Riso17779 a_58313_15032.t18 a_58313_15032.t56 217236.230727741
Riso17780 a_58313_15032.t18 a_58313_15032.t57 183910.988971489
Riso17781 a_58313_15032.t18 a_58313_15032.t58 154534.627421499
Riso17782 a_58313_15032.t18 a_58313_15032.t59 129164.031423179
Riso17783 a_58313_15032.t18 a_58313_15032.t6 290.750105699399
Riso17784 a_58313_15032.t18 a_58313_15032.t60 129164.031423179
Riso17785 a_58313_15032.t18 a_58313_15032.t61 154534.627421499
Riso17786 a_58313_15032.t18 a_58313_15032.t62 183910.988971489
Riso17787 a_58313_15032.t18 a_58313_15032.t63 217236.230727741
Riso17788 a_58313_15032.t18 a_58313_15032.t64 253932.821334192
Riso17789 a_58313_15032.t18 a_58313_15032.t65 292628.458463589
Riso17790 a_58313_15032.t18 a_58313_15032.t66 330913.576293725
Riso17791 a_58313_15032.t18 a_58313_15032.t67 365303.914709503
Riso17792 a_58313_15032.t18 a_58313_15032.t68 391635.665248741
Riso17793 a_58313_15032.t18 a_58313_15032.t69 406004.184556086
Riso17794 a_58313_15032.t18 a_58313_15032.t7 6226.91960668579
Riso17795 a_58313_15032.t18 a_58313_15032.t70 358815.514386148
Riso17796 a_58313_15032.t18 a_58313_15032.t71 346117.00574425
Riso17797 a_58313_15032.t18 a_58313_15032.t72 322845.716989542
Riso17798 a_58313_15032.t18 a_58313_15032.t73 292452.466284348
Riso17799 a_58313_15032.t18 a_58313_15032.t74 258617.114901025
Riso17800 a_58313_15032.t18 a_58313_15032.t75 224418.957667091
Riso17801 a_58313_15032.t18 a_58313_15032.t76 191987.503668487
Riso17802 a_58313_15032.t18 a_58313_15032.t77 162535.556576152
Riso17803 a_58313_15032.t18 a_58313_15032.t78 136573.522978203
Riso17804 a_58313_15032.t18 a_58313_15032.t79 114151.676603949
Riso17805 a_58313_15032.t18 a_58313_15032.t8 6226.91960668579
Riso17806 a_58313_15032.t18 a_58313_15032.t80 114151.676603949
Riso17807 a_58313_15032.t18 a_58313_15032.t81 136573.522978203
Riso17808 a_58313_15032.t18 a_58313_15032.t82 162535.556576152
Riso17809 a_58313_15032.t18 a_58313_15032.t83 191987.503668487
Riso17810 a_58313_15032.t18 a_58313_15032.t84 224418.957667091
Riso17811 a_58313_15032.t18 a_58313_15032.t85 258617.114901025
Riso17812 a_58313_15032.t18 a_58313_15032.t86 292452.466284348
Riso17813 a_58313_15032.t18 a_58313_15032.t87 322845.716989542
Riso17814 a_58313_15032.t18 a_58313_15032.t88 346117.00574425
Riso17815 a_58313_15032.t18 a_58313_15032.t89 358815.514386148
Riso17816 a_58313_15032.t18 a_58313_15032.t9 9460.50813943607
Riso17817 a_58313_15032.t18 a_58313_15032.t90 303272.880510849
Riso17818 a_58313_15032.t18 a_58313_15032.t91 292540.029952231
Riso17819 a_58313_15032.t18 a_58313_15032.t92 272871.00648229
Riso17820 a_58313_15032.t18 a_58313_15032.t93 247182.460920871
Riso17821 a_58313_15032.t18 a_58313_15032.t94 218584.632606028
Riso17822 a_58313_15032.t18 a_58313_15032.t95 189680.158756169
Riso17823 a_58313_15032.t18 a_58313_15032.t96 162268.912366396
Riso17824 a_58313_15032.t18 a_58313_15032.t97 137375.961885629
Riso17825 a_58313_15032.t18 a_58313_15032.t98 115432.705818122
Riso17826 a_58313_15032.t18 a_58313_15032.t99 96481.6358011952
Riso17827 a_58313_15032.t19 a_58313_15032.t2 62957.5888366032
Riso17828 a_58313_15032.t19 a_58313_15032.t20 3766.20286382212
Riso17829 a_58313_15032.t19 a_58313_15032.t21 7628.27374703719
Riso17830 a_58313_15032.t19 a_58313_15032.t22 3766.20286382212
Riso17831 a_58313_15032.t19 a_58313_15032.t23 7628.27374703719
Riso17832 a_58313_15032.t19 a_58313_15032.t24 15446.9741043976
Riso17833 a_58313_15032.t19 a_58313_15032.t25 0.710593380644177
Riso17834 a_58313_15032.t19 a_58313_15032.t26 124780.122345125
Riso17835 a_58313_15032.t19 a_58313_15032.t27 1859.32561256712
Riso17836 a_58313_15032.t19 a_58313_15032.t28 124780.122345125
Riso17837 a_58313_15032.t19 a_58313_15032.t29 62957.5888366032
Riso17838 a_58313_15032.t19 a_58313_15032.t3 30.1053767576445
Riso17839 a_58313_15032.t19 a_58313_15032.t30 6889.02677662776
Riso17840 a_58313_15032.t19 a_58313_15032.t31 6645.22358933544
Riso17841 a_58313_15032.t19 a_58313_15032.t32 4985.39253253908
Riso17842 a_58313_15032.t19 a_58313_15032.t33 3875.25523706754
Riso17843 a_58313_15032.t19 a_58313_15032.t34 3077.14254140557
Riso17844 a_58313_15032.t19 a_58313_15032.t35 2476.29223080157
Riso17845 a_58313_15032.t19 a_58313_15032.t36 2010.05489511127
Riso17846 a_58313_15032.t19 a_58313_15032.t37 1640.90061062164
Riso17847 a_58313_15032.t19 a_58313_15032.t38 1344.62141956009
Riso17848 a_58313_15032.t19 a_58313_15032.t39 1104.63957275272
Riso17849 a_58313_15032.t19 a_58313_15032.t4 352820.446051764
Riso17850 a_58313_15032.t19 a_58313_15032.t40 1097.50795788188
Riso17851 a_58313_15032.t19 a_58313_15032.t41 1313.08214442253
Riso17852 a_58313_15032.t19 a_58313_15032.t42 1562.69335754035
Riso17853 a_58313_15032.t19 a_58313_15032.t43 1845.85824193448
Riso17854 a_58313_15032.t19 a_58313_15032.t44 2157.66950838343
Riso17855 a_58313_15032.t19 a_58313_15032.t45 2486.46669144503
Riso17856 a_58313_15032.t19 a_58313_15032.t46 2811.77568826131
Riso17857 a_58313_15032.t19 a_58313_15032.t47 3103.99070872554
Riso17858 a_58313_15032.t19 a_58313_15032.t48 3327.73183420258
Riso17859 a_58313_15032.t19 a_58313_15032.t49 3449.82127434342
Riso17860 a_58313_15032.t19 a_58313_15032.t5 1859.32561256712
Riso17861 a_58313_15032.t19 a_58313_15032.t50 3226.42659436324
Riso17862 a_58313_15032.t19 a_58313_15032.t51 3112.24310912274
Riso17863 a_58313_15032.t19 a_58313_15032.t52 2902.99043772767
Riso17864 a_58313_15032.t19 a_58313_15032.t53 2629.69792825482
Riso17865 a_58313_15032.t19 a_58313_15032.t54 2325.45445729025
Riso17866 a_58313_15032.t19 a_58313_15032.t55 2017.94867910073
Riso17867 a_58313_15032.t19 a_58313_15032.t56 1726.32888709153
Riso17868 a_58313_15032.t19 a_58313_15032.t57 1461.50046818369
Riso17869 a_58313_15032.t19 a_58313_15032.t58 1228.05293794666
Riso17870 a_58313_15032.t19 a_58313_15032.t59 1026.43835179819
Riso17871 a_58313_15032.t19 a_58313_15032.t6 18.770768325182
Riso17872 a_58313_15032.t19 a_58313_15032.t60 1026.43835179819
Riso17873 a_58313_15032.t19 a_58313_15032.t61 1228.05293794666
Riso17874 a_58313_15032.t19 a_58313_15032.t62 1461.50046818369
Riso17875 a_58313_15032.t19 a_58313_15032.t63 1726.32888709153
Riso17876 a_58313_15032.t19 a_58313_15032.t64 2017.94867910073
Riso17877 a_58313_15032.t19 a_58313_15032.t65 2325.45445729025
Riso17878 a_58313_15032.t19 a_58313_15032.t66 2629.69792825482
Riso17879 a_58313_15032.t19 a_58313_15032.t67 2902.99043772767
Riso17880 a_58313_15032.t19 a_58313_15032.t68 3112.24310912274
Riso17881 a_58313_15032.t19 a_58313_15032.t69 3226.42659436324
Riso17882 a_58313_15032.t19 a_58313_15032.t7 232226.907981954
Riso17883 a_58313_15032.t19 a_58313_15032.t70 2851.42853724866
Riso17884 a_58313_15032.t19 a_58313_15032.t71 2750.51626208142
Riso17885 a_58313_15032.t19 a_58313_15032.t72 2565.58441216616
Riso17886 a_58313_15032.t19 a_58313_15032.t73 2324.05588587373
Riso17887 a_58313_15032.t19 a_58313_15032.t74 2055.17373715368
Riso17888 a_58313_15032.t19 a_58313_15032.t75 1783.40844956576
Riso17889 a_58313_15032.t19 a_58313_15032.t76 1525.68276678893
Riso17890 a_58313_15032.t19 a_58313_15032.t77 1291.63457475273
Riso17891 a_58313_15032.t19 a_58313_15032.t78 1085.31996315393
Riso17892 a_58313_15032.t19 a_58313_15032.t79 907.138446340958
Riso17893 a_58313_15032.t19 a_58313_15032.t8 232226.907981954
Riso17894 a_58313_15032.t19 a_58313_15032.t80 907.138446340958
Riso17895 a_58313_15032.t19 a_58313_15032.t81 1085.31996315393
Riso17896 a_58313_15032.t19 a_58313_15032.t82 1291.63457475273
Riso17897 a_58313_15032.t19 a_58313_15032.t83 1525.68276678893
Riso17898 a_58313_15032.t19 a_58313_15032.t84 1783.40844956576
Riso17899 a_58313_15032.t19 a_58313_15032.t85 2055.17373715368
Riso17900 a_58313_15032.t19 a_58313_15032.t86 2324.05588587373
Riso17901 a_58313_15032.t19 a_58313_15032.t87 2565.58441216616
Riso17902 a_58313_15032.t19 a_58313_15032.t88 2750.51626208142
Riso17903 a_58313_15032.t19 a_58313_15032.t89 2851.42853724866
Riso17904 a_58313_15032.t19 a_58313_15032.t9 352820.446051764
Riso17905 a_58313_15032.t19 a_58313_15032.t90 2410.0433548467
Riso17906 a_58313_15032.t19 a_58313_15032.t91 2324.75173522087
Riso17907 a_58313_15032.t19 a_58313_15032.t92 2168.4463008866
Riso17908 a_58313_15032.t19 a_58313_15032.t93 1964.30503899174
Riso17909 a_58313_15032.t19 a_58313_15032.t94 1737.04434236387
Riso17910 a_58313_15032.t19 a_58313_15032.t95 1507.34680063231
Riso17911 a_58313_15032.t19 a_58313_15032.t96 1289.51561144566
Riso17912 a_58313_15032.t19 a_58313_15032.t97 1091.69676992034
Riso17913 a_58313_15032.t19 a_58313_15032.t98 917.318505763941
Riso17914 a_58313_15032.t19 a_58313_15032.t99 766.718490739204
Riso17915 a_58313_15032.t2 a_58313_15032.t20 219.257289863757
Riso17916 a_58313_15032.t2 a_58313_15032.t21 108.338080073898
Riso17917 a_58313_15032.t2 a_58313_15032.t22 219.257289863757
Riso17918 a_58313_15032.t2 a_58313_15032.t23 108.338080073898
Riso17919 a_58313_15032.t2 a_58313_15032.t24 53.4956101406176
Riso17920 a_58313_15032.t2 a_58313_15032.t25 62957.5888366032
Riso17921 a_58313_15032.t2 a_58313_15032.t26 25.842275227707
Riso17922 a_58313_15032.t2 a_58313_15032.t27 442.527265291983
Riso17923 a_58313_15032.t2 a_58313_15032.t28 25.842275227707
Riso17924 a_58313_15032.t2 a_58313_15032.t29 0.815877850236953
Riso17925 a_58313_15032.t2 a_58313_15032.t3 22327.1803124643
Riso17926 a_58313_15032.t2 a_58313_15032.t30 120439736.498004
Riso17927 a_58313_15032.t2 a_58313_15032.t31 116177364.963249
Riso17928 a_58313_15032.t2 a_58313_15032.t32 87158808.1200701
Riso17929 a_58313_15032.t2 a_58313_15032.t33 67750458.0470502
Riso17930 a_58313_15032.t2 a_58313_15032.t34 53797183.3860548
Riso17931 a_58313_15032.t2 a_58313_15032.t35 43292614.9716302
Riso17932 a_58313_15032.t2 a_58313_15032.t36 35141463.3392136
Riso17933 a_58313_15032.t2 a_58313_15032.t37 28687598.9266259
Riso17934 a_58313_15032.t2 a_58313_15032.t38 23507797.9390091
Riso17935 a_58313_15032.t2 a_58313_15032.t39 19312234.279445
Riso17936 a_58313_15032.t2 a_58313_15032.t4 73.0699962580074
Riso17937 a_58313_15032.t2 a_58313_15032.t40 19187553.4146872
Riso17938 a_58313_15032.t2 a_58313_15032.t41 22956401.9131157
Riso17939 a_58313_15032.t2 a_58313_15032.t42 27320314.2202724
Riso17940 a_58313_15032.t2 a_58313_15032.t43 32270839.9139192
Riso17941 a_58313_15032.t2 a_58313_15032.t44 37722185.6534409
Riso17942 a_58313_15032.t2 a_58313_15032.t45 43470493.4149344
Riso17943 a_58313_15032.t2 a_58313_15032.t46 49157817.7827112
Riso17944 a_58313_15032.t2 a_58313_15032.t47 54266565.5357136
Riso17945 a_58313_15032.t2 a_58313_15032.t48 58178195.3014223
Riso17946 a_58313_15032.t2 a_58313_15032.t49 60312665.1585638
Riso17947 a_58313_15032.t2 a_58313_15032.t5 442.527265291983
Riso17948 a_58313_15032.t2 a_58313_15032.t50 56407092.2432209
Riso17949 a_58313_15032.t2 a_58313_15032.t51 54410840.911836
Riso17950 a_58313_15032.t2 a_58313_15032.t52 50752510.4362123
Riso17951 a_58313_15032.t2 a_58313_15032.t53 45974581.8702412
Riso17952 a_58313_15032.t2 a_58313_15032.t54 40655542.670317
Riso17953 a_58313_15032.t2 a_58313_15032.t55 35279469.0829115
Riso17954 a_58313_15032.t2 a_58313_15032.t56 30181127.6123352
Riso17955 a_58313_15032.t2 a_58313_15032.t57 25551175.3673163
Riso17956 a_58313_15032.t2 a_58313_15032.t58 21469850.1033113
Riso17957 a_58313_15032.t2 a_58313_15032.t59 17945055.031784
Riso17958 a_58313_15032.t2 a_58313_15032.t6 40394.5788141173
Riso17959 a_58313_15032.t2 a_58313_15032.t60 17945055.031784
Riso17960 a_58313_15032.t2 a_58313_15032.t61 21469850.1033113
Riso17961 a_58313_15032.t2 a_58313_15032.t62 25551175.3673163
Riso17962 a_58313_15032.t2 a_58313_15032.t63 30181127.6123352
Riso17963 a_58313_15032.t2 a_58313_15032.t64 35279469.0829115
Riso17964 a_58313_15032.t2 a_58313_15032.t65 40655542.670317
Riso17965 a_58313_15032.t2 a_58313_15032.t66 45974581.8702412
Riso17966 a_58313_15032.t2 a_58313_15032.t67 50752510.4362123
Riso17967 a_58313_15032.t2 a_58313_15032.t68 54410840.911836
Riso17968 a_58313_15032.t2 a_58313_15032.t69 56407092.2432209
Riso17969 a_58313_15032.t2 a_58313_15032.t7 48.0947730981568
Riso17970 a_58313_15032.t2 a_58313_15032.t70 49851062.1027412
Riso17971 a_58313_15032.t2 a_58313_15032.t71 48086829.1820927
Riso17972 a_58313_15032.t2 a_58313_15032.t72 44853695.6791938
Riso17973 a_58313_15032.t2 a_58313_15032.t73 40631091.6733417
Riso17974 a_58313_15032.t2 a_58313_15032.t74 35930268.728259
Riso17975 a_58313_15032.t2 a_58313_15032.t75 31179040.3345126
Riso17976 a_58313_15032.t2 a_58313_15032.t76 26673264.0719323
Riso17977 a_58313_15032.t2 a_58313_15032.t77 22581437.5352276
Riso17978 a_58313_15032.t2 a_58313_15032.t78 18974472.6819409
Riso17979 a_58313_15032.t2 a_58313_15032.t79 15859354.1565526
Riso17980 a_58313_15032.t2 a_58313_15032.t8 48.0947730981568
Riso17981 a_58313_15032.t2 a_58313_15032.t80 15859354.1565526
Riso17982 a_58313_15032.t2 a_58313_15032.t81 18974472.6819409
Riso17983 a_58313_15032.t2 a_58313_15032.t82 22581437.5352276
Riso17984 a_58313_15032.t2 a_58313_15032.t83 26673264.0719323
Riso17985 a_58313_15032.t2 a_58313_15032.t84 31179040.3345126
Riso17986 a_58313_15032.t2 a_58313_15032.t85 35930268.728259
Riso17987 a_58313_15032.t2 a_58313_15032.t86 40631091.6733417
Riso17988 a_58313_15032.t2 a_58313_15032.t87 44853695.6791938
Riso17989 a_58313_15032.t2 a_58313_15032.t88 48086829.1820927
Riso17990 a_58313_15032.t2 a_58313_15032.t89 49851062.1027412
Riso17991 a_58313_15032.t2 a_58313_15032.t9 73.0699962580074
Riso17992 a_58313_15032.t2 a_58313_15032.t90 42134396.6307807
Riso17993 a_58313_15032.t2 a_58313_15032.t91 40643257.0944858
Riso17994 a_58313_15032.t2 a_58313_15032.t92 37910594.5668421
Riso17995 a_58313_15032.t2 a_58313_15032.t93 34341626.0335214
Riso17996 a_58313_15032.t2 a_58313_15032.t94 30368464.1768896
Riso17997 a_58313_15032.t2 a_58313_15032.t95 26352699.3530038
Riso17998 a_58313_15032.t2 a_58313_15032.t96 22544392.0438067
Riso17999 a_58313_15032.t2 a_58313_15032.t97 19085957.3591745
Riso18000 a_58313_15032.t2 a_58313_15032.t98 16037330.4824102
Riso18001 a_58313_15032.t2 a_58313_15032.t99 13404414.8741109
Riso18002 a_58313_15032.t20 a_58313_15032.t21 26.5663704570244
Riso18003 a_58313_15032.t20 a_58313_15032.t22 0.816179909091945
Riso18004 a_58313_15032.t20 a_58313_15032.t23 26.5663704570244
Riso18005 a_58313_15032.t20 a_58313_15032.t24 53.7959242294991
Riso18006 a_58313_15032.t20 a_58313_15032.t25 3766.20286382212
Riso18007 a_58313_15032.t20 a_58313_15032.t26 434.561614569868
Riso18008 a_58313_15032.t20 a_58313_15032.t27 26.4725426221065
Riso18009 a_58313_15032.t20 a_58313_15032.t28 434.561614569868
Riso18010 a_58313_15032.t20 a_58313_15032.t29 219.257289863757
Riso18011 a_58313_15032.t20 a_58313_15032.t3 1335.64026176598
Riso18012 a_58313_15032.t20 a_58313_15032.t30 7204857.887649
Riso18013 a_58313_15032.t20 a_58313_15032.t31 6949877.41305476
Riso18014 a_58313_15032.t20 a_58313_15032.t32 5213950.51518051
Riso18015 a_58313_15032.t20 a_58313_15032.t33 4052918.38263207
Riso18016 a_58313_15032.t20 a_58313_15032.t34 3218215.78427931
Riso18017 a_58313_15032.t20 a_58313_15032.t35 2589819.1703572
Riso18018 a_58313_15032.t20 a_58313_15032.t36 2102206.93506131
Riso18019 a_58313_15032.t20 a_58313_15032.t37 1716128.57528658
Riso18020 a_58313_15032.t20 a_58313_15032.t38 1406266.30651036
Riso18021 a_58313_15032.t20 a_58313_15032.t39 1155282.36379603
Riso18022 a_58313_15032.t20 a_58313_15032.t4 1228.73915979539
Riso18023 a_58313_15032.t20 a_58313_15032.t40 1147823.79623345
Riso18024 a_58313_15032.t20 a_58313_15032.t41 1373281.09646349
Riso18025 a_58313_15032.t20 a_58313_15032.t42 1634335.86892845
Riso18026 a_58313_15032.t20 a_58313_15032.t43 1930482.59864561
Riso18027 a_58313_15032.t20 a_58313_15032.t44 2256589.01909884
Riso18028 a_58313_15032.t20 a_58313_15032.t45 2600460.08458159
Riso18029 a_58313_15032.t20 a_58313_15032.t46 2940683.04605805
Riso18030 a_58313_15032.t20 a_58313_15032.t47 3246294.82016583
Riso18031 a_58313_15032.t20 a_58313_15032.t48 3480293.47700859
Riso18032 a_58313_15032.t20 a_58313_15032.t49 3607980.17272325
Riso18033 a_58313_15032.t20 a_58313_15032.t5 26.4725426221065
Riso18034 a_58313_15032.t20 a_58313_15032.t50 3374343.84435613
Riso18035 a_58313_15032.t20 a_58313_15032.t51 3254925.55626567
Riso18036 a_58313_15032.t20 a_58313_15032.t52 3036079.5844185
Riso18037 a_58313_15032.t20 a_58313_15032.t53 2750257.83392229
Riso18038 a_58313_15032.t20 a_58313_15032.t54 2432066.15857831
Riso18039 a_58313_15032.t20 a_58313_15032.t55 2110462.61379272
Riso18040 a_58313_15032.t20 a_58313_15032.t56 1805473.35670631
Riso18041 a_58313_15032.t20 a_58313_15032.t57 1528503.73752655
Riso18042 a_58313_15032.t20 a_58313_15032.t58 1284353.68061477
Riso18043 a_58313_15032.t20 a_58313_15032.t59 1073495.96611071
Riso18044 a_58313_15032.t20 a_58313_15032.t6 2416.45496951063
Riso18045 a_58313_15032.t20 a_58313_15032.t60 1073495.96611071
Riso18046 a_58313_15032.t20 a_58313_15032.t61 1284353.68061477
Riso18047 a_58313_15032.t20 a_58313_15032.t62 1528503.73752655
Riso18048 a_58313_15032.t20 a_58313_15032.t63 1805473.35670631
Riso18049 a_58313_15032.t20 a_58313_15032.t64 2110462.61379272
Riso18050 a_58313_15032.t20 a_58313_15032.t65 2432066.15857831
Riso18051 a_58313_15032.t20 a_58313_15032.t66 2750257.83392229
Riso18052 a_58313_15032.t20 a_58313_15032.t67 3036079.5844185
Riso18053 a_58313_15032.t20 a_58313_15032.t68 3254925.55626567
Riso18054 a_58313_15032.t20 a_58313_15032.t69 3374343.84435613
Riso18055 a_58313_15032.t20 a_58313_15032.t7 808.757822821198
Riso18056 a_58313_15032.t20 a_58313_15032.t70 2982153.80108016
Riso18057 a_58313_15032.t20 a_58313_15032.t71 2876615.14877503
Riso18058 a_58313_15032.t20 a_58313_15032.t72 2683204.99945467
Riso18059 a_58313_15032.t20 a_58313_15032.t73 2430603.46890843
Riso18060 a_58313_15032.t20 a_58313_15032.t74 2149394.27450869
Riso18061 a_58313_15032.t20 a_58313_15032.t75 1865169.76220022
Riso18062 a_58313_15032.t20 a_58313_15032.t76 1595628.50788195
Riso18063 a_58313_15032.t20 a_58313_15032.t77 1350850.25151009
Riso18064 a_58313_15032.t20 a_58313_15032.t78 1135077.03637934
Riso18065 a_58313_15032.t20 a_58313_15032.t79 948726.692786738
Riso18066 a_58313_15032.t20 a_58313_15032.t8 808.757822821198
Riso18067 a_58313_15032.t20 a_58313_15032.t80 948726.692786738
Riso18068 a_58313_15032.t20 a_58313_15032.t81 1135077.03637934
Riso18069 a_58313_15032.t20 a_58313_15032.t82 1350850.25151009
Riso18070 a_58313_15032.t20 a_58313_15032.t83 1595628.50788195
Riso18071 a_58313_15032.t20 a_58313_15032.t84 1865169.76220022
Riso18072 a_58313_15032.t20 a_58313_15032.t85 2149394.27450869
Riso18073 a_58313_15032.t20 a_58313_15032.t86 2430603.46890843
Riso18074 a_58313_15032.t20 a_58313_15032.t87 2683204.99945467
Riso18075 a_58313_15032.t20 a_58313_15032.t88 2876615.14877503
Riso18076 a_58313_15032.t20 a_58313_15032.t89 2982153.80108016
Riso18077 a_58313_15032.t20 a_58313_15032.t9 1228.73915979539
Riso18078 a_58313_15032.t20 a_58313_15032.t90 2520533.07931011
Riso18079 a_58313_15032.t20 a_58313_15032.t91 2431331.21984043
Riso18080 a_58313_15032.t20 a_58313_15032.t92 2267859.87940867
Riso18081 a_58313_15032.t20 a_58313_15032.t93 2054359.6523595
Riso18082 a_58313_15032.t20 a_58313_15032.t94 1816680.06774721
Riso18083 a_58313_15032.t20 a_58313_15032.t95 1576451.91956626
Riso18084 a_58313_15032.t20 a_58313_15032.t96 1348634.14319878
Riso18085 a_58313_15032.t20 a_58313_15032.t97 1141746.1912569
Riso18086 a_58313_15032.t20 a_58313_15032.t98 959373.462469684
Riso18087 a_58313_15032.t20 a_58313_15032.t99 801869.109342147
Riso18088 a_58313_15032.t21 a_58313_15032.t22 26.5663704570244
Riso18089 a_58313_15032.t21 a_58313_15032.t23 0.816220784565558
Riso18090 a_58313_15032.t21 a_58313_15032.t24 26.5813152686799
Riso18091 a_58313_15032.t21 a_58313_15032.t25 7628.27374703719
Riso18092 a_58313_15032.t21 a_58313_15032.t26 214.722945018464
Riso18093 a_58313_15032.t21 a_58313_15032.t27 53.618939075576
Riso18094 a_58313_15032.t21 a_58313_15032.t28 214.722945018464
Riso18095 a_58313_15032.t21 a_58313_15032.t29 108.338080073898
Riso18096 a_58313_15032.t21 a_58313_15032.t3 2705.2790071896
Riso18097 a_58313_15032.t21 a_58313_15032.t30 14593114.1424788
Riso18098 a_58313_15032.t21 a_58313_15032.t31 14076662.7109751
Riso18099 a_58313_15032.t21 a_58313_15032.t32 10560621.2069359
Riso18100 a_58313_15032.t21 a_58313_15032.t33 8209003.07683927
Riso18101 a_58313_15032.t21 a_58313_15032.t34 6518350.6749832
Riso18102 a_58313_15032.t21 a_58313_15032.t35 5245561.72387388
Riso18103 a_58313_15032.t21 a_58313_15032.t36 4257925.17116124
Riso18104 a_58313_15032.t21 a_58313_15032.t37 3475940.89610817
Riso18105 a_58313_15032.t21 a_58313_15032.t38 2848328.8699986
Riso18106 a_58313_15032.t21 a_58313_15032.t39 2339972.23325795
Riso18107 a_58313_15032.t21 a_58313_15032.t4 607.137129016626
Riso18108 a_58313_15032.t21 a_58313_15032.t40 2324865.24163128
Riso18109 a_58313_15032.t21 a_58313_15032.t41 2781518.81729057
Riso18110 a_58313_15032.t21 a_58313_15032.t42 3310273.46470017
Riso18111 a_58313_15032.t21 a_58313_15032.t43 3910105.28610123
Riso18112 a_58313_15032.t21 a_58313_15032.t44 4570619.10753651
Riso18113 a_58313_15032.t21 a_58313_15032.t45 5267114.41488852
Riso18114 a_58313_15032.t21 a_58313_15032.t46 5956220.6523938
Riso18115 a_58313_15032.t21 a_58313_15032.t47 6575223.49358594
Riso18116 a_58313_15032.t21 a_58313_15032.t48 7049177.20117356
Riso18117 a_58313_15032.t21 a_58313_15032.t49 7307800.83457434
Riso18118 a_58313_15032.t21 a_58313_15032.t5 53.618939075576
Riso18119 a_58313_15032.t21 a_58313_15032.t50 6834581.00694447
Riso18120 a_58313_15032.t21 a_58313_15032.t51 6592704.65962734
Riso18121 a_58313_15032.t21 a_58313_15032.t52 6149442.03091368
Riso18122 a_58313_15032.t21 a_58313_15032.t53 5570522.98845146
Riso18123 a_58313_15032.t21 a_58313_15032.t54 4926040.12565393
Riso18124 a_58313_15032.t21 a_58313_15032.t55 4274646.67544762
Riso18125 a_58313_15032.t21 a_58313_15032.t56 3656904.7143575
Riso18126 a_58313_15032.t21 a_58313_15032.t57 3095915.26394546
Riso18127 a_58313_15032.t21 a_58313_15032.t58 2601400.35414911
Riso18128 a_58313_15032.t21 a_58313_15032.t59 2174317.57978172
Riso18129 a_58313_15032.t21 a_58313_15032.t6 4894.42036749674
Riso18130 a_58313_15032.t21 a_58313_15032.t60 2174317.57978172
Riso18131 a_58313_15032.t21 a_58313_15032.t61 2601400.35414911
Riso18132 a_58313_15032.t21 a_58313_15032.t62 3095915.26394546
Riso18133 a_58313_15032.t21 a_58313_15032.t63 3656904.7143575
Riso18134 a_58313_15032.t21 a_58313_15032.t64 4274646.67544762
Riso18135 a_58313_15032.t21 a_58313_15032.t65 4926040.12565393
Riso18136 a_58313_15032.t21 a_58313_15032.t66 5570522.98845146
Riso18137 a_58313_15032.t21 a_58313_15032.t67 6149442.03091368
Riso18138 a_58313_15032.t21 a_58313_15032.t68 6592704.65962734
Riso18139 a_58313_15032.t21 a_58313_15032.t69 6834581.00694447
Riso18140 a_58313_15032.t21 a_58313_15032.t7 399.618502188182
Riso18141 a_58313_15032.t21 a_58313_15032.t70 6040217.79307993
Riso18142 a_58313_15032.t21 a_58313_15032.t71 5826454.02097663
Riso18143 a_58313_15032.t21 a_58313_15032.t72 5434710.50162362
Riso18144 a_58313_15032.t21 a_58313_15032.t73 4923077.51381059
Riso18145 a_58313_15032.t21 a_58313_15032.t74 4353500.99533064
Riso18146 a_58313_15032.t21 a_58313_15032.t75 3777817.0866559
Riso18147 a_58313_15032.t21 a_58313_15032.t76 3231873.45366402
Riso18148 a_58313_15032.t21 a_58313_15032.t77 2736086.15424273
Riso18149 a_58313_15032.t21 a_58313_15032.t78 2299047.25543384
Riso18150 a_58313_15032.t21 a_58313_15032.t79 1921603.05362677
Riso18151 a_58313_15032.t21 a_58313_15032.t8 399.618502188182
Riso18152 a_58313_15032.t21 a_58313_15032.t80 1921603.05362677
Riso18153 a_58313_15032.t21 a_58313_15032.t81 2299047.25543384
Riso18154 a_58313_15032.t21 a_58313_15032.t82 2736086.15424273
Riso18155 a_58313_15032.t21 a_58313_15032.t83 3231873.45366402
Riso18156 a_58313_15032.t21 a_58313_15032.t84 3777817.0866559
Riso18157 a_58313_15032.t21 a_58313_15032.t85 4353500.99533064
Riso18158 a_58313_15032.t21 a_58313_15032.t86 4923077.51381059
Riso18159 a_58313_15032.t21 a_58313_15032.t87 5434710.50162362
Riso18160 a_58313_15032.t21 a_58313_15032.t88 5826454.02097663
Riso18161 a_58313_15032.t21 a_58313_15032.t89 6040217.79307993
Riso18162 a_58313_15032.t21 a_58313_15032.t9 607.137129016626
Riso18163 a_58313_15032.t21 a_58313_15032.t90 5105225.87674084
Riso18164 a_58313_15032.t21 a_58313_15032.t91 4924551.54044424
Riso18165 a_58313_15032.t21 a_58313_15032.t92 4593447.72588681
Riso18166 a_58313_15032.t21 a_58313_15032.t93 4161012.66174562
Riso18167 a_58313_15032.t21 a_58313_15032.t94 3679603.40126179
Riso18168 a_58313_15032.t21 a_58313_15032.t95 3193032.14041145
Riso18169 a_58313_15032.t21 a_58313_15032.t96 2731597.52697992
Riso18170 a_58313_15032.t21 a_58313_15032.t97 2312555.32733197
Riso18171 a_58313_15032.t21 a_58313_15032.t98 1943167.60460817
Riso18172 a_58313_15032.t21 a_58313_15032.t99 1624149.65325238
Riso18173 a_58313_15032.t22 a_58313_15032.t23 26.5663704570244
Riso18174 a_58313_15032.t22 a_58313_15032.t24 53.7959242294991
Riso18175 a_58313_15032.t22 a_58313_15032.t25 3766.20286382212
Riso18176 a_58313_15032.t22 a_58313_15032.t26 434.561614569868
Riso18177 a_58313_15032.t22 a_58313_15032.t27 26.4725426221065
Riso18178 a_58313_15032.t22 a_58313_15032.t28 434.561614569868
Riso18179 a_58313_15032.t22 a_58313_15032.t29 219.257289863757
Riso18180 a_58313_15032.t22 a_58313_15032.t3 1335.64026176598
Riso18181 a_58313_15032.t22 a_58313_15032.t30 7204857.887649
Riso18182 a_58313_15032.t22 a_58313_15032.t31 6949877.41305476
Riso18183 a_58313_15032.t22 a_58313_15032.t32 5213950.51518051
Riso18184 a_58313_15032.t22 a_58313_15032.t33 4052918.38263207
Riso18185 a_58313_15032.t22 a_58313_15032.t34 3218215.78427931
Riso18186 a_58313_15032.t22 a_58313_15032.t35 2589819.1703572
Riso18187 a_58313_15032.t22 a_58313_15032.t36 2102206.93506131
Riso18188 a_58313_15032.t22 a_58313_15032.t37 1716128.57528658
Riso18189 a_58313_15032.t22 a_58313_15032.t38 1406266.30651036
Riso18190 a_58313_15032.t22 a_58313_15032.t39 1155282.36379603
Riso18191 a_58313_15032.t22 a_58313_15032.t4 1228.73915979539
Riso18192 a_58313_15032.t22 a_58313_15032.t40 1147823.79623345
Riso18193 a_58313_15032.t22 a_58313_15032.t41 1373281.09646349
Riso18194 a_58313_15032.t22 a_58313_15032.t42 1634335.86892845
Riso18195 a_58313_15032.t22 a_58313_15032.t43 1930482.59864561
Riso18196 a_58313_15032.t22 a_58313_15032.t44 2256589.01909884
Riso18197 a_58313_15032.t22 a_58313_15032.t45 2600460.08458159
Riso18198 a_58313_15032.t22 a_58313_15032.t46 2940683.04605805
Riso18199 a_58313_15032.t22 a_58313_15032.t47 3246294.82016583
Riso18200 a_58313_15032.t22 a_58313_15032.t48 3480293.47700859
Riso18201 a_58313_15032.t22 a_58313_15032.t49 3607980.17272325
Riso18202 a_58313_15032.t22 a_58313_15032.t5 26.4725426221065
Riso18203 a_58313_15032.t22 a_58313_15032.t50 3374343.84435613
Riso18204 a_58313_15032.t22 a_58313_15032.t51 3254925.55626567
Riso18205 a_58313_15032.t22 a_58313_15032.t52 3036079.5844185
Riso18206 a_58313_15032.t22 a_58313_15032.t53 2750257.83392229
Riso18207 a_58313_15032.t22 a_58313_15032.t54 2432066.15857831
Riso18208 a_58313_15032.t22 a_58313_15032.t55 2110462.61379272
Riso18209 a_58313_15032.t22 a_58313_15032.t56 1805473.35670631
Riso18210 a_58313_15032.t22 a_58313_15032.t57 1528503.73752655
Riso18211 a_58313_15032.t22 a_58313_15032.t58 1284353.68061477
Riso18212 a_58313_15032.t22 a_58313_15032.t59 1073495.96611071
Riso18213 a_58313_15032.t22 a_58313_15032.t6 2416.45496951063
Riso18214 a_58313_15032.t22 a_58313_15032.t60 1073495.96611071
Riso18215 a_58313_15032.t22 a_58313_15032.t61 1284353.68061477
Riso18216 a_58313_15032.t22 a_58313_15032.t62 1528503.73752655
Riso18217 a_58313_15032.t22 a_58313_15032.t63 1805473.35670631
Riso18218 a_58313_15032.t22 a_58313_15032.t64 2110462.61379272
Riso18219 a_58313_15032.t22 a_58313_15032.t65 2432066.15857831
Riso18220 a_58313_15032.t22 a_58313_15032.t66 2750257.83392229
Riso18221 a_58313_15032.t22 a_58313_15032.t67 3036079.5844185
Riso18222 a_58313_15032.t22 a_58313_15032.t68 3254925.55626567
Riso18223 a_58313_15032.t22 a_58313_15032.t69 3374343.84435613
Riso18224 a_58313_15032.t22 a_58313_15032.t7 808.757822821198
Riso18225 a_58313_15032.t22 a_58313_15032.t70 2982153.80108016
Riso18226 a_58313_15032.t22 a_58313_15032.t71 2876615.14877503
Riso18227 a_58313_15032.t22 a_58313_15032.t72 2683204.99945467
Riso18228 a_58313_15032.t22 a_58313_15032.t73 2430603.46890843
Riso18229 a_58313_15032.t22 a_58313_15032.t74 2149394.27450869
Riso18230 a_58313_15032.t22 a_58313_15032.t75 1865169.76220022
Riso18231 a_58313_15032.t22 a_58313_15032.t76 1595628.50788195
Riso18232 a_58313_15032.t22 a_58313_15032.t77 1350850.25151009
Riso18233 a_58313_15032.t22 a_58313_15032.t78 1135077.03637934
Riso18234 a_58313_15032.t22 a_58313_15032.t79 948726.692786738
Riso18235 a_58313_15032.t22 a_58313_15032.t8 808.757822821198
Riso18236 a_58313_15032.t22 a_58313_15032.t80 948726.692786738
Riso18237 a_58313_15032.t22 a_58313_15032.t81 1135077.03637934
Riso18238 a_58313_15032.t22 a_58313_15032.t82 1350850.25151009
Riso18239 a_58313_15032.t22 a_58313_15032.t83 1595628.50788195
Riso18240 a_58313_15032.t22 a_58313_15032.t84 1865169.76220022
Riso18241 a_58313_15032.t22 a_58313_15032.t85 2149394.27450869
Riso18242 a_58313_15032.t22 a_58313_15032.t86 2430603.46890843
Riso18243 a_58313_15032.t22 a_58313_15032.t87 2683204.99945467
Riso18244 a_58313_15032.t22 a_58313_15032.t88 2876615.14877503
Riso18245 a_58313_15032.t22 a_58313_15032.t89 2982153.80108016
Riso18246 a_58313_15032.t22 a_58313_15032.t9 1228.73915979539
Riso18247 a_58313_15032.t22 a_58313_15032.t90 2520533.07931011
Riso18248 a_58313_15032.t22 a_58313_15032.t91 2431331.21984043
Riso18249 a_58313_15032.t22 a_58313_15032.t92 2267859.87940867
Riso18250 a_58313_15032.t22 a_58313_15032.t93 2054359.6523595
Riso18251 a_58313_15032.t22 a_58313_15032.t94 1816680.06774721
Riso18252 a_58313_15032.t22 a_58313_15032.t95 1576451.91956626
Riso18253 a_58313_15032.t22 a_58313_15032.t96 1348634.14319878
Riso18254 a_58313_15032.t22 a_58313_15032.t97 1141746.1912569
Riso18255 a_58313_15032.t22 a_58313_15032.t98 959373.462469684
Riso18256 a_58313_15032.t22 a_58313_15032.t99 801869.109342147
Riso18257 a_58313_15032.t23 a_58313_15032.t24 26.5813152686799
Riso18258 a_58313_15032.t23 a_58313_15032.t25 7628.27374703719
Riso18259 a_58313_15032.t23 a_58313_15032.t26 214.722945018464
Riso18260 a_58313_15032.t23 a_58313_15032.t27 53.618939075576
Riso18261 a_58313_15032.t23 a_58313_15032.t28 214.722945018464
Riso18262 a_58313_15032.t23 a_58313_15032.t29 108.338080073898
Riso18263 a_58313_15032.t23 a_58313_15032.t3 2705.2790071896
Riso18264 a_58313_15032.t23 a_58313_15032.t30 14593114.1424788
Riso18265 a_58313_15032.t23 a_58313_15032.t31 14076662.7109751
Riso18266 a_58313_15032.t23 a_58313_15032.t32 10560621.2069359
Riso18267 a_58313_15032.t23 a_58313_15032.t33 8209003.07683927
Riso18268 a_58313_15032.t23 a_58313_15032.t34 6518350.6749832
Riso18269 a_58313_15032.t23 a_58313_15032.t35 5245561.72387388
Riso18270 a_58313_15032.t23 a_58313_15032.t36 4257925.17116124
Riso18271 a_58313_15032.t23 a_58313_15032.t37 3475940.89610817
Riso18272 a_58313_15032.t23 a_58313_15032.t38 2848328.8699986
Riso18273 a_58313_15032.t23 a_58313_15032.t39 2339972.23325795
Riso18274 a_58313_15032.t23 a_58313_15032.t4 607.137129016626
Riso18275 a_58313_15032.t23 a_58313_15032.t40 2324865.24163128
Riso18276 a_58313_15032.t23 a_58313_15032.t41 2781518.81729057
Riso18277 a_58313_15032.t23 a_58313_15032.t42 3310273.46470017
Riso18278 a_58313_15032.t23 a_58313_15032.t43 3910105.28610123
Riso18279 a_58313_15032.t23 a_58313_15032.t44 4570619.10753651
Riso18280 a_58313_15032.t23 a_58313_15032.t45 5267114.41488852
Riso18281 a_58313_15032.t23 a_58313_15032.t46 5956220.6523938
Riso18282 a_58313_15032.t23 a_58313_15032.t47 6575223.49358594
Riso18283 a_58313_15032.t23 a_58313_15032.t48 7049177.20117356
Riso18284 a_58313_15032.t23 a_58313_15032.t49 7307800.83457434
Riso18285 a_58313_15032.t23 a_58313_15032.t5 53.618939075576
Riso18286 a_58313_15032.t23 a_58313_15032.t50 6834581.00694447
Riso18287 a_58313_15032.t23 a_58313_15032.t51 6592704.65962734
Riso18288 a_58313_15032.t23 a_58313_15032.t52 6149442.03091368
Riso18289 a_58313_15032.t23 a_58313_15032.t53 5570522.98845146
Riso18290 a_58313_15032.t23 a_58313_15032.t54 4926040.12565393
Riso18291 a_58313_15032.t23 a_58313_15032.t55 4274646.67544762
Riso18292 a_58313_15032.t23 a_58313_15032.t56 3656904.7143575
Riso18293 a_58313_15032.t23 a_58313_15032.t57 3095915.26394546
Riso18294 a_58313_15032.t23 a_58313_15032.t58 2601400.35414911
Riso18295 a_58313_15032.t23 a_58313_15032.t59 2174317.57978172
Riso18296 a_58313_15032.t23 a_58313_15032.t6 4894.42036749674
Riso18297 a_58313_15032.t23 a_58313_15032.t60 2174317.57978172
Riso18298 a_58313_15032.t23 a_58313_15032.t61 2601400.35414911
Riso18299 a_58313_15032.t23 a_58313_15032.t62 3095915.26394546
Riso18300 a_58313_15032.t23 a_58313_15032.t63 3656904.7143575
Riso18301 a_58313_15032.t23 a_58313_15032.t64 4274646.67544762
Riso18302 a_58313_15032.t23 a_58313_15032.t65 4926040.12565393
Riso18303 a_58313_15032.t23 a_58313_15032.t66 5570522.98845146
Riso18304 a_58313_15032.t23 a_58313_15032.t67 6149442.03091368
Riso18305 a_58313_15032.t23 a_58313_15032.t68 6592704.65962734
Riso18306 a_58313_15032.t23 a_58313_15032.t69 6834581.00694447
Riso18307 a_58313_15032.t23 a_58313_15032.t7 399.618502188182
Riso18308 a_58313_15032.t23 a_58313_15032.t70 6040217.79307993
Riso18309 a_58313_15032.t23 a_58313_15032.t71 5826454.02097663
Riso18310 a_58313_15032.t23 a_58313_15032.t72 5434710.50162362
Riso18311 a_58313_15032.t23 a_58313_15032.t73 4923077.51381059
Riso18312 a_58313_15032.t23 a_58313_15032.t74 4353500.99533064
Riso18313 a_58313_15032.t23 a_58313_15032.t75 3777817.0866559
Riso18314 a_58313_15032.t23 a_58313_15032.t76 3231873.45366402
Riso18315 a_58313_15032.t23 a_58313_15032.t77 2736086.15424273
Riso18316 a_58313_15032.t23 a_58313_15032.t78 2299047.25543384
Riso18317 a_58313_15032.t23 a_58313_15032.t79 1921603.05362677
Riso18318 a_58313_15032.t23 a_58313_15032.t8 399.618502188182
Riso18319 a_58313_15032.t23 a_58313_15032.t80 1921603.05362677
Riso18320 a_58313_15032.t23 a_58313_15032.t81 2299047.25543384
Riso18321 a_58313_15032.t23 a_58313_15032.t82 2736086.15424273
Riso18322 a_58313_15032.t23 a_58313_15032.t83 3231873.45366402
Riso18323 a_58313_15032.t23 a_58313_15032.t84 3777817.0866559
Riso18324 a_58313_15032.t23 a_58313_15032.t85 4353500.99533064
Riso18325 a_58313_15032.t23 a_58313_15032.t86 4923077.51381059
Riso18326 a_58313_15032.t23 a_58313_15032.t87 5434710.50162362
Riso18327 a_58313_15032.t23 a_58313_15032.t88 5826454.02097663
Riso18328 a_58313_15032.t23 a_58313_15032.t89 6040217.79307993
Riso18329 a_58313_15032.t23 a_58313_15032.t9 607.137129016626
Riso18330 a_58313_15032.t23 a_58313_15032.t90 5105225.87674084
Riso18331 a_58313_15032.t23 a_58313_15032.t91 4924551.54044424
Riso18332 a_58313_15032.t23 a_58313_15032.t92 4593447.72588681
Riso18333 a_58313_15032.t23 a_58313_15032.t93 4161012.66174562
Riso18334 a_58313_15032.t23 a_58313_15032.t94 3679603.40126179
Riso18335 a_58313_15032.t23 a_58313_15032.t95 3193032.14041145
Riso18336 a_58313_15032.t23 a_58313_15032.t96 2731597.52697992
Riso18337 a_58313_15032.t23 a_58313_15032.t97 2312555.32733197
Riso18338 a_58313_15032.t23 a_58313_15032.t98 1943167.60460817
Riso18339 a_58313_15032.t23 a_58313_15032.t99 1624149.65325238
Riso18340 a_58313_15032.t24 a_58313_15032.t25 15446.9741043976
Riso18341 a_58313_15032.t24 a_58313_15032.t26 106.026753908855
Riso18342 a_58313_15032.t24 a_58313_15032.t27 108.576381875046
Riso18343 a_58313_15032.t24 a_58313_15032.t28 106.026753908855
Riso18344 a_58313_15032.t24 a_58313_15032.t29 53.4956101406176
Riso18345 a_58313_15032.t24 a_58313_15032.t3 5478.09060804338
Riso18346 a_58313_15032.t24 a_58313_15032.t30 29550520.0437965
Riso18347 a_58313_15032.t24 a_58313_15032.t31 28504724.8674349
Riso18348 a_58313_15032.t24 a_58313_15032.t32 21384869.9875579
Riso18349 a_58313_15032.t24 a_58313_15032.t33 16622929.6634914
Riso18350 a_58313_15032.t24 a_58313_15032.t34 13199420.6577806
Riso18351 a_58313_15032.t24 a_58313_15032.t35 10622069.7891408
Riso18352 a_58313_15032.t24 a_58313_15032.t36 8622142.05185498
Riso18353 a_58313_15032.t24 a_58313_15032.t37 7038652.6219584
Riso18354 a_58313_15032.t24 a_58313_15032.t38 5767761.32513144
Riso18355 a_58313_15032.t24 a_58313_15032.t39 4738357.81079355
Riso18356 a_58313_15032.t24 a_58313_15032.t4 299.794597925429
Riso18357 a_58313_15032.t24 a_58313_15032.t40 4707766.70772214
Riso18358 a_58313_15032.t24 a_58313_15032.t41 5632473.42274131
Riso18359 a_58313_15032.t24 a_58313_15032.t42 6703182.15933958
Riso18360 a_58313_15032.t24 a_58313_15032.t43 7917819.56216936
Riso18361 a_58313_15032.t24 a_58313_15032.t44 9255335.78584586
Riso18362 a_58313_15032.t24 a_58313_15032.t45 10665713.1966826
Riso18363 a_58313_15032.t24 a_58313_15032.t46 12061128.0125259
Riso18364 a_58313_15032.t24 a_58313_15032.t47 13314586.0261632
Riso18365 a_58313_15032.t24 a_58313_15032.t48 14274324.8727972
Riso18366 a_58313_15032.t24 a_58313_15032.t49 14798028.229599
Riso18367 a_58313_15032.t24 a_58313_15032.t5 108.576381875046
Riso18368 a_58313_15032.t24 a_58313_15032.t50 13839775.4629196
Riso18369 a_58313_15032.t24 a_58313_15032.t51 13349984.7452064
Riso18370 a_58313_15032.t24 a_58313_15032.t52 12452394.2058204
Riso18371 a_58313_15032.t24 a_58313_15032.t53 11280104.412087
Riso18372 a_58313_15032.t24 a_58313_15032.t54 9975050.29073635
Riso18373 a_58313_15032.t24 a_58313_15032.t55 8656002.48375131
Riso18374 a_58313_15032.t24 a_58313_15032.t56 7405097.70600065
Riso18375 a_58313_15032.t24 a_58313_15032.t57 6269114.67750473
Riso18376 a_58313_15032.t24 a_58313_15032.t58 5267740.1517374
Riso18377 a_58313_15032.t24 a_58313_15032.t59 4402913.22301717
Riso18378 a_58313_15032.t24 a_58313_15032.t6 9911.02144205603
Riso18379 a_58313_15032.t24 a_58313_15032.t60 4402913.22301717
Riso18380 a_58313_15032.t24 a_58313_15032.t61 5267740.1517374
Riso18381 a_58313_15032.t24 a_58313_15032.t62 6269114.67750473
Riso18382 a_58313_15032.t24 a_58313_15032.t63 7405097.70600065
Riso18383 a_58313_15032.t24 a_58313_15032.t64 8656002.48375131
Riso18384 a_58313_15032.t24 a_58313_15032.t65 9975050.29073635
Riso18385 a_58313_15032.t24 a_58313_15032.t66 11280104.412087
Riso18386 a_58313_15032.t24 a_58313_15032.t67 12452394.2058204
Riso18387 a_58313_15032.t24 a_58313_15032.t68 13349984.7452064
Riso18388 a_58313_15032.t24 a_58313_15032.t69 13839775.4629196
Riso18389 a_58313_15032.t24 a_58313_15032.t7 197.325221043742
Riso18390 a_58313_15032.t24 a_58313_15032.t70 12231219.1366843
Riso18391 a_58313_15032.t24 a_58313_15032.t71 11798355.3510315
Riso18392 a_58313_15032.t24 a_58313_15032.t72 11005089.1154875
Riso18393 a_58313_15032.t24 a_58313_15032.t73 9969051.11058858
Riso18394 a_58313_15032.t24 a_58313_15032.t74 8815679.58471088
Riso18395 a_58313_15032.t24 a_58313_15032.t75 7649940.81805072
Riso18396 a_58313_15032.t24 a_58313_15032.t76 6544425.01710535
Riso18397 a_58313_15032.t24 a_58313_15032.t77 5540473.94909022
Riso18398 a_58313_15032.t24 a_58313_15032.t78 4655486.23412553
Riso18399 a_58313_15032.t24 a_58313_15032.t79 3891175.59131029
Riso18400 a_58313_15032.t24 a_58313_15032.t8 197.325221043742
Riso18401 a_58313_15032.t24 a_58313_15032.t80 3891175.59131029
Riso18402 a_58313_15032.t24 a_58313_15032.t81 4655486.23412553
Riso18403 a_58313_15032.t24 a_58313_15032.t82 5540473.94909022
Riso18404 a_58313_15032.t24 a_58313_15032.t83 6544425.01710535
Riso18405 a_58313_15032.t24 a_58313_15032.t84 7649940.81805072
Riso18406 a_58313_15032.t24 a_58313_15032.t85 8815679.58471088
Riso18407 a_58313_15032.t24 a_58313_15032.t86 9969051.11058858
Riso18408 a_58313_15032.t24 a_58313_15032.t87 11005089.1154875
Riso18409 a_58313_15032.t24 a_58313_15032.t88 11798355.3510315
Riso18410 a_58313_15032.t24 a_58313_15032.t89 12231219.1366843
Riso18411 a_58313_15032.t24 a_58313_15032.t9 299.794597925429
Riso18412 a_58313_15032.t24 a_58313_15032.t90 10337894.854094
Riso18413 a_58313_15032.t24 a_58313_15032.t91 9972035.96037162
Riso18414 a_58313_15032.t24 a_58313_15032.t92 9301562.89936982
Riso18415 a_58313_15032.t24 a_58313_15032.t93 8425897.7804801
Riso18416 a_58313_15032.t24 a_58313_15032.t94 7451061.71311963
Riso18417 a_58313_15032.t24 a_58313_15032.t95 6465772.78464895
Riso18418 a_58313_15032.t24 a_58313_15032.t96 5531384.6437779
Riso18419 a_58313_15032.t24 a_58313_15032.t97 4682839.5834848
Riso18420 a_58313_15032.t24 a_58313_15032.t98 3934843.0148492
Riso18421 a_58313_15032.t24 a_58313_15032.t99 3288843.38284269
Riso18422 a_58313_15032.t25 a_58313_15032.t26 124780.122345125
Riso18423 a_58313_15032.t25 a_58313_15032.t27 1859.32561256712
Riso18424 a_58313_15032.t25 a_58313_15032.t28 124780.122345125
Riso18425 a_58313_15032.t25 a_58313_15032.t29 62957.5888366032
Riso18426 a_58313_15032.t25 a_58313_15032.t3 30.1053767576445
Riso18427 a_58313_15032.t25 a_58313_15032.t30 6889.02677662776
Riso18428 a_58313_15032.t25 a_58313_15032.t31 6645.22358933544
Riso18429 a_58313_15032.t25 a_58313_15032.t32 4985.39253253908
Riso18430 a_58313_15032.t25 a_58313_15032.t33 3875.25523706754
Riso18431 a_58313_15032.t25 a_58313_15032.t34 3077.14254140557
Riso18432 a_58313_15032.t25 a_58313_15032.t35 2476.29223080157
Riso18433 a_58313_15032.t25 a_58313_15032.t36 2010.05489511127
Riso18434 a_58313_15032.t25 a_58313_15032.t37 1640.90061062164
Riso18435 a_58313_15032.t25 a_58313_15032.t38 1344.62141956009
Riso18436 a_58313_15032.t25 a_58313_15032.t39 1104.63957275272
Riso18437 a_58313_15032.t25 a_58313_15032.t4 352820.446051764
Riso18438 a_58313_15032.t25 a_58313_15032.t40 1097.50795788188
Riso18439 a_58313_15032.t25 a_58313_15032.t41 1313.08214442253
Riso18440 a_58313_15032.t25 a_58313_15032.t42 1562.69335754035
Riso18441 a_58313_15032.t25 a_58313_15032.t43 1845.85824193448
Riso18442 a_58313_15032.t25 a_58313_15032.t44 2157.66950838343
Riso18443 a_58313_15032.t25 a_58313_15032.t45 2486.46669144503
Riso18444 a_58313_15032.t25 a_58313_15032.t46 2811.77568826131
Riso18445 a_58313_15032.t25 a_58313_15032.t47 3103.99070872554
Riso18446 a_58313_15032.t25 a_58313_15032.t48 3327.73183420258
Riso18447 a_58313_15032.t25 a_58313_15032.t49 3449.82127434342
Riso18448 a_58313_15032.t25 a_58313_15032.t5 1859.32561256712
Riso18449 a_58313_15032.t25 a_58313_15032.t50 3226.42659436324
Riso18450 a_58313_15032.t25 a_58313_15032.t51 3112.24310912274
Riso18451 a_58313_15032.t25 a_58313_15032.t52 2902.99043772767
Riso18452 a_58313_15032.t25 a_58313_15032.t53 2629.69792825482
Riso18453 a_58313_15032.t25 a_58313_15032.t54 2325.45445729025
Riso18454 a_58313_15032.t25 a_58313_15032.t55 2017.94867910073
Riso18455 a_58313_15032.t25 a_58313_15032.t56 1726.32888709153
Riso18456 a_58313_15032.t25 a_58313_15032.t57 1461.50046818369
Riso18457 a_58313_15032.t25 a_58313_15032.t58 1228.05293794666
Riso18458 a_58313_15032.t25 a_58313_15032.t59 1026.43835179819
Riso18459 a_58313_15032.t25 a_58313_15032.t6 18.770768325182
Riso18460 a_58313_15032.t25 a_58313_15032.t60 1026.43835179819
Riso18461 a_58313_15032.t25 a_58313_15032.t61 1228.05293794666
Riso18462 a_58313_15032.t25 a_58313_15032.t62 1461.50046818369
Riso18463 a_58313_15032.t25 a_58313_15032.t63 1726.32888709153
Riso18464 a_58313_15032.t25 a_58313_15032.t64 2017.94867910073
Riso18465 a_58313_15032.t25 a_58313_15032.t65 2325.45445729025
Riso18466 a_58313_15032.t25 a_58313_15032.t66 2629.69792825482
Riso18467 a_58313_15032.t25 a_58313_15032.t67 2902.99043772767
Riso18468 a_58313_15032.t25 a_58313_15032.t68 3112.24310912274
Riso18469 a_58313_15032.t25 a_58313_15032.t69 3226.42659436324
Riso18470 a_58313_15032.t25 a_58313_15032.t7 232226.907981954
Riso18471 a_58313_15032.t25 a_58313_15032.t70 2851.42853724866
Riso18472 a_58313_15032.t25 a_58313_15032.t71 2750.51626208142
Riso18473 a_58313_15032.t25 a_58313_15032.t72 2565.58441216616
Riso18474 a_58313_15032.t25 a_58313_15032.t73 2324.05588587373
Riso18475 a_58313_15032.t25 a_58313_15032.t74 2055.17373715368
Riso18476 a_58313_15032.t25 a_58313_15032.t75 1783.40844956576
Riso18477 a_58313_15032.t25 a_58313_15032.t76 1525.68276678893
Riso18478 a_58313_15032.t25 a_58313_15032.t77 1291.63457475273
Riso18479 a_58313_15032.t25 a_58313_15032.t78 1085.31996315393
Riso18480 a_58313_15032.t25 a_58313_15032.t79 907.138446340958
Riso18481 a_58313_15032.t25 a_58313_15032.t8 232226.907981954
Riso18482 a_58313_15032.t25 a_58313_15032.t80 907.138446340958
Riso18483 a_58313_15032.t25 a_58313_15032.t81 1085.31996315393
Riso18484 a_58313_15032.t25 a_58313_15032.t82 1291.63457475273
Riso18485 a_58313_15032.t25 a_58313_15032.t83 1525.68276678893
Riso18486 a_58313_15032.t25 a_58313_15032.t84 1783.40844956576
Riso18487 a_58313_15032.t25 a_58313_15032.t85 2055.17373715368
Riso18488 a_58313_15032.t25 a_58313_15032.t86 2324.05588587373
Riso18489 a_58313_15032.t25 a_58313_15032.t87 2565.58441216616
Riso18490 a_58313_15032.t25 a_58313_15032.t88 2750.51626208142
Riso18491 a_58313_15032.t25 a_58313_15032.t89 2851.42853724866
Riso18492 a_58313_15032.t25 a_58313_15032.t9 352820.446051764
Riso18493 a_58313_15032.t25 a_58313_15032.t90 2410.0433548467
Riso18494 a_58313_15032.t25 a_58313_15032.t91 2324.75173522087
Riso18495 a_58313_15032.t25 a_58313_15032.t92 2168.4463008866
Riso18496 a_58313_15032.t25 a_58313_15032.t93 1964.30503899174
Riso18497 a_58313_15032.t25 a_58313_15032.t94 1737.04434236387
Riso18498 a_58313_15032.t25 a_58313_15032.t95 1507.34680063231
Riso18499 a_58313_15032.t25 a_58313_15032.t96 1289.51561144566
Riso18500 a_58313_15032.t25 a_58313_15032.t97 1091.69676992034
Riso18501 a_58313_15032.t25 a_58313_15032.t98 917.318505763941
Riso18502 a_58313_15032.t25 a_58313_15032.t99 766.718490739204
Riso18503 a_58313_15032.t26 a_58313_15032.t27 877.076256009402
Riso18504 a_58313_15032.t26 a_58313_15032.t28 0.814755404766932
Riso18505 a_58313_15032.t26 a_58313_15032.t29 25.842275227707
Riso18506 a_58313_15032.t26 a_58313_15032.t3 44251.8263881035
Riso18507 a_58313_15032.t26 a_58313_15032.t30 238708078.456431
Riso18508 a_58313_15032.t26 a_58313_15032.t31 230260181.206626
Riso18509 a_58313_15032.t26 a_58313_15032.t32 172746239.836214
Riso18510 a_58313_15032.t26 a_58313_15032.t33 134279450.663049
Riso18511 a_58313_15032.t26 a_58313_15032.t34 106624463.369415
Riso18512 a_58313_15032.t26 a_58313_15032.t35 85804712.2296984
Riso18513 a_58313_15032.t26 a_58313_15032.t36 69649365.1660372
Riso18514 a_58313_15032.t26 a_58313_15032.t37 56857992.3405687
Riso18515 a_58313_15032.t26 a_58313_15032.t38 46591776.4180422
Riso18516 a_58313_15032.t26 a_58313_15032.t39 38276290.4469084
Riso18517 a_58313_15032.t26 a_58313_15032.t4 36.0731361183348
Riso18518 a_58313_15032.t26 a_58313_15032.t40 38029176.5747595
Riso18519 a_58313_15032.t26 a_58313_15032.t41 45498925.423539
Riso18520 a_58313_15032.t26 a_58313_15032.t42 54148073.5509182
Riso18521 a_58313_15032.t26 a_58313_15032.t43 63959872.4641382
Riso18522 a_58313_15032.t26 a_58313_15032.t44 74764282.2405115
Riso18523 a_58313_15032.t26 a_58313_15032.t45 86157262.1657461
Riso18524 a_58313_15032.t26 a_58313_15032.t46 97429374.7663324
Riso18525 a_58313_15032.t26 a_58313_15032.t47 107554765.230451
Riso18526 a_58313_15032.t26 a_58313_15032.t48 115307502.426291
Riso18527 a_58313_15032.t26 a_58313_15032.t49 119537960.022235
Riso18528 a_58313_15032.t26 a_58313_15032.t5 877.076256009402
Riso18529 a_58313_15032.t26 a_58313_15032.t50 111797227.328848
Riso18530 a_58313_15032.t26 a_58313_15032.t51 107840714.858075
Riso18531 a_58313_15032.t26 a_58313_15032.t52 100590009.537832
Riso18532 a_58313_15032.t26 a_58313_15032.t53 91120293.1456513
Riso18533 a_58313_15032.t26 a_58313_15032.t54 80578111.1086674
Riso18534 a_58313_15032.t26 a_58313_15032.t55 69922888.5633141
Riso18535 a_58313_15032.t26 a_58313_15032.t56 59818123.050346
Riso18536 a_58313_15032.t26 a_58313_15032.t57 50641691.4515288
Riso18537 a_58313_15032.t26 a_58313_15032.t58 42552622.6802562
Riso18538 a_58313_15032.t26 a_58313_15032.t59 35566580.6733399
Riso18539 a_58313_15032.t26 a_58313_15032.t6 80060.8882844458
Riso18540 a_58313_15032.t26 a_58313_15032.t60 35566580.6733399
Riso18541 a_58313_15032.t26 a_58313_15032.t61 42552622.6802562
Riso18542 a_58313_15032.t26 a_58313_15032.t62 50641691.4515288
Riso18543 a_58313_15032.t26 a_58313_15032.t63 59818123.050346
Riso18544 a_58313_15032.t26 a_58313_15032.t64 69922888.5633141
Riso18545 a_58313_15032.t26 a_58313_15032.t65 80578111.1086674
Riso18546 a_58313_15032.t26 a_58313_15032.t66 91120293.1456513
Riso18547 a_58313_15032.t26 a_58313_15032.t67 100590009.537832
Riso18548 a_58313_15032.t26 a_58313_15032.t68 107840714.858075
Riso18549 a_58313_15032.t26 a_58313_15032.t69 111797227.328848
Riso18550 a_58313_15032.t26 a_58313_15032.t7 23.7433883317068
Riso18551 a_58313_15032.t26 a_58313_15032.t70 98803364.9820775
Riso18552 a_58313_15032.t26 a_58313_15032.t71 95306706.2987989
Riso18553 a_58313_15032.t26 a_58313_15032.t72 88898729.0953372
Riso18554 a_58313_15032.t26 a_58313_15032.t73 80529649.9390067
Riso18555 a_58313_15032.t26 a_58313_15032.t74 71212754.6599872
Riso18556 a_58313_15032.t26 a_58313_15032.t75 61795957.2378373
Riso18557 a_58313_15032.t26 a_58313_15032.t76 52865638.8489976
Riso18558 a_58313_15032.t26 a_58313_15032.t77 44755756.8585965
Riso18559 a_58313_15032.t26 a_58313_15032.t78 37606856.7179671
Riso18560 a_58313_15032.t26 a_58313_15032.t79 31432781.790696
Riso18561 a_58313_15032.t26 a_58313_15032.t8 23.7433883317068
Riso18562 a_58313_15032.t26 a_58313_15032.t80 31432781.790696
Riso18563 a_58313_15032.t26 a_58313_15032.t81 37606856.7179671
Riso18564 a_58313_15032.t26 a_58313_15032.t82 44755756.8585965
Riso18565 a_58313_15032.t26 a_58313_15032.t83 52865638.8489976
Riso18566 a_58313_15032.t26 a_58313_15032.t84 61795957.2378373
Riso18567 a_58313_15032.t26 a_58313_15032.t85 71212754.6599872
Riso18568 a_58313_15032.t26 a_58313_15032.t86 80529649.9390067
Riso18569 a_58313_15032.t26 a_58313_15032.t87 88898729.0953372
Riso18570 a_58313_15032.t26 a_58313_15032.t88 95306706.2987989
Riso18571 a_58313_15032.t26 a_58313_15032.t89 98803364.9820776
Riso18572 a_58313_15032.t26 a_58313_15032.t9 36.0731361183348
Riso18573 a_58313_15032.t26 a_58313_15032.t90 83509156.9369337
Riso18574 a_58313_15032.t26 a_58313_15032.t91 80553761.4522779
Riso18575 a_58313_15032.t26 a_58313_15032.t92 75137703.2640854
Riso18576 a_58313_15032.t26 a_58313_15032.t93 68064110.731985
Riso18577 a_58313_15032.t26 a_58313_15032.t94 60189418.7094839
Riso18578 a_58313_15032.t26 a_58313_15032.t95 52230288.8366069
Riso18579 a_58313_15032.t26 a_58313_15032.t96 44682333.7647763
Riso18580 a_58313_15032.t26 a_58313_15032.t97 37827816.1276567
Riso18581 a_58313_15032.t26 a_58313_15032.t98 31785525.7271366
Riso18582 a_58313_15032.t26 a_58313_15032.t99 26567163.05158
Riso18583 a_58313_15032.t27 a_58313_15032.t28 877.076256009402
Riso18584 a_58313_15032.t27 a_58313_15032.t29 442.527265291983
Riso18585 a_58313_15032.t27 a_58313_15032.t3 659.388311695215
Riso18586 a_58313_15032.t27 a_58313_15032.t30 3556945.09557485
Riso18587 a_58313_15032.t27 a_58313_15032.t31 3431064.53516434
Riso18588 a_58313_15032.t27 a_58313_15032.t32 2574059.89163694
Riso18589 a_58313_15032.t27 a_58313_15032.t33 2000873.35359954
Riso18590 a_58313_15032.t27 a_58313_15032.t34 1588791.48331531
Riso18591 a_58313_15032.t27 a_58313_15032.t35 1278560.20758151
Riso18592 a_58313_15032.t27 a_58313_15032.t36 1037832.35757753
Riso18593 a_58313_15032.t27 a_58313_15032.t37 847230.467891065
Riso18594 a_58313_15032.t27 a_58313_15032.t38 694255.475960038
Riso18595 a_58313_15032.t27 a_58313_15032.t39 570347.951616474
Riso18596 a_58313_15032.t27 a_58313_15032.t4 2479.9657994464
Riso18597 a_58313_15032.t27 a_58313_15032.t40 566665.753337838
Riso18598 a_58313_15032.t27 a_58313_15032.t41 677971.104646642
Riso18599 a_58313_15032.t27 a_58313_15032.t42 806850.467303809
Riso18600 a_58313_15032.t27 a_58313_15032.t43 953054.275104615
Riso18601 a_58313_15032.t27 a_58313_15032.t44 1114048.79449063
Riso18602 a_58313_15032.t27 a_58313_15032.t45 1283813.48922191
Riso18603 a_58313_15032.t27 a_58313_15032.t46 1451777.16221817
Riso18604 a_58313_15032.t27 a_58313_15032.t47 1602653.73994028
Riso18605 a_58313_15032.t27 a_58313_15032.t48 1718175.84846858
Riso18606 a_58313_15032.t27 a_58313_15032.t49 1781213.11765206
Riso18607 a_58313_15032.t27 a_58313_15032.t5 0.815996923632082
Riso18608 a_58313_15032.t27 a_58313_15032.t50 1665869.88600301
Riso18609 a_58313_15032.t27 a_58313_15032.t51 1606914.62265584
Riso18610 a_58313_15032.t27 a_58313_15032.t52 1498873.19860742
Riso18611 a_58313_15032.t27 a_58313_15032.t53 1357766.69942457
Riso18612 a_58313_15032.t27 a_58313_15032.t54 1200679.58726824
Riso18613 a_58313_15032.t27 a_58313_15032.t55 1041908.07932419
Riso18614 a_58313_15032.t27 a_58313_15032.t56 891338.830199065
Riso18615 a_58313_15032.t27 a_58313_15032.t57 754602.513684965
Riso18616 a_58313_15032.t27 a_58313_15032.t58 634068.790319598
Riso18617 a_58313_15032.t27 a_58313_15032.t59 529971.065539344
Riso18618 a_58313_15032.t27 a_58313_15032.t6 1192.97254526182
Riso18619 a_58313_15032.t27 a_58313_15032.t60 529971.065539344
Riso18620 a_58313_15032.t27 a_58313_15032.t61 634068.790319598
Riso18621 a_58313_15032.t27 a_58313_15032.t62 754602.513684965
Riso18622 a_58313_15032.t27 a_58313_15032.t63 891338.830199065
Riso18623 a_58313_15032.t27 a_58313_15032.t64 1041908.07932419
Riso18624 a_58313_15032.t27 a_58313_15032.t65 1200679.58726824
Riso18625 a_58313_15032.t27 a_58313_15032.t66 1357766.69942457
Riso18626 a_58313_15032.t27 a_58313_15032.t67 1498873.19860742
Riso18627 a_58313_15032.t27 a_58313_15032.t68 1606914.62265584
Riso18628 a_58313_15032.t27 a_58313_15032.t69 1665869.88600301
Riso18629 a_58313_15032.t27 a_58313_15032.t7 1632.31693613907
Riso18630 a_58313_15032.t27 a_58313_15032.t70 1472250.73726794
Riso18631 a_58313_15032.t27 a_58313_15032.t71 1420147.67048104
Riso18632 a_58313_15032.t27 a_58313_15032.t72 1324663.58282974
Riso18633 a_58313_15032.t27 a_58313_15032.t73 1199957.476308
Riso18634 a_58313_15032.t27 a_58313_15032.t74 1061128.13637537
Riso18635 a_58313_15032.t27 a_58313_15032.t75 920810.173014729
Riso18636 a_58313_15032.t27 a_58313_15032.t76 787741.144096617
Riso18637 a_58313_15032.t27 a_58313_15032.t77 666897.286787811
Riso18638 a_58313_15032.t27 a_58313_15032.t78 560372.842963396
Riso18639 a_58313_15032.t27 a_58313_15032.t79 468374.090033562
Riso18640 a_58313_15032.t27 a_58313_15032.t8 1632.31693613907
Riso18641 a_58313_15032.t27 a_58313_15032.t80 468374.090033562
Riso18642 a_58313_15032.t27 a_58313_15032.t81 560372.842963396
Riso18643 a_58313_15032.t27 a_58313_15032.t82 666897.286787811
Riso18644 a_58313_15032.t27 a_58313_15032.t83 787741.144096617
Riso18645 a_58313_15032.t27 a_58313_15032.t84 920810.173014729
Riso18646 a_58313_15032.t27 a_58313_15032.t85 1061128.13637537
Riso18647 a_58313_15032.t27 a_58313_15032.t86 1199957.476308
Riso18648 a_58313_15032.t27 a_58313_15032.t87 1324663.58282974
Riso18649 a_58313_15032.t27 a_58313_15032.t88 1420147.67048104
Riso18650 a_58313_15032.t27 a_58313_15032.t89 1472250.73726794
Riso18651 a_58313_15032.t27 a_58313_15032.t9 2479.9657994464
Riso18652 a_58313_15032.t27 a_58313_15032.t90 1244354.56111568
Riso18653 a_58313_15032.t27 a_58313_15032.t91 1200316.75752475
Riso18654 a_58313_15032.t27 a_58313_15032.t92 1119613.0723608
Riso18655 a_58313_15032.t27 a_58313_15032.t93 1014210.77333579
Riso18656 a_58313_15032.t27 a_58313_15032.t94 896871.438405368
Riso18657 a_58313_15032.t27 a_58313_15032.t95 778273.910624001
Riso18658 a_58313_15032.t27 a_58313_15032.t96 665803.222794861
Riso18659 a_58313_15032.t27 a_58313_15032.t97 563665.318415835
Riso18660 a_58313_15032.t27 a_58313_15032.t98 473630.262438072
Riso18661 a_58313_15032.t27 a_58313_15032.t99 395872.401682891
Riso18662 a_58313_15032.t28 a_58313_15032.t29 25.842275227707
Riso18663 a_58313_15032.t28 a_58313_15032.t3 44251.8263881035
Riso18664 a_58313_15032.t28 a_58313_15032.t30 238708078.456431
Riso18665 a_58313_15032.t28 a_58313_15032.t31 230260181.206626
Riso18666 a_58313_15032.t28 a_58313_15032.t32 172746239.836214
Riso18667 a_58313_15032.t28 a_58313_15032.t33 134279450.663049
Riso18668 a_58313_15032.t28 a_58313_15032.t34 106624463.369415
Riso18669 a_58313_15032.t28 a_58313_15032.t35 85804712.2296984
Riso18670 a_58313_15032.t28 a_58313_15032.t36 69649365.1660372
Riso18671 a_58313_15032.t28 a_58313_15032.t37 56857992.3405687
Riso18672 a_58313_15032.t28 a_58313_15032.t38 46591776.4180422
Riso18673 a_58313_15032.t28 a_58313_15032.t39 38276290.4469084
Riso18674 a_58313_15032.t28 a_58313_15032.t4 36.0731361183348
Riso18675 a_58313_15032.t28 a_58313_15032.t40 38029176.5747595
Riso18676 a_58313_15032.t28 a_58313_15032.t41 45498925.423539
Riso18677 a_58313_15032.t28 a_58313_15032.t42 54148073.5509182
Riso18678 a_58313_15032.t28 a_58313_15032.t43 63959872.4641382
Riso18679 a_58313_15032.t28 a_58313_15032.t44 74764282.2405115
Riso18680 a_58313_15032.t28 a_58313_15032.t45 86157262.1657461
Riso18681 a_58313_15032.t28 a_58313_15032.t46 97429374.7663324
Riso18682 a_58313_15032.t28 a_58313_15032.t47 107554765.230451
Riso18683 a_58313_15032.t28 a_58313_15032.t48 115307502.426291
Riso18684 a_58313_15032.t28 a_58313_15032.t49 119537960.022235
Riso18685 a_58313_15032.t28 a_58313_15032.t5 877.076256009402
Riso18686 a_58313_15032.t28 a_58313_15032.t50 111797227.328848
Riso18687 a_58313_15032.t28 a_58313_15032.t51 107840714.858075
Riso18688 a_58313_15032.t28 a_58313_15032.t52 100590009.537832
Riso18689 a_58313_15032.t28 a_58313_15032.t53 91120293.1456513
Riso18690 a_58313_15032.t28 a_58313_15032.t54 80578111.1086674
Riso18691 a_58313_15032.t28 a_58313_15032.t55 69922888.5633141
Riso18692 a_58313_15032.t28 a_58313_15032.t56 59818123.050346
Riso18693 a_58313_15032.t28 a_58313_15032.t57 50641691.4515288
Riso18694 a_58313_15032.t28 a_58313_15032.t58 42552622.6802562
Riso18695 a_58313_15032.t28 a_58313_15032.t59 35566580.6733399
Riso18696 a_58313_15032.t28 a_58313_15032.t6 80060.8882844458
Riso18697 a_58313_15032.t28 a_58313_15032.t60 35566580.6733399
Riso18698 a_58313_15032.t28 a_58313_15032.t61 42552622.6802562
Riso18699 a_58313_15032.t28 a_58313_15032.t62 50641691.4515288
Riso18700 a_58313_15032.t28 a_58313_15032.t63 59818123.050346
Riso18701 a_58313_15032.t28 a_58313_15032.t64 69922888.5633141
Riso18702 a_58313_15032.t28 a_58313_15032.t65 80578111.1086674
Riso18703 a_58313_15032.t28 a_58313_15032.t66 91120293.1456513
Riso18704 a_58313_15032.t28 a_58313_15032.t67 100590009.537832
Riso18705 a_58313_15032.t28 a_58313_15032.t68 107840714.858075
Riso18706 a_58313_15032.t28 a_58313_15032.t69 111797227.328848
Riso18707 a_58313_15032.t28 a_58313_15032.t7 23.7433883317068
Riso18708 a_58313_15032.t28 a_58313_15032.t70 98803364.9820775
Riso18709 a_58313_15032.t28 a_58313_15032.t71 95306706.2987989
Riso18710 a_58313_15032.t28 a_58313_15032.t72 88898729.0953372
Riso18711 a_58313_15032.t28 a_58313_15032.t73 80529649.9390067
Riso18712 a_58313_15032.t28 a_58313_15032.t74 71212754.6599872
Riso18713 a_58313_15032.t28 a_58313_15032.t75 61795957.2378373
Riso18714 a_58313_15032.t28 a_58313_15032.t76 52865638.8489976
Riso18715 a_58313_15032.t28 a_58313_15032.t77 44755756.8585965
Riso18716 a_58313_15032.t28 a_58313_15032.t78 37606856.7179671
Riso18717 a_58313_15032.t28 a_58313_15032.t79 31432781.790696
Riso18718 a_58313_15032.t28 a_58313_15032.t8 23.7433883317068
Riso18719 a_58313_15032.t28 a_58313_15032.t80 31432781.790696
Riso18720 a_58313_15032.t28 a_58313_15032.t81 37606856.7179671
Riso18721 a_58313_15032.t28 a_58313_15032.t82 44755756.8585965
Riso18722 a_58313_15032.t28 a_58313_15032.t83 52865638.8489976
Riso18723 a_58313_15032.t28 a_58313_15032.t84 61795957.2378373
Riso18724 a_58313_15032.t28 a_58313_15032.t85 71212754.6599872
Riso18725 a_58313_15032.t28 a_58313_15032.t86 80529649.9390067
Riso18726 a_58313_15032.t28 a_58313_15032.t87 88898729.0953372
Riso18727 a_58313_15032.t28 a_58313_15032.t88 95306706.2987989
Riso18728 a_58313_15032.t28 a_58313_15032.t89 98803364.9820776
Riso18729 a_58313_15032.t28 a_58313_15032.t9 36.0731361183348
Riso18730 a_58313_15032.t28 a_58313_15032.t90 83509156.9369337
Riso18731 a_58313_15032.t28 a_58313_15032.t91 80553761.4522779
Riso18732 a_58313_15032.t28 a_58313_15032.t92 75137703.2640854
Riso18733 a_58313_15032.t28 a_58313_15032.t93 68064110.731985
Riso18734 a_58313_15032.t28 a_58313_15032.t94 60189418.7094839
Riso18735 a_58313_15032.t28 a_58313_15032.t95 52230288.8366069
Riso18736 a_58313_15032.t28 a_58313_15032.t96 44682333.7647763
Riso18737 a_58313_15032.t28 a_58313_15032.t97 37827816.1276567
Riso18738 a_58313_15032.t28 a_58313_15032.t98 31785525.7271366
Riso18739 a_58313_15032.t28 a_58313_15032.t99 26567163.05158
Riso18740 a_58313_15032.t29 a_58313_15032.t3 22327.1803124643
Riso18741 a_58313_15032.t29 a_58313_15032.t30 120439736.498004
Riso18742 a_58313_15032.t29 a_58313_15032.t31 116177364.963249
Riso18743 a_58313_15032.t29 a_58313_15032.t32 87158808.1200701
Riso18744 a_58313_15032.t29 a_58313_15032.t33 67750458.0470502
Riso18745 a_58313_15032.t29 a_58313_15032.t34 53797183.3860548
Riso18746 a_58313_15032.t29 a_58313_15032.t35 43292614.9716302
Riso18747 a_58313_15032.t29 a_58313_15032.t36 35141463.3392136
Riso18748 a_58313_15032.t29 a_58313_15032.t37 28687598.9266259
Riso18749 a_58313_15032.t29 a_58313_15032.t38 23507797.9390091
Riso18750 a_58313_15032.t29 a_58313_15032.t39 19312234.279445
Riso18751 a_58313_15032.t29 a_58313_15032.t4 73.0699962580074
Riso18752 a_58313_15032.t29 a_58313_15032.t40 19187553.4146872
Riso18753 a_58313_15032.t29 a_58313_15032.t41 22956401.9131157
Riso18754 a_58313_15032.t29 a_58313_15032.t42 27320314.2202724
Riso18755 a_58313_15032.t29 a_58313_15032.t43 32270839.9139192
Riso18756 a_58313_15032.t29 a_58313_15032.t44 37722185.6534409
Riso18757 a_58313_15032.t29 a_58313_15032.t45 43470493.4149344
Riso18758 a_58313_15032.t29 a_58313_15032.t46 49157817.7827112
Riso18759 a_58313_15032.t29 a_58313_15032.t47 54266565.5357136
Riso18760 a_58313_15032.t29 a_58313_15032.t48 58178195.3014223
Riso18761 a_58313_15032.t29 a_58313_15032.t49 60312665.1585638
Riso18762 a_58313_15032.t29 a_58313_15032.t5 442.527265291983
Riso18763 a_58313_15032.t29 a_58313_15032.t50 56407092.2432209
Riso18764 a_58313_15032.t29 a_58313_15032.t51 54410840.911836
Riso18765 a_58313_15032.t29 a_58313_15032.t52 50752510.4362123
Riso18766 a_58313_15032.t29 a_58313_15032.t53 45974581.8702412
Riso18767 a_58313_15032.t29 a_58313_15032.t54 40655542.670317
Riso18768 a_58313_15032.t29 a_58313_15032.t55 35279469.0829115
Riso18769 a_58313_15032.t29 a_58313_15032.t56 30181127.6123352
Riso18770 a_58313_15032.t29 a_58313_15032.t57 25551175.3673163
Riso18771 a_58313_15032.t29 a_58313_15032.t58 21469850.1033113
Riso18772 a_58313_15032.t29 a_58313_15032.t59 17945055.031784
Riso18773 a_58313_15032.t29 a_58313_15032.t6 40394.5788141173
Riso18774 a_58313_15032.t29 a_58313_15032.t60 17945055.031784
Riso18775 a_58313_15032.t29 a_58313_15032.t61 21469850.1033113
Riso18776 a_58313_15032.t29 a_58313_15032.t62 25551175.3673163
Riso18777 a_58313_15032.t29 a_58313_15032.t63 30181127.6123352
Riso18778 a_58313_15032.t29 a_58313_15032.t64 35279469.0829115
Riso18779 a_58313_15032.t29 a_58313_15032.t65 40655542.670317
Riso18780 a_58313_15032.t29 a_58313_15032.t66 45974581.8702412
Riso18781 a_58313_15032.t29 a_58313_15032.t67 50752510.4362123
Riso18782 a_58313_15032.t29 a_58313_15032.t68 54410840.911836
Riso18783 a_58313_15032.t29 a_58313_15032.t69 56407092.2432209
Riso18784 a_58313_15032.t29 a_58313_15032.t7 48.0947730981568
Riso18785 a_58313_15032.t29 a_58313_15032.t70 49851062.1027412
Riso18786 a_58313_15032.t29 a_58313_15032.t71 48086829.1820927
Riso18787 a_58313_15032.t29 a_58313_15032.t72 44853695.6791938
Riso18788 a_58313_15032.t29 a_58313_15032.t73 40631091.6733417
Riso18789 a_58313_15032.t29 a_58313_15032.t74 35930268.728259
Riso18790 a_58313_15032.t29 a_58313_15032.t75 31179040.3345126
Riso18791 a_58313_15032.t29 a_58313_15032.t76 26673264.0719323
Riso18792 a_58313_15032.t29 a_58313_15032.t77 22581437.5352276
Riso18793 a_58313_15032.t29 a_58313_15032.t78 18974472.6819409
Riso18794 a_58313_15032.t29 a_58313_15032.t79 15859354.1565526
Riso18795 a_58313_15032.t29 a_58313_15032.t8 48.0947730981568
Riso18796 a_58313_15032.t29 a_58313_15032.t80 15859354.1565526
Riso18797 a_58313_15032.t29 a_58313_15032.t81 18974472.6819409
Riso18798 a_58313_15032.t29 a_58313_15032.t82 22581437.5352276
Riso18799 a_58313_15032.t29 a_58313_15032.t83 26673264.0719323
Riso18800 a_58313_15032.t29 a_58313_15032.t84 31179040.3345126
Riso18801 a_58313_15032.t29 a_58313_15032.t85 35930268.728259
Riso18802 a_58313_15032.t29 a_58313_15032.t86 40631091.6733417
Riso18803 a_58313_15032.t29 a_58313_15032.t87 44853695.6791938
Riso18804 a_58313_15032.t29 a_58313_15032.t88 48086829.1820927
Riso18805 a_58313_15032.t29 a_58313_15032.t89 49851062.1027412
Riso18806 a_58313_15032.t29 a_58313_15032.t9 73.0699962580074
Riso18807 a_58313_15032.t29 a_58313_15032.t90 42134396.6307807
Riso18808 a_58313_15032.t29 a_58313_15032.t91 40643257.0944858
Riso18809 a_58313_15032.t29 a_58313_15032.t92 37910594.5668421
Riso18810 a_58313_15032.t29 a_58313_15032.t93 34341626.0335214
Riso18811 a_58313_15032.t29 a_58313_15032.t94 30368464.1768896
Riso18812 a_58313_15032.t29 a_58313_15032.t95 26352699.3530038
Riso18813 a_58313_15032.t29 a_58313_15032.t96 22544392.0438067
Riso18814 a_58313_15032.t29 a_58313_15032.t97 19085957.3591745
Riso18815 a_58313_15032.t29 a_58313_15032.t98 16037330.4824102
Riso18816 a_58313_15032.t29 a_58313_15032.t99 13404414.8741109
Riso18817 a_58313_15032.t3 a_58313_15032.t30 57592.4794908245
Riso18818 a_58313_15032.t3 a_58313_15032.t31 55554.2772136077
Riso18819 a_58313_15032.t3 a_58313_15032.t32 41678.0376232643
Riso18820 a_58313_15032.t3 a_58313_15032.t33 32397.2550839429
Riso18821 a_58313_15032.t3 a_58313_15032.t34 25725.0079659285
Riso18822 a_58313_15032.t3 a_58313_15032.t35 20701.8805616458
Riso18823 a_58313_15032.t3 a_58313_15032.t36 16804.121841256
Riso18824 a_58313_15032.t3 a_58313_15032.t37 13717.9804677676
Riso18825 a_58313_15032.t3 a_58313_15032.t38 11241.0771564521
Riso18826 a_58313_15032.t3 a_58313_15032.t39 9234.82140530394
Riso18827 a_58313_15032.t3 a_58313_15032.t4 125123.688223934
Riso18828 a_58313_15032.t3 a_58313_15032.t40 9175.20088175206
Riso18829 a_58313_15032.t3 a_58313_15032.t41 10977.4078290694
Riso18830 a_58313_15032.t3 a_58313_15032.t42 13064.1653839885
Riso18831 a_58313_15032.t3 a_58313_15032.t43 15431.4326810644
Riso18832 a_58313_15032.t3 a_58313_15032.t44 18038.1846287987
Riso18833 a_58313_15032.t3 a_58313_15032.t45 20786.939371103
Riso18834 a_58313_15032.t3 a_58313_15032.t46 23506.5327672101
Riso18835 a_58313_15032.t3 a_58313_15032.t47 25949.4594851166
Riso18836 a_58313_15032.t3 a_58313_15032.t48 27819.9422975811
Riso18837 a_58313_15032.t3 a_58313_15032.t49 28840.613838765
Riso18838 a_58313_15032.t3 a_58313_15032.t5 659.388311695215
Riso18839 a_58313_15032.t3 a_58313_15032.t50 26973.0273214985
Riso18840 a_58313_15032.t3 a_58313_15032.t51 26018.4498107514
Riso18841 a_58313_15032.t3 a_58313_15032.t52 24269.0909279252
Riso18842 a_58313_15032.t3 a_58313_15032.t53 21984.3569942133
Riso18843 a_58313_15032.t3 a_58313_15032.t54 19440.8720536131
Riso18844 a_58313_15032.t3 a_58313_15032.t55 16870.1141224967
Riso18845 a_58313_15032.t3 a_58313_15032.t56 14432.1635331059
Riso18846 a_58313_15032.t3 a_58313_15032.t57 12218.1896614579
Riso18847 a_58313_15032.t3 a_58313_15032.t58 10266.5610013729
Riso18848 a_58313_15032.t3 a_58313_15032.t59 8581.05675029325
Riso18849 a_58313_15032.t3 a_58313_15032.t6 19.3160830431666
Riso18850 a_58313_15032.t3 a_58313_15032.t60 8581.05675029325
Riso18851 a_58313_15032.t3 a_58313_15032.t61 10266.5610013729
Riso18852 a_58313_15032.t3 a_58313_15032.t62 12218.1896614579
Riso18853 a_58313_15032.t3 a_58313_15032.t63 14432.1635331059
Riso18854 a_58313_15032.t3 a_58313_15032.t64 16870.1141224967
Riso18855 a_58313_15032.t3 a_58313_15032.t65 19440.8720536131
Riso18856 a_58313_15032.t3 a_58313_15032.t66 21984.3569942133
Riso18857 a_58313_15032.t3 a_58313_15032.t67 24269.0909279252
Riso18858 a_58313_15032.t3 a_58313_15032.t68 26018.4498107514
Riso18859 a_58313_15032.t3 a_58313_15032.t69 26973.0273214985
Riso18860 a_58313_15032.t3 a_58313_15032.t7 82356.5855003748
Riso18861 a_58313_15032.t3 a_58313_15032.t70 23838.0318259457
Riso18862 a_58313_15032.t3 a_58313_15032.t71 22994.4020468224
Riso18863 a_58313_15032.t3 a_58313_15032.t72 21448.3659928504
Riso18864 a_58313_15032.t3 a_58313_15032.t73 19429.1799527935
Riso18865 a_58313_15032.t3 a_58313_15032.t74 17181.3167730266
Riso18866 a_58313_15032.t3 a_58313_15032.t75 14909.3504620774
Riso18867 a_58313_15032.t3 a_58313_15032.t76 12754.7556868125
Riso18868 a_58313_15032.t3 a_58313_15032.t77 10798.1054752846
Riso18869 a_58313_15032.t3 a_58313_15032.t78 9073.30886432154
Riso18870 a_58313_15032.t3 a_58313_15032.t79 7583.70580638156
Riso18871 a_58313_15032.t3 a_58313_15032.t8 82356.5855003748
Riso18872 a_58313_15032.t3 a_58313_15032.t80 7583.70580638156
Riso18873 a_58313_15032.t3 a_58313_15032.t81 9073.30886432154
Riso18874 a_58313_15032.t3 a_58313_15032.t82 10798.1054752846
Riso18875 a_58313_15032.t3 a_58313_15032.t83 12754.7556868125
Riso18876 a_58313_15032.t3 a_58313_15032.t84 14909.3504620774
Riso18877 a_58313_15032.t3 a_58313_15032.t85 17181.3167730266
Riso18878 a_58313_15032.t3 a_58313_15032.t86 19429.1799527935
Riso18879 a_58313_15032.t3 a_58313_15032.t87 21448.3659928504
Riso18880 a_58313_15032.t3 a_58313_15032.t88 22994.4020468224
Riso18881 a_58313_15032.t3 a_58313_15032.t89 23838.0318259457
Riso18882 a_58313_15032.t3 a_58313_15032.t9 125123.688223934
Riso18883 a_58313_15032.t3 a_58313_15032.t90 20148.037884961
Riso18884 a_58313_15032.t3 a_58313_15032.t91 19434.9972751168
Riso18885 a_58313_15032.t3 a_58313_15032.t92 18128.2789514572
Riso18886 a_58313_15032.t3 a_58313_15032.t93 16421.6516120486
Riso18887 a_58313_15032.t3 a_58313_15032.t94 14521.7450745945
Riso18888 a_58313_15032.t3 a_58313_15032.t95 12601.4664357962
Riso18889 a_58313_15032.t3 a_58313_15032.t96 10780.3908757103
Riso18890 a_58313_15032.t3 a_58313_15032.t97 9126.61916849365
Riso18891 a_58313_15032.t3 a_58313_15032.t98 7668.81142181083
Riso18892 a_58313_15032.t3 a_58313_15032.t99 6409.79058216825
Riso18893 a_58313_15032.t30 a_58313_15032.t31 1933.74060193159
Riso18894 a_58313_15032.t30 a_58313_15032.t32 2374.8749182081
Riso18895 a_58313_15032.t30 a_58313_15032.t33 2937.14690578451
Riso18896 a_58313_15032.t30 a_58313_15032.t34 3671.74781546846
Riso18897 a_58313_15032.t30 a_58313_15032.t35 4667.97163614426
Riso18898 a_58313_15032.t30 a_58313_15032.t36 6098.98425357067
Riso18899 a_58313_15032.t30 a_58313_15032.t37 8353.28218284051
Riso18900 a_58313_15032.t30 a_58313_15032.t38 12522.3185322237
Riso18901 a_58313_15032.t30 a_58313_15032.t39 23292.981356726
Riso18902 a_58313_15032.t30 a_58313_15032.t4 674955987.654933
Riso18903 a_58313_15032.t30 a_58313_15032.t40 43571.23701946
Riso18904 a_58313_15032.t30 a_58313_15032.t41 52129.5658311868
Riso18905 a_58313_15032.t30 a_58313_15032.t42 62039.1699040918
Riso18906 a_58313_15032.t30 a_58313_15032.t43 73280.8599573791
Riso18907 a_58313_15032.t30 a_58313_15032.t44 85659.8158439546
Riso18908 a_58313_15032.t30 a_58313_15032.t45 98713.1152680031
Riso18909 a_58313_15032.t30 a_58313_15032.t46 111627.933154335
Riso18910 a_58313_15032.t30 a_58313_15032.t47 123228.91502044
Riso18911 a_58313_15032.t30 a_58313_15032.t48 132111.472581093
Riso18912 a_58313_15032.t30 a_58313_15032.t49 136958.442387322
Riso18913 a_58313_15032.t30 a_58313_15032.t5 3556945.09557485
Riso18914 a_58313_15032.t30 a_58313_15032.t50 181689.889209134
Riso18915 a_58313_15032.t30 a_58313_15032.t51 175259.870060673
Riso18916 a_58313_15032.t30 a_58313_15032.t52 163476.21604886
Riso18917 a_58313_15032.t30 a_58313_15032.t53 148086.284086807
Riso18918 a_58313_15032.t30 a_58313_15032.t54 130953.409398529
Riso18919 a_58313_15032.t30 a_58313_15032.t55 113636.824273663
Riso18920 a_58313_15032.t30 a_58313_15032.t56 97214.8273207775
Riso18921 a_58313_15032.t30 a_58313_15032.t57 82301.534027554
Riso18922 a_58313_15032.t30 a_58313_15032.t58 69155.3939669021
Riso18923 a_58313_15032.t30 a_58313_15032.t59 57801.863753551
Riso18924 a_58313_15032.t30 a_58313_15032.t6 35909.0370633066
Riso18925 a_58313_15032.t30 a_58313_15032.t60 57801.863753551
Riso18926 a_58313_15032.t30 a_58313_15032.t61 69155.3939669021
Riso18927 a_58313_15032.t30 a_58313_15032.t62 82301.534027554
Riso18928 a_58313_15032.t30 a_58313_15032.t63 97214.8273207775
Riso18929 a_58313_15032.t30 a_58313_15032.t64 113636.824273663
Riso18930 a_58313_15032.t30 a_58313_15032.t65 130953.409398529
Riso18931 a_58313_15032.t30 a_58313_15032.t66 148086.284086807
Riso18932 a_58313_15032.t30 a_58313_15032.t67 163476.21604886
Riso18933 a_58313_15032.t30 a_58313_15032.t68 175259.870060673
Riso18934 a_58313_15032.t30 a_58313_15032.t69 181689.889209134
Riso18935 a_58313_15032.t30 a_58313_15032.t7 444256969.206412
Riso18936 a_58313_15032.t30 a_58313_15032.t70 235673.946691926
Riso18937 a_58313_15032.t30 a_58313_15032.t71 227333.427598548
Riso18938 a_58313_15032.t30 a_58313_15032.t72 212048.591114229
Riso18939 a_58313_15032.t30 a_58313_15032.t73 192085.972277236
Riso18940 a_58313_15032.t30 a_58313_15032.t74 169862.544140753
Riso18941 a_58313_15032.t30 a_58313_15032.t75 147400.821161186
Riso18942 a_58313_15032.t30 a_58313_15032.t76 126099.48815198
Riso18943 a_58313_15032.t30 a_58313_15032.t77 106755.127803218
Riso18944 a_58313_15032.t30 a_58313_15032.t78 89702.9807335893
Riso18945 a_58313_15032.t30 a_58313_15032.t79 74976.0672772955
Riso18946 a_58313_15032.t30 a_58313_15032.t8 444256969.206412
Riso18947 a_58313_15032.t30 a_58313_15032.t80 74976.0672772955
Riso18948 a_58313_15032.t30 a_58313_15032.t81 89702.9807335893
Riso18949 a_58313_15032.t30 a_58313_15032.t82 106755.127803218
Riso18950 a_58313_15032.t30 a_58313_15032.t83 126099.48815198
Riso18951 a_58313_15032.t30 a_58313_15032.t84 147400.821161186
Riso18952 a_58313_15032.t30 a_58313_15032.t85 169862.544140753
Riso18953 a_58313_15032.t30 a_58313_15032.t86 192085.972277236
Riso18954 a_58313_15032.t30 a_58313_15032.t87 212048.591114229
Riso18955 a_58313_15032.t30 a_58313_15032.t88 227333.427598548
Riso18956 a_58313_15032.t30 a_58313_15032.t89 235673.946691926
Riso18957 a_58313_15032.t30 a_58313_15032.t9 674955987.654933
Riso18958 a_58313_15032.t30 a_58313_15032.t90 306151.54386968
Riso18959 a_58313_15032.t30 a_58313_15032.t91 295316.817193464
Riso18960 a_58313_15032.t30 a_58313_15032.t92 275461.095535834
Riso18961 a_58313_15032.t30 a_58313_15032.t93 249528.714539064
Riso18962 a_58313_15032.t30 a_58313_15032.t94 220659.435904057
Riso18963 a_58313_15032.t30 a_58313_15032.t95 191480.601057468
Riso18964 a_58313_15032.t30 a_58313_15032.t96 163809.167372117
Riso18965 a_58313_15032.t30 a_58313_15032.t97 138679.9332371
Riso18966 a_58313_15032.t30 a_58313_15032.t98 116528.391987256
Riso18967 a_58313_15032.t30 a_58313_15032.t99 97397.4385901322
Riso18968 a_58313_15032.t31 a_58313_15032.t32 2290.82791225886
Riso18969 a_58313_15032.t31 a_58313_15032.t33 2833.20105096429
Riso18970 a_58313_15032.t31 a_58313_15032.t34 3541.80437797423
Riso18971 a_58313_15032.t31 a_58313_15032.t35 4502.77176104097
Riso18972 a_58313_15032.t31 a_58313_15032.t36 5883.1407319123
Riso18973 a_58313_15032.t31 a_58313_15032.t37 8057.65888414206
Riso18974 a_58313_15032.t31 a_58313_15032.t38 12079.1527165814
Riso18975 a_58313_15032.t31 a_58313_15032.t39 22468.6409556149
Riso18976 a_58313_15032.t31 a_58313_15032.t4 651069243.357379
Riso18977 a_58313_15032.t31 a_58313_15032.t40 42029.2475913374
Riso18978 a_58313_15032.t31 a_58313_15032.t41 50284.6964884044
Riso18979 a_58313_15032.t31 a_58313_15032.t42 59843.5989112626
Riso18980 a_58313_15032.t31 a_58313_15032.t43 70687.4446892393
Riso18981 a_58313_15032.t31 a_58313_15032.t44 82628.3083752244
Riso18982 a_58313_15032.t31 a_58313_15032.t45 95219.6505290441
Riso18983 a_58313_15032.t31 a_58313_15032.t46 107677.412017414
Riso18984 a_58313_15032.t31 a_58313_15032.t47 118867.834243328
Riso18985 a_58313_15032.t31 a_58313_15032.t48 127436.037408969
Riso18986 a_58313_15032.t31 a_58313_15032.t49 132111.472581093
Riso18987 a_58313_15032.t31 a_58313_15032.t5 3431064.53516434
Riso18988 a_58313_15032.t31 a_58313_15032.t50 175259.870060673
Riso18989 a_58313_15032.t31 a_58313_15032.t51 169057.409784252
Riso18990 a_58313_15032.t31 a_58313_15032.t52 157690.780193912
Riso18991 a_58313_15032.t31 a_58313_15032.t53 142845.499107261
Riso18992 a_58313_15032.t31 a_58313_15032.t54 126318.958171474
Riso18993 a_58313_15032.t31 a_58313_15032.t55 109615.208325574
Riso18994 a_58313_15032.t31 a_58313_15032.t56 93774.3871074677
Riso18995 a_58313_15032.t31 a_58313_15032.t57 79388.8764105101
Riso18996 a_58313_15032.t31 a_58313_15032.t58 66707.9792573544
Riso18997 a_58313_15032.t31 a_58313_15032.t59 55756.2513511775
Riso18998 a_58313_15032.t31 a_58313_15032.t6 34638.2134807456
Riso18999 a_58313_15032.t31 a_58313_15032.t60 55756.2513511775
Riso19000 a_58313_15032.t31 a_58313_15032.t61 66707.9792573545
Riso19001 a_58313_15032.t31 a_58313_15032.t62 79388.8764105101
Riso19002 a_58313_15032.t31 a_58313_15032.t63 93774.3871074677
Riso19003 a_58313_15032.t31 a_58313_15032.t64 109615.208325574
Riso19004 a_58313_15032.t31 a_58313_15032.t65 126318.958171474
Riso19005 a_58313_15032.t31 a_58313_15032.t66 142845.499107261
Riso19006 a_58313_15032.t31 a_58313_15032.t67 157690.780193912
Riso19007 a_58313_15032.t31 a_58313_15032.t68 169057.409784252
Riso19008 a_58313_15032.t31 a_58313_15032.t69 175259.870060673
Riso19009 a_58313_15032.t31 a_58313_15032.t7 428534680.909201
Riso19010 a_58313_15032.t31 a_58313_15032.t70 227333.427598548
Riso19011 a_58313_15032.t31 a_58313_15032.t71 219288.080117153
Riso19012 a_58313_15032.t31 a_58313_15032.t72 204544.175171198
Riso19013 a_58313_15032.t31 a_58313_15032.t73 185288.034949685
Riso19014 a_58313_15032.t31 a_58313_15032.t74 163851.095643615
Riso19015 a_58313_15032.t31 a_58313_15032.t75 142184.294767281
Riso19016 a_58313_15032.t31 a_58313_15032.t76 121636.817571038
Riso19017 a_58313_15032.t31 a_58313_15032.t77 102977.055622322
Riso19018 a_58313_15032.t31 a_58313_15032.t78 86528.3853485535
Riso19019 a_58313_15032.t31 a_58313_15032.t79 72322.6584917667
Riso19020 a_58313_15032.t31 a_58313_15032.t8 428534680.909201
Riso19021 a_58313_15032.t31 a_58313_15032.t80 72322.6584917667
Riso19022 a_58313_15032.t31 a_58313_15032.t81 86528.3853485535
Riso19023 a_58313_15032.t31 a_58313_15032.t82 102977.055622322
Riso19024 a_58313_15032.t31 a_58313_15032.t83 121636.817571038
Riso19025 a_58313_15032.t31 a_58313_15032.t84 142184.294767281
Riso19026 a_58313_15032.t31 a_58313_15032.t85 163851.095643615
Riso19027 a_58313_15032.t31 a_58313_15032.t86 185288.034949685
Riso19028 a_58313_15032.t31 a_58313_15032.t87 204544.175171198
Riso19029 a_58313_15032.t31 a_58313_15032.t88 219288.080117153
Riso19030 a_58313_15032.t31 a_58313_15032.t89 227333.427598548
Riso19031 a_58313_15032.t31 a_58313_15032.t9 651069243.357379
Riso19032 a_58313_15032.t31 a_58313_15032.t90 295316.817193464
Riso19033 a_58313_15032.t31 a_58313_15032.t91 284865.532327355
Riso19034 a_58313_15032.t31 a_58313_15032.t92 265712.506185808
Riso19035 a_58313_15032.t31 a_58313_15032.t93 240697.874146344
Riso19036 a_58313_15032.t31 a_58313_15032.t94 212850.281501863
Riso19037 a_58313_15032.t31 a_58313_15032.t95 184704.087863929
Riso19038 a_58313_15032.t31 a_58313_15032.t96 158011.94834424
Riso19039 a_58313_15032.t31 a_58313_15032.t97 133772.039737339
Riso19040 a_58313_15032.t31 a_58313_15032.t98 112404.443235463
Riso19041 a_58313_15032.t31 a_58313_15032.t99 93950.5357499598
Riso19042 a_58313_15032.t32 a_58313_15032.t33 2125.38423373107
Riso19043 a_58313_15032.t32 a_58313_15032.t34 2656.9569942321
Riso19044 a_58313_15032.t32 a_58313_15032.t35 3377.8450222176
Riso19045 a_58313_15032.t32 a_58313_15032.t36 4413.35379613834
Riso19046 a_58313_15032.t32 a_58313_15032.t37 6044.60441843019
Riso19047 a_58313_15032.t32 a_58313_15032.t38 9061.3822519337
Riso19048 a_58313_15032.t32 a_58313_15032.t39 16855.1227473378
Riso19049 a_58313_15032.t32 a_58313_15032.t4 488446430.788094
Riso19050 a_58313_15032.t32 a_58313_15032.t40 31528.4196655621
Riso19051 a_58313_15032.t32 a_58313_15032.t41 37721.2799300407
Riso19052 a_58313_15032.t32 a_58313_15032.t42 44891.9314263609
Riso19053 a_58313_15032.t32 a_58313_15032.t43 53026.4886709009
Riso19054 a_58313_15032.t32 a_58313_15032.t44 61983.9785865331
Riso19055 a_58313_15032.t32 a_58313_15032.t45 71429.4277042121
Riso19056 a_58313_15032.t32 a_58313_15032.t46 80774.6707149331
Riso19057 a_58313_15032.t32 a_58313_15032.t47 89169.2137627647
Riso19058 a_58313_15032.t32 a_58313_15032.t48 95596.6879781677
Riso19059 a_58313_15032.t32 a_58313_15032.t49 99103.9856499976
Riso19060 a_58313_15032.t32 a_58313_15032.t5 2574059.89163694
Riso19061 a_58313_15032.t32 a_58313_15032.t50 131470.717025801
Riso19062 a_58313_15032.t32 a_58313_15032.t51 126817.958242043
Riso19063 a_58313_15032.t32 a_58313_15032.t52 118291.31182897
Riso19064 a_58313_15032.t32 a_58313_15032.t53 107155.164414071
Riso19065 a_58313_15032.t32 a_58313_15032.t54 94757.8244752015
Riso19066 a_58313_15032.t32 a_58313_15032.t55 82227.5517521891
Riso19067 a_58313_15032.t32 a_58313_15032.t56 70344.6026030136
Riso19068 a_58313_15032.t32 a_58313_15032.t57 59553.3507011571
Riso19069 a_58313_15032.t32 a_58313_15032.t58 50040.8100340971
Riso19070 a_58313_15032.t32 a_58313_15032.t59 41825.4009960891
Riso19071 a_58313_15032.t32 a_58313_15032.t6 25986.3477136475
Riso19072 a_58313_15032.t32 a_58313_15032.t60 41825.4009960891
Riso19073 a_58313_15032.t32 a_58313_15032.t61 50040.8100340971
Riso19074 a_58313_15032.t32 a_58313_15032.t62 59553.3507011571
Riso19075 a_58313_15032.t32 a_58313_15032.t63 70344.6026030136
Riso19076 a_58313_15032.t32 a_58313_15032.t64 82227.5517521891
Riso19077 a_58313_15032.t32 a_58313_15032.t65 94757.8244752015
Riso19078 a_58313_15032.t32 a_58313_15032.t66 107155.164414071
Riso19079 a_58313_15032.t32 a_58313_15032.t67 118291.31182897
Riso19080 a_58313_15032.t32 a_58313_15032.t68 126817.958242043
Riso19081 a_58313_15032.t32 a_58313_15032.t69 131470.717025801
Riso19082 a_58313_15032.t32 a_58313_15032.t7 321496119.644095
Riso19083 a_58313_15032.t32 a_58313_15032.t70 170531.039493158
Riso19084 a_58313_15032.t32 a_58313_15032.t71 164495.932894102
Riso19085 a_58313_15032.t32 a_58313_15032.t72 153435.995676852
Riso19086 a_58313_15032.t32 a_58313_15032.t73 138991.267317768
Riso19087 a_58313_15032.t32 a_58313_15032.t74 122910.642563052
Riso19088 a_58313_15032.t32 a_58313_15032.t75 106657.590317442
Riso19089 a_58313_15032.t32 a_58313_15032.t76 91244.1833132382
Riso19090 a_58313_15032.t32 a_58313_15032.t77 77246.819901164
Riso19091 a_58313_15032.t32 a_58313_15032.t78 64908.0764541624
Riso19092 a_58313_15032.t32 a_58313_15032.t79 54251.8461178052
Riso19093 a_58313_15032.t32 a_58313_15032.t8 321496119.644095
Riso19094 a_58313_15032.t32 a_58313_15032.t80 54251.8461178052
Riso19095 a_58313_15032.t32 a_58313_15032.t81 64908.0764541624
Riso19096 a_58313_15032.t32 a_58313_15032.t82 77246.819901164
Riso19097 a_58313_15032.t32 a_58313_15032.t83 91244.1833132382
Riso19098 a_58313_15032.t32 a_58313_15032.t84 106657.590317442
Riso19099 a_58313_15032.t32 a_58313_15032.t85 122910.642563052
Riso19100 a_58313_15032.t32 a_58313_15032.t86 138991.267317768
Riso19101 a_58313_15032.t32 a_58313_15032.t87 153435.995676852
Riso19102 a_58313_15032.t32 a_58313_15032.t88 164495.932894102
Riso19103 a_58313_15032.t32 a_58313_15032.t89 170531.039493158
Riso19104 a_58313_15032.t32 a_58313_15032.t9 488446430.788094
Riso19105 a_58313_15032.t32 a_58313_15032.t90 221522.336281991
Riso19106 a_58313_15032.t32 a_58313_15032.t91 213682.643769077
Riso19107 a_58313_15032.t32 a_58313_15032.t92 199315.6221478
Riso19108 a_58313_15032.t32 a_58313_15032.t93 180551.706894756
Riso19109 a_58313_15032.t32 a_58313_15032.t94 159662.738088103
Riso19110 a_58313_15032.t32 a_58313_15032.t95 138549.783426818
Riso19111 a_58313_15032.t32 a_58313_15032.t96 118527.540322076
Riso19112 a_58313_15032.t32 a_58313_15032.t97 100344.75873553
Riso19113 a_58313_15032.t32 a_58313_15032.t98 84316.5489545556
Riso19114 a_58313_15032.t32 a_58313_15032.t99 70473.9485277659
Riso19115 a_58313_15032.t33 a_58313_15032.t34 2065.22843960603
Riso19116 a_58313_15032.t33 a_58313_15032.t35 2625.56753583146
Riso19117 a_58313_15032.t33 a_58313_15032.t36 3430.45759229937
Riso19118 a_58313_15032.t33 a_58313_15032.t37 4698.40990553261
Riso19119 a_58313_15032.t33 a_58313_15032.t38 7043.31110402542
Riso19120 a_58313_15032.t33 a_58313_15032.t39 13101.2480661671
Riso19121 a_58313_15032.t33 a_58313_15032.t4 379680150.877602
Riso19122 a_58313_15032.t33 a_58313_15032.t40 24506.4448528137
Riso19123 a_58313_15032.t33 a_58313_15032.t41 29320.0381176356
Riso19124 a_58313_15032.t33 a_58313_15032.t42 34893.6500308663
Riso19125 a_58313_15032.t33 a_58313_15032.t43 41216.4876684635
Riso19126 a_58313_15032.t33 a_58313_15032.t44 48178.9753213682
Riso19127 a_58313_15032.t33 a_58313_15032.t45 55520.7444416674
Riso19128 a_58313_15032.t33 a_58313_15032.t46 62784.6252484981
Riso19129 a_58313_15032.t33 a_58313_15032.t47 69309.5449383663
Riso19130 a_58313_15032.t33 a_58313_15032.t48 74305.4991940345
Riso19131 a_58313_15032.t33 a_58313_15032.t49 77031.6554013178
Riso19132 a_58313_15032.t33 a_58313_15032.t5 2000873.35359954
Riso19133 a_58313_15032.t33 a_58313_15032.t50 102189.149665627
Riso19134 a_58313_15032.t33 a_58313_15032.t51 98572.6678020783
Riso19135 a_58313_15032.t33 a_58313_15032.t52 91945.102621305
Riso19136 a_58313_15032.t33 a_58313_15032.t53 83289.2326251278
Riso19137 a_58313_15032.t33 a_58313_15032.t54 73653.0668299709
Riso19138 a_58313_15032.t33 a_58313_15032.t55 63913.5754541709
Riso19139 a_58313_15032.t33 a_58313_15032.t56 54677.233730745
Riso19140 a_58313_15032.t33 a_58313_15032.t57 46289.4430452963
Riso19141 a_58313_15032.t33 a_58313_15032.t58 38895.5650478423
Riso19142 a_58313_15032.t33 a_58313_15032.t59 32509.9174850883
Riso19143 a_58313_15032.t33 a_58313_15032.t6 20199.7594797779
Riso19144 a_58313_15032.t33 a_58313_15032.t60 32509.9174850883
Riso19145 a_58313_15032.t33 a_58313_15032.t61 38895.5650478423
Riso19146 a_58313_15032.t33 a_58313_15032.t62 46289.4430452963
Riso19147 a_58313_15032.t33 a_58313_15032.t63 54677.233730745
Riso19148 a_58313_15032.t33 a_58313_15032.t64 63913.5754541709
Riso19149 a_58313_15032.t33 a_58313_15032.t65 73653.0668299709
Riso19150 a_58313_15032.t33 a_58313_15032.t66 83289.2326251278
Riso19151 a_58313_15032.t33 a_58313_15032.t67 91945.102621305
Riso19152 a_58313_15032.t33 a_58313_15032.t68 98572.6678020783
Riso19153 a_58313_15032.t33 a_58313_15032.t69 102189.149665627
Riso19154 a_58313_15032.t33 a_58313_15032.t7 249906003.031047
Riso19155 a_58313_15032.t33 a_58313_15032.t70 132548.695393516
Riso19156 a_58313_15032.t33 a_58313_15032.t71 127857.786872444
Riso19157 a_58313_15032.t33 a_58313_15032.t72 119261.227245307
Riso19158 a_58313_15032.t33 a_58313_15032.t73 108033.770326022
Riso19159 a_58313_15032.t33 a_58313_15032.t74 95534.7798860095
Riso19160 a_58313_15032.t33 a_58313_15032.t75 82901.7666954424
Riso19161 a_58313_15032.t33 a_58313_15032.t76 70921.3847306768
Riso19162 a_58313_15032.t33 a_58313_15032.t77 60041.6512538056
Riso19163 a_58313_15032.t33 a_58313_15032.t78 50451.1136510546
Riso19164 a_58313_15032.t33 a_58313_15032.t79 42168.3433524919
Riso19165 a_58313_15032.t33 a_58313_15032.t8 249906003.031047
Riso19166 a_58313_15032.t33 a_58313_15032.t80 42168.3433524919
Riso19167 a_58313_15032.t33 a_58313_15032.t81 50451.1136510546
Riso19168 a_58313_15032.t33 a_58313_15032.t82 60041.6512538056
Riso19169 a_58313_15032.t33 a_58313_15032.t83 70921.3847306768
Riso19170 a_58313_15032.t33 a_58313_15032.t84 82901.7666954424
Riso19171 a_58313_15032.t33 a_58313_15032.t85 95534.7798860095
Riso19172 a_58313_15032.t33 a_58313_15032.t86 108033.770326022
Riso19173 a_58313_15032.t33 a_58313_15032.t87 119261.227245307
Riso19174 a_58313_15032.t33 a_58313_15032.t88 127857.786872444
Riso19175 a_58313_15032.t33 a_58313_15032.t89 132548.695393516
Riso19176 a_58313_15032.t33 a_58313_15032.t9 379680150.877602
Riso19177 a_58313_15032.t33 a_58313_15032.t90 172180.21548276
Riso19178 a_58313_15032.t33 a_58313_15032.t91 166086.744418633
Riso19179 a_58313_15032.t33 a_58313_15032.t92 154919.848474342
Riso19180 a_58313_15032.t33 a_58313_15032.t93 140335.427662454
Riso19181 a_58313_15032.t33 a_58313_15032.t94 124099.289985738
Riso19182 a_58313_15032.t33 a_58313_15032.t95 107689.057301887
Riso19183 a_58313_15032.t33 a_58313_15032.t96 92126.5899223705
Riso19184 a_58313_15032.t33 a_58313_15032.t97 77993.8604459978
Riso19185 a_58313_15032.t33 a_58313_15032.t98 65535.7911595764
Riso19186 a_58313_15032.t33 a_58313_15032.t99 54776.5062751287
Riso19187 a_58313_15032.t34 a_58313_15032.t35 2084.77748465457
Riso19188 a_58313_15032.t34 a_58313_15032.t36 2723.88312095062
Riso19189 a_58313_15032.t34 a_58313_15032.t37 3730.6725961233
Riso19190 a_58313_15032.t34 a_58313_15032.t38 5592.58682955854
Riso19191 a_58313_15032.t34 a_58313_15032.t39 10402.7342272753
Riso19192 a_58313_15032.t34 a_58313_15032.t4 301484643.699714
Riso19193 a_58313_15032.t34 a_58313_15032.t40 19458.6862921078
Riso19194 a_58313_15032.t34 a_58313_15032.t41 23280.791123736
Riso19195 a_58313_15032.t34 a_58313_15032.t42 27706.3684110535
Riso19196 a_58313_15032.t34 a_58313_15032.t43 32726.8483217416
Riso19197 a_58313_15032.t34 a_58313_15032.t44 38255.2251982835
Riso19198 a_58313_15032.t34 a_58313_15032.t45 44084.760367461
Riso19199 a_58313_15032.t34 a_58313_15032.t46 49852.4504070528
Riso19200 a_58313_15032.t34 a_58313_15032.t47 55033.3881599136
Riso19201 a_58313_15032.t34 a_58313_15032.t48 59000.2918529886
Riso19202 a_58313_15032.t34 a_58313_15032.t49 61164.9231872932
Riso19203 a_58313_15032.t34 a_58313_15032.t5 1588791.48331531
Riso19204 a_58313_15032.t34 a_58313_15032.t50 81140.286126853
Riso19205 a_58313_15032.t34 a_58313_15032.t51 78268.7251622981
Riso19206 a_58313_15032.t34 a_58313_15032.t52 73006.3021276421
Riso19207 a_58313_15032.t34 a_58313_15032.t53 66133.3633619826
Riso19208 a_58313_15032.t34 a_58313_15032.t54 58482.0495743327
Riso19209 a_58313_15032.t34 a_58313_15032.t55 50748.6931509917
Riso19210 a_58313_15032.t34 a_58313_15032.t56 43414.8478977881
Riso19211 a_58313_15032.t34 a_58313_15032.t57 36754.7696173011
Riso19212 a_58313_15032.t34 a_58313_15032.t58 30883.8784486837
Riso19213 a_58313_15032.t34 a_58313_15032.t59 25813.542977232
Riso19214 a_58313_15032.t34 a_58313_15032.t6 16039.5987925742
Riso19215 a_58313_15032.t34 a_58313_15032.t60 25813.542977232
Riso19216 a_58313_15032.t34 a_58313_15032.t61 30883.8784486837
Riso19217 a_58313_15032.t34 a_58313_15032.t62 36754.7696173011
Riso19218 a_58313_15032.t34 a_58313_15032.t63 43414.8478977881
Riso19219 a_58313_15032.t34 a_58313_15032.t64 50748.6931509917
Riso19220 a_58313_15032.t34 a_58313_15032.t65 58482.0495743327
Riso19221 a_58313_15032.t34 a_58313_15032.t66 66133.3633619826
Riso19222 a_58313_15032.t34 a_58313_15032.t67 73006.3021276421
Riso19223 a_58313_15032.t34 a_58313_15032.t68 78268.7251622981
Riso19224 a_58313_15032.t34 a_58313_15032.t69 81140.286126853
Riso19225 a_58313_15032.t34 a_58313_15032.t7 198437611.521396
Riso19226 a_58313_15032.t34 a_58313_15032.t70 105245.83100176
Riso19227 a_58313_15032.t34 a_58313_15032.t71 101521.172950712
Riso19228 a_58313_15032.t34 a_58313_15032.t72 94695.364073241
Riso19229 a_58313_15032.t34 a_58313_15032.t73 85780.579736824
Riso19230 a_58313_15032.t34 a_58313_15032.t74 75856.1769983681
Riso19231 a_58313_15032.t34 a_58313_15032.t75 65825.3580050152
Riso19232 a_58313_15032.t34 a_58313_15032.t76 56312.7388739337
Riso19233 a_58313_15032.t34 a_58313_15032.t77 47674.0526352535
Riso19234 a_58313_15032.t34 a_58313_15032.t78 40059.008995944
Riso19235 a_58313_15032.t34 a_58313_15032.t79 33482.3539750786
Riso19236 a_58313_15032.t34 a_58313_15032.t8 198437611.521396
Riso19237 a_58313_15032.t34 a_58313_15032.t80 33482.3539750786
Riso19238 a_58313_15032.t34 a_58313_15032.t81 40059.008995944
Riso19239 a_58313_15032.t34 a_58313_15032.t82 47674.0526352535
Riso19240 a_58313_15032.t34 a_58313_15032.t83 56312.7388739337
Riso19241 a_58313_15032.t34 a_58313_15032.t84 65825.3580050152
Riso19242 a_58313_15032.t34 a_58313_15032.t85 75856.1769983681
Riso19243 a_58313_15032.t34 a_58313_15032.t86 85780.579736824
Riso19244 a_58313_15032.t34 a_58313_15032.t87 94695.364073241
Riso19245 a_58313_15032.t34 a_58313_15032.t88 101521.172950712
Riso19246 a_58313_15032.t34 a_58313_15032.t89 105245.83100176
Riso19247 a_58313_15032.t34 a_58313_15032.t9 301484643.699714
Riso19248 a_58313_15032.t34 a_58313_15032.t90 136712.683004635
Riso19249 a_58313_15032.t34 a_58313_15032.t91 131874.410641854
Riso19250 a_58313_15032.t34 a_58313_15032.t92 123007.79201731
Riso19251 a_58313_15032.t34 a_58313_15032.t93 111427.627050786
Riso19252 a_58313_15032.t34 a_58313_15032.t94 98535.9836224573
Riso19253 a_58313_15032.t34 a_58313_15032.t95 85506.1071488495
Riso19254 a_58313_15032.t34 a_58313_15032.t96 73149.364164991
Riso19255 a_58313_15032.t34 a_58313_15032.t97 61927.8462950296
Riso19256 a_58313_15032.t34 a_58313_15032.t98 52036.0240991465
Riso19257 a_58313_15032.t34 a_58313_15032.t99 43493.0524247303
Riso19258 a_58313_15032.t35 a_58313_15032.t36 2191.97598272422
Riso19259 a_58313_15032.t35 a_58313_15032.t37 3002.16352939181
Riso19260 a_58313_15032.t35 a_58313_15032.t38 4500.48902738702
Riso19261 a_58313_15032.t35 a_58313_15032.t39 8371.31754491249
Riso19262 a_58313_15032.t35 a_58313_15032.t4 242616021.472495
Riso19263 a_58313_15032.t35 a_58313_15032.t40 15658.811219835
Riso19264 a_58313_15032.t35 a_58313_15032.t41 18734.5387958102
Riso19265 a_58313_15032.t35 a_58313_15032.t42 22295.8932593436
Riso19266 a_58313_15032.t35 a_58313_15032.t43 26335.9782874024
Riso19267 a_58313_15032.t35 a_58313_15032.t44 30784.7786104223
Riso19268 a_58313_15032.t35 a_58313_15032.t45 35475.9273006894
Riso19269 a_58313_15032.t35 a_58313_15032.t46 40117.3079236517
Riso19270 a_58313_15032.t35 a_58313_15032.t47 44286.5167281878
Riso19271 a_58313_15032.t35 a_58313_15032.t48 47478.7669718398
Riso19272 a_58313_15032.t35 a_58313_15032.t49 49220.6910110882
Riso19273 a_58313_15032.t35 a_58313_15032.t5 1278560.20758151
Riso19274 a_58313_15032.t35 a_58313_15032.t50 65295.1430124234
Riso19275 a_58313_15032.t35 a_58313_15032.t51 62984.3428809527
Riso19276 a_58313_15032.t35 a_58313_15032.t52 58749.5702292696
Riso19277 a_58313_15032.t35 a_58313_15032.t53 53218.7847090193
Riso19278 a_58313_15032.t35 a_58313_15032.t54 47061.6258937734
Riso19279 a_58313_15032.t35 a_58313_15032.t55 40838.4457975304
Riso19280 a_58313_15032.t35 a_58313_15032.t56 34936.7599951133
Riso19281 a_58313_15032.t35 a_58313_15032.t57 29577.2673859985
Riso19282 a_58313_15032.t35 a_58313_15032.t58 24852.8487677804
Riso19283 a_58313_15032.t35 a_58313_15032.t59 20772.6526588855
Riso19284 a_58313_15032.t35 a_58313_15032.t6 12907.6678576883
Riso19285 a_58313_15032.t35 a_58313_15032.t60 20772.6526588855
Riso19286 a_58313_15032.t35 a_58313_15032.t61 24852.8487677804
Riso19287 a_58313_15032.t35 a_58313_15032.t62 29577.2673859985
Riso19288 a_58313_15032.t35 a_58313_15032.t63 34936.7599951133
Riso19289 a_58313_15032.t35 a_58313_15032.t64 40838.4457975304
Riso19290 a_58313_15032.t35 a_58313_15032.t65 47061.6258937734
Riso19291 a_58313_15032.t35 a_58313_15032.t66 53218.7847090193
Riso19292 a_58313_15032.t35 a_58313_15032.t67 58749.5702292696
Riso19293 a_58313_15032.t35 a_58313_15032.t68 62984.3428809527
Riso19294 a_58313_15032.t35 a_58313_15032.t69 65295.1430124234
Riso19295 a_58313_15032.t35 a_58313_15032.t7 159690202.549017
Riso19296 a_58313_15032.t35 a_58313_15032.t70 84693.0495924074
Riso19297 a_58313_15032.t35 a_58313_15032.t71 81695.75605565
Riso19298 a_58313_15032.t35 a_58313_15032.t72 76202.9154911793
Riso19299 a_58313_15032.t35 a_58313_15032.t73 69029.0420491315
Riso19300 a_58313_15032.t35 a_58313_15032.t74 61042.7120890496
Riso19301 a_58313_15032.t35 a_58313_15032.t75 52970.7472200345
Riso19302 a_58313_15032.t35 a_58313_15032.t76 45315.7862951795
Riso19303 a_58313_15032.t35 a_58313_15032.t77 38364.0935291872
Riso19304 a_58313_15032.t35 a_58313_15032.t78 32236.1427832655
Riso19305 a_58313_15032.t35 a_58313_15032.t79 26943.8004212674
Riso19306 a_58313_15032.t35 a_58313_15032.t8 159690202.549017
Riso19307 a_58313_15032.t35 a_58313_15032.t80 26943.8004212674
Riso19308 a_58313_15032.t35 a_58313_15032.t81 32236.1427832655
Riso19309 a_58313_15032.t35 a_58313_15032.t82 38364.0935291872
Riso19310 a_58313_15032.t35 a_58313_15032.t83 45315.7862951795
Riso19311 a_58313_15032.t35 a_58313_15032.t84 52970.7472200345
Riso19312 a_58313_15032.t35 a_58313_15032.t85 61042.7120890496
Riso19313 a_58313_15032.t35 a_58313_15032.t86 69029.0420491315
Riso19314 a_58313_15032.t35 a_58313_15032.t87 76202.9154911793
Riso19315 a_58313_15032.t35 a_58313_15032.t88 81695.75605565
Riso19316 a_58313_15032.t35 a_58313_15032.t89 84693.0495924074
Riso19317 a_58313_15032.t35 a_58313_15032.t9 242616021.472495
Riso19318 a_58313_15032.t35 a_58313_15032.t90 110014.313712621
Riso19319 a_58313_15032.t35 a_58313_15032.t91 106120.898691807
Riso19320 a_58313_15032.t35 a_58313_15032.t92 98985.8257673896
Riso19321 a_58313_15032.t35 a_58313_15032.t93 89667.1299926323
Riso19322 a_58313_15032.t35 a_58313_15032.t94 79293.0719811505
Riso19323 a_58313_15032.t35 a_58313_15032.t95 68807.7762024436
Riso19324 a_58313_15032.t35 a_58313_15032.t96 58864.1589080163
Riso19325 a_58313_15032.t35 a_58313_15032.t97 49834.0706956749
Riso19326 a_58313_15032.t35 a_58313_15032.t98 41874.0043263356
Riso19327 a_58313_15032.t35 a_58313_15032.t99 34999.373932348
Riso19328 a_58313_15032.t36 a_58313_15032.t37 2436.88900158747
Riso19329 a_58313_15032.t36 a_58313_15032.t38 3653.09491280337
Riso19330 a_58313_15032.t36 a_58313_15032.t39 6795.08094746841
Riso19331 a_58313_15032.t36 a_58313_15032.t4 196936175.596429
Riso19332 a_58313_15032.t36 a_58313_15032.t40 12710.3914747486
Riso19333 a_58313_15032.t36 a_58313_15032.t41 15206.9859487152
Riso19334 a_58313_15032.t36 a_58313_15032.t42 18097.7679356973
Riso19335 a_58313_15032.t36 a_58313_15032.t43 21377.1396310947
Riso19336 a_58313_15032.t36 a_58313_15032.t44 24988.2690396251
Riso19337 a_58313_15032.t36 a_58313_15032.t45 28796.1146980503
Riso19338 a_58313_15032.t36 a_58313_15032.t46 32563.5631890593
Riso19339 a_58313_15032.t36 a_58313_15032.t47 35947.745762159
Riso19340 a_58313_15032.t36 a_58313_15032.t48 38538.9226856526
Riso19341 a_58313_15032.t36 a_58313_15032.t49 39952.857380138
Riso19342 a_58313_15032.t36 a_58313_15032.t5 1037832.35757753
Riso19343 a_58313_15032.t36 a_58313_15032.t50 53000.5539717222
Riso19344 a_58313_15032.t36 a_58313_15032.t51 51124.8602916796
Riso19345 a_58313_15032.t36 a_58313_15032.t52 47687.4637851616
Riso19346 a_58313_15032.t36 a_58313_15032.t53 43198.0839791281
Riso19347 a_58313_15032.t36 a_58313_15032.t54 38200.2723036438
Riso19348 a_58313_15032.t36 a_58313_15032.t55 33148.8706625765
Riso19349 a_58313_15032.t36 a_58313_15032.t56 28358.4283346435
Riso19350 a_58313_15032.t36 a_58313_15032.t57 24008.0882605527
Riso19351 a_58313_15032.t36 a_58313_15032.t58 20173.2424755877
Riso19352 a_58313_15032.t36 a_58313_15032.t59 16861.3169003034
Riso19353 a_58313_15032.t36 a_58313_15032.t6 10477.4067612441
Riso19354 a_58313_15032.t36 a_58313_15032.t60 16861.3169003034
Riso19355 a_58313_15032.t36 a_58313_15032.t61 20173.2424755877
Riso19356 a_58313_15032.t36 a_58313_15032.t62 24008.0882605527
Riso19357 a_58313_15032.t36 a_58313_15032.t63 28358.4283346435
Riso19358 a_58313_15032.t36 a_58313_15032.t64 33148.8706625765
Riso19359 a_58313_15032.t36 a_58313_15032.t65 38200.2723036438
Riso19360 a_58313_15032.t36 a_58313_15032.t66 43198.0839791281
Riso19361 a_58313_15032.t36 a_58313_15032.t67 47687.4637851616
Riso19362 a_58313_15032.t36 a_58313_15032.t68 51124.8602916796
Riso19363 a_58313_15032.t36 a_58313_15032.t69 53000.5539717222
Riso19364 a_58313_15032.t36 a_58313_15032.t7 129623664.502255
Riso19365 a_58313_15032.t36 a_58313_15032.t70 68745.8269238383
Riso19366 a_58313_15032.t36 a_58313_15032.t71 66312.9068234345
Riso19367 a_58313_15032.t36 a_58313_15032.t72 61854.3370992053
Riso19368 a_58313_15032.t36 a_58313_15032.t73 56031.2634893404
Riso19369 a_58313_15032.t36 a_58313_15032.t74 49548.7143328902
Riso19370 a_58313_15032.t36 a_58313_15032.t75 42996.6548369672
Riso19371 a_58313_15032.t36 a_58313_15032.t76 36783.0797988568
Riso19372 a_58313_15032.t36 a_58313_15032.t77 31140.3514992083
Riso19373 a_58313_15032.t36 a_58313_15032.t78 26166.2592519183
Riso19374 a_58313_15032.t36 a_58313_15032.t79 21870.4350515788
Riso19375 a_58313_15032.t36 a_58313_15032.t8 129623664.502255
Riso19376 a_58313_15032.t36 a_58313_15032.t80 21870.4350515788
Riso19377 a_58313_15032.t36 a_58313_15032.t81 26166.2592519183
Riso19378 a_58313_15032.t36 a_58313_15032.t82 31140.3514992083
Riso19379 a_58313_15032.t36 a_58313_15032.t83 36783.0797988568
Riso19380 a_58313_15032.t36 a_58313_15032.t84 42996.6548369672
Riso19381 a_58313_15032.t36 a_58313_15032.t85 49548.7143328902
Riso19382 a_58313_15032.t36 a_58313_15032.t86 56031.2634893404
Riso19383 a_58313_15032.t36 a_58313_15032.t87 61854.3370992053
Riso19384 a_58313_15032.t36 a_58313_15032.t88 66312.9068234346
Riso19385 a_58313_15032.t36 a_58313_15032.t89 68745.8269238383
Riso19386 a_58313_15032.t36 a_58313_15032.t9 196936175.596429
Riso19387 a_58313_15032.t36 a_58313_15032.t90 89298.9067335209
Riso19388 a_58313_15032.t36 a_58313_15032.t91 86138.611558415
Riso19389 a_58313_15032.t36 a_58313_15032.t92 80347.0541681761
Riso19390 a_58313_15032.t36 a_58313_15032.t93 72783.0443881229
Riso19391 a_58313_15032.t36 a_58313_15032.t94 64362.394314939
Riso19392 a_58313_15032.t36 a_58313_15032.t95 55851.4522545996
Riso19393 a_58313_15032.t36 a_58313_15032.t96 47780.1920394207
Riso19394 a_58313_15032.t36 a_58313_15032.t97 40450.4457740778
Riso19395 a_58313_15032.t36 a_58313_15032.t98 33989.2390426966
Riso19396 a_58313_15032.t36 a_58313_15032.t99 28409.0835368981
Riso19397 a_58313_15032.t37 a_58313_15032.t38 2982.16830828607
Riso19398 a_58313_15032.t37 a_58313_15032.t39 5547.09424108132
Riso19399 a_58313_15032.t37 a_58313_15032.t4 160768092.242466
Riso19400 a_58313_15032.t37 a_58313_15032.t40 10375.9862075541
Riso19401 a_58313_15032.t37 a_58313_15032.t41 12414.0532394938
Riso19402 a_58313_15032.t37 a_58313_15032.t42 14773.9108477793
Riso19403 a_58313_15032.t37 a_58313_15032.t43 17450.9893271076
Riso19404 a_58313_15032.t37 a_58313_15032.t44 20398.8945124863
Riso19405 a_58313_15032.t37 a_58313_15032.t45 23507.386812728
Riso19406 a_58313_15032.t37 a_58313_15032.t46 26582.9013362612
Riso19407 a_58313_15032.t37 a_58313_15032.t47 29345.541005707
Riso19408 a_58313_15032.t37 a_58313_15032.t48 31460.8193645927
Riso19409 a_58313_15032.t37 a_58313_15032.t49 32615.0691701561
Riso19410 a_58313_15032.t37 a_58313_15032.t5 847230.467891065
Riso19411 a_58313_15032.t37 a_58313_15032.t50 43266.3705765498
Riso19412 a_58313_15032.t37 a_58313_15032.t51 41735.1703952817
Riso19413 a_58313_15032.t37 a_58313_15032.t52 38929.0927239257
Riso19414 a_58313_15032.t37 a_58313_15032.t53 35264.2410235008
Riso19415 a_58313_15032.t37 a_58313_15032.t54 31184.3370259184
Riso19416 a_58313_15032.t37 a_58313_15032.t55 27060.6854986152
Riso19417 a_58313_15032.t37 a_58313_15032.t56 23150.0649964875
Riso19418 a_58313_15032.t37 a_58313_15032.t57 19598.7167241648
Riso19419 a_58313_15032.t37 a_58313_15032.t58 16468.1860711315
Riso19420 a_58313_15032.t37 a_58313_15032.t59 13764.5350991313
Riso19421 a_58313_15032.t37 a_58313_15032.t6 8553.19085765813
Riso19422 a_58313_15032.t37 a_58313_15032.t60 13764.5350991313
Riso19423 a_58313_15032.t37 a_58313_15032.t61 16468.1860711315
Riso19424 a_58313_15032.t37 a_58313_15032.t62 19598.7167241648
Riso19425 a_58313_15032.t37 a_58313_15032.t63 23150.0649964875
Riso19426 a_58313_15032.t37 a_58313_15032.t64 27060.6854986152
Riso19427 a_58313_15032.t37 a_58313_15032.t65 31184.3370259184
Riso19428 a_58313_15032.t37 a_58313_15032.t66 35264.2410235008
Riso19429 a_58313_15032.t37 a_58313_15032.t67 38929.0927239257
Riso19430 a_58313_15032.t37 a_58313_15032.t68 41735.1703952817
Riso19431 a_58313_15032.t37 a_58313_15032.t69 43266.3705765498
Riso19432 a_58313_15032.t37 a_58313_15032.t7 105817781.768089
Riso19433 a_58313_15032.t37 a_58313_15032.t70 56119.7541081702
Riso19434 a_58313_15032.t37 a_58313_15032.t71 54133.671695477
Riso19435 a_58313_15032.t37 a_58313_15032.t72 50493.9767817031
Riso19436 a_58313_15032.t37 a_58313_15032.t73 45740.3870183355
Riso19437 a_58313_15032.t37 a_58313_15032.t74 40448.4430424902
Riso19438 a_58313_15032.t37 a_58313_15032.t75 35099.7552127451
Riso19439 a_58313_15032.t37 a_58313_15032.t76 30027.3847304213
Riso19440 a_58313_15032.t37 a_58313_15032.t77 25421.017495559
Riso19441 a_58313_15032.t37 a_58313_15032.t78 21360.4825319091
Riso19442 a_58313_15032.t37 a_58313_15032.t79 17853.6427919191
Riso19443 a_58313_15032.t37 a_58313_15032.t8 105817781.768089
Riso19444 a_58313_15032.t37 a_58313_15032.t80 17853.6427919191
Riso19445 a_58313_15032.t37 a_58313_15032.t81 21360.4825319091
Riso19446 a_58313_15032.t37 a_58313_15032.t82 25421.017495559
Riso19447 a_58313_15032.t37 a_58313_15032.t83 30027.3847304213
Riso19448 a_58313_15032.t37 a_58313_15032.t84 35099.7552127451
Riso19449 a_58313_15032.t37 a_58313_15032.t85 40448.4430424902
Riso19450 a_58313_15032.t37 a_58313_15032.t86 45740.3870183355
Riso19451 a_58313_15032.t37 a_58313_15032.t87 50493.9767817031
Riso19452 a_58313_15032.t37 a_58313_15032.t88 54133.671695477
Riso19453 a_58313_15032.t37 a_58313_15032.t89 56119.7541081702
Riso19454 a_58313_15032.t37 a_58313_15032.t9 160768092.242466
Riso19455 a_58313_15032.t37 a_58313_15032.t90 72897.8109067035
Riso19456 a_58313_15032.t37 a_58313_15032.t91 70317.951773918
Riso19457 a_58313_15032.t37 a_58313_15032.t92 65590.1015579144
Riso19458 a_58313_15032.t37 a_58313_15032.t93 59415.3366608679
Riso19459 a_58313_15032.t37 a_58313_15032.t94 52541.2664264106
Riso19460 a_58313_15032.t37 a_58313_15032.t95 45593.487694875
Riso19461 a_58313_15032.t37 a_58313_15032.t96 39004.6365827254
Riso19462 a_58313_15032.t37 a_58313_15032.t97 33021.1091601605
Riso19463 a_58313_15032.t37 a_58313_15032.t98 27746.6008401551
Riso19464 a_58313_15032.t37 a_58313_15032.t99 23191.3253527901
Riso19465 a_58313_15032.t38 a_58313_15032.t39 4545.49292195746
Riso19466 a_58313_15032.t38 a_58313_15032.t4 131739984.135381
Riso19467 a_58313_15032.t38 a_58313_15032.t40 8502.4585984806
Riso19468 a_58313_15032.t38 a_58313_15032.t41 10172.5244807366
Riso19469 a_58313_15032.t38 a_58313_15032.t42 12106.2772066365
Riso19470 a_58313_15032.t38 a_58313_15032.t43 14299.9721942802
Riso19471 a_58313_15032.t38 a_58313_15032.t44 16715.5923858992
Riso19472 a_58313_15032.t38 a_58313_15032.t45 19262.8034709775
Riso19473 a_58313_15032.t38 a_58313_15032.t46 21782.9913723771
Riso19474 a_58313_15032.t38 a_58313_15032.t47 24046.7982956055
Riso19475 a_58313_15032.t38 a_58313_15032.t48 25780.1339333875
Riso19476 a_58313_15032.t38 a_58313_15032.t49 26725.9679955957
Riso19477 a_58313_15032.t38 a_58313_15032.t5 694255.475960038
Riso19478 a_58313_15032.t38 a_58313_15032.t50 35454.0078680051
Riso19479 a_58313_15032.t38 a_58313_15032.t51 34199.2878036511
Riso19480 a_58313_15032.t38 a_58313_15032.t52 31899.8876341252
Riso19481 a_58313_15032.t38 a_58313_15032.t53 28896.7773826645
Riso19482 a_58313_15032.t38 a_58313_15032.t54 25553.5584691421
Riso19483 a_58313_15032.t38 a_58313_15032.t55 22174.4912687802
Riso19484 a_58313_15032.t38 a_58313_15032.t56 18969.989291756
Riso19485 a_58313_15032.t38 a_58313_15032.t57 16059.8877992773
Riso19486 a_58313_15032.t38 a_58313_15032.t58 13494.6192795316
Riso19487 a_58313_15032.t38 a_58313_15032.t59 11279.1512022163
Riso19488 a_58313_15032.t38 a_58313_15032.t6 7008.83621978524
Riso19489 a_58313_15032.t38 a_58313_15032.t60 11279.1512022163
Riso19490 a_58313_15032.t38 a_58313_15032.t61 13494.6192795316
Riso19491 a_58313_15032.t38 a_58313_15032.t62 16059.8877992773
Riso19492 a_58313_15032.t38 a_58313_15032.t63 18969.989291756
Riso19493 a_58313_15032.t38 a_58313_15032.t64 22174.4912687802
Riso19494 a_58313_15032.t38 a_58313_15032.t65 25553.5584691421
Riso19495 a_58313_15032.t38 a_58313_15032.t66 28896.7773826645
Riso19496 a_58313_15032.t38 a_58313_15032.t67 31899.8876341252
Riso19497 a_58313_15032.t38 a_58313_15032.t68 34199.2878036511
Riso19498 a_58313_15032.t38 a_58313_15032.t69 35454.0078680051
Riso19499 a_58313_15032.t38 a_58313_15032.t7 86711440.6653824
Riso19500 a_58313_15032.t38 a_58313_15032.t70 45986.4838016089
Riso19501 a_58313_15032.t38 a_58313_15032.t71 44359.0186041682
Riso19502 a_58313_15032.t38 a_58313_15032.t72 41376.5256503958
Riso19503 a_58313_15032.t38 a_58313_15032.t73 37481.2684076208
Riso19504 a_58313_15032.t38 a_58313_15032.t74 33144.8649469933
Riso19505 a_58313_15032.t38 a_58313_15032.t75 28761.9635934283
Riso19506 a_58313_15032.t38 a_58313_15032.t76 24605.4863114442
Riso19507 a_58313_15032.t38 a_58313_15032.t77 20830.868343198
Riso19508 a_58313_15032.t38 a_58313_15032.t78 17503.5243749434
Riso19509 a_58313_15032.t38 a_58313_15032.t79 14629.8975841517
Riso19510 a_58313_15032.t38 a_58313_15032.t8 86711440.6653824
Riso19511 a_58313_15032.t38 a_58313_15032.t80 14629.8975841517
Riso19512 a_58313_15032.t38 a_58313_15032.t81 17503.5243749434
Riso19513 a_58313_15032.t38 a_58313_15032.t82 20830.868343198
Riso19514 a_58313_15032.t38 a_58313_15032.t83 24605.4863114442
Riso19515 a_58313_15032.t38 a_58313_15032.t84 28761.9635934283
Riso19516 a_58313_15032.t38 a_58313_15032.t85 33144.8649469933
Riso19517 a_58313_15032.t38 a_58313_15032.t86 37481.2684076208
Riso19518 a_58313_15032.t38 a_58313_15032.t87 41376.5256503958
Riso19519 a_58313_15032.t38 a_58313_15032.t88 44359.0186041682
Riso19520 a_58313_15032.t38 a_58313_15032.t89 45986.4838016089
Riso19521 a_58313_15032.t38 a_58313_15032.t9 131739984.135381
Riso19522 a_58313_15032.t38 a_58313_15032.t90 59734.9098675072
Riso19523 a_58313_15032.t38 a_58313_15032.t91 57620.8868145373
Riso19524 a_58313_15032.t38 a_58313_15032.t92 53746.7278650801
Riso19525 a_58313_15032.t38 a_58313_15032.t93 48686.918523889
Riso19526 a_58313_15032.t38 a_58313_15032.t94 43054.0749477801
Riso19527 a_58313_15032.t38 a_58313_15032.t95 37360.8321583798
Riso19528 a_58313_15032.t38 a_58313_15032.t96 31961.7066919319
Riso19529 a_58313_15032.t38 a_58313_15032.t97 27058.6037478105
Riso19530 a_58313_15032.t38 a_58313_15032.t98 22736.494823385
Riso19531 a_58313_15032.t38 a_58313_15032.t99 19003.7493914589
Riso19532 a_58313_15032.t39 a_58313_15032.t4 108227637.662776
Riso19533 a_58313_15032.t39 a_58313_15032.t40 6984.95064957919
Riso19534 a_58313_15032.t39 a_58313_15032.t41 8356.94530665273
Riso19535 a_58313_15032.t39 a_58313_15032.t42 9945.56431637227
Riso19536 a_58313_15032.t39 a_58313_15032.t43 11747.7314250318
Riso19537 a_58313_15032.t39 a_58313_15032.t44 13732.214810767
Riso19538 a_58313_15032.t39 a_58313_15032.t45 15824.802915402
Riso19539 a_58313_15032.t39 a_58313_15032.t46 17895.1908996597
Riso19540 a_58313_15032.t39 a_58313_15032.t47 19754.9564552076
Riso19541 a_58313_15032.t39 a_58313_15032.t48 21178.9285626669
Riso19542 a_58313_15032.t39 a_58313_15032.t49 21955.9513697401
Riso19543 a_58313_15032.t39 a_58313_15032.t5 570347.951616474
Riso19544 a_58313_15032.t39 a_58313_15032.t50 29126.2096890925
Riso19545 a_58313_15032.t39 a_58313_15032.t51 28095.4308888073
Riso19546 a_58313_15032.t39 a_58313_15032.t52 26206.4255118669
Riso19547 a_58313_15032.t39 a_58313_15032.t53 23739.3075705286
Riso19548 a_58313_15032.t39 a_58313_15032.t54 20992.7832431713
Riso19549 a_58313_15032.t39 a_58313_15032.t55 18216.8087976956
Riso19550 a_58313_15032.t39 a_58313_15032.t56 15584.2433376945
Riso19551 a_58313_15032.t39 a_58313_15032.t57 13193.5340389873
Riso19552 a_58313_15032.t39 a_58313_15032.t58 11086.1122464185
Riso19553 a_58313_15032.t39 a_58313_15032.t59 9266.05884033779
Riso19554 a_58313_15032.t39 a_58313_15032.t6 5757.93136617616
Riso19555 a_58313_15032.t39 a_58313_15032.t60 9266.05884033779
Riso19556 a_58313_15032.t39 a_58313_15032.t61 11086.1122464185
Riso19557 a_58313_15032.t39 a_58313_15032.t62 13193.5340389873
Riso19558 a_58313_15032.t39 a_58313_15032.t63 15584.2433376945
Riso19559 a_58313_15032.t39 a_58313_15032.t64 18216.8087976956
Riso19560 a_58313_15032.t39 a_58313_15032.t65 20992.7832431713
Riso19561 a_58313_15032.t39 a_58313_15032.t66 23739.3075705286
Riso19562 a_58313_15032.t39 a_58313_15032.t67 26206.4255118669
Riso19563 a_58313_15032.t39 a_58313_15032.t68 28095.4308888073
Riso19564 a_58313_15032.t39 a_58313_15032.t69 29126.2096890925
Riso19565 a_58313_15032.t39 a_58313_15032.t7 71235581.5369341
Riso19566 a_58313_15032.t39 a_58313_15032.t70 37778.8341881875
Riso19567 a_58313_15032.t39 a_58313_15032.t71 36441.8383416164
Riso19568 a_58313_15032.t39 a_58313_15032.t72 33991.6595618231
Riso19569 a_58313_15032.t39 a_58313_15032.t73 30791.6263057476
Riso19570 a_58313_15032.t39 a_58313_15032.t74 27229.18243596
Riso19571 a_58313_15032.t39 a_58313_15032.t75 23628.5395989505
Riso19572 a_58313_15032.t39 a_58313_15032.t76 20213.9087539292
Riso19573 a_58313_15032.t39 a_58313_15032.t77 17112.9831219256
Riso19574 a_58313_15032.t39 a_58313_15032.t78 14379.5022016175
Riso19575 a_58313_15032.t39 a_58313_15032.t79 12018.7591946852
Riso19576 a_58313_15032.t39 a_58313_15032.t8 71235581.5369341
Riso19577 a_58313_15032.t39 a_58313_15032.t80 12018.7591946852
Riso19578 a_58313_15032.t39 a_58313_15032.t81 14379.5022016175
Riso19579 a_58313_15032.t39 a_58313_15032.t82 17112.9831219256
Riso19580 a_58313_15032.t39 a_58313_15032.t83 20213.9087539292
Riso19581 a_58313_15032.t39 a_58313_15032.t84 23628.5395989505
Riso19582 a_58313_15032.t39 a_58313_15032.t85 27229.18243596
Riso19583 a_58313_15032.t39 a_58313_15032.t86 30791.6263057476
Riso19584 a_58313_15032.t39 a_58313_15032.t87 33991.6595618231
Riso19585 a_58313_15032.t39 a_58313_15032.t88 36441.8383416164
Riso19586 a_58313_15032.t39 a_58313_15032.t89 37778.8341881875
Riso19587 a_58313_15032.t39 a_58313_15032.t9 108227637.662776
Riso19588 a_58313_15032.t39 a_58313_15032.t90 49073.3918930588
Riso19589 a_58313_15032.t39 a_58313_15032.t91 47336.6807809226
Riso19590 a_58313_15032.t39 a_58313_15032.t92 44153.9837482428
Riso19591 a_58313_15032.t39 a_58313_15032.t93 39997.2518262365
Riso19592 a_58313_15032.t39 a_58313_15032.t94 35369.7611194489
Riso19593 a_58313_15032.t39 a_58313_15032.t95 30692.6512825669
Riso19594 a_58313_15032.t39 a_58313_15032.t96 26257.1645549153
Riso19595 a_58313_15032.t39 a_58313_15032.t97 22229.1699902201
Riso19596 a_58313_15032.t39 a_58313_15032.t98 18678.4733285316
Riso19597 a_58313_15032.t39 a_58313_15032.t99 15611.9502547675
Riso19598 a_58313_15032.t4 a_58313_15032.t40 107528913.980201
Riso19599 a_58313_15032.t4 a_58313_15032.t41 128649907.22167
Riso19600 a_58313_15032.t4 a_58313_15032.t42 153105695.875486
Riso19601 a_58313_15032.t4 a_58313_15032.t43 180848922.954216
Riso19602 a_58313_15032.t4 a_58313_15032.t44 211398794.239664
Riso19603 a_58313_15032.t4 a_58313_15032.t45 243612869.554979
Riso19604 a_58313_15032.t4 a_58313_15032.t46 275485188.005546
Riso19605 a_58313_15032.t4 a_58313_15032.t47 304115106.880906
Riso19606 a_58313_15032.t4 a_58313_15032.t48 326036260.219681
Riso19607 a_58313_15032.t4 a_58313_15032.t49 337998036.726644
Riso19608 a_58313_15032.t4 a_58313_15032.t5 2479.9657994464
Riso19609 a_58313_15032.t4 a_58313_15032.t50 316110826.565923
Riso19610 a_58313_15032.t4 a_58313_15032.t51 304923640.109361
Riso19611 a_58313_15032.t4 a_58313_15032.t52 284422000.60782
Riso19612 a_58313_15032.t4 a_58313_15032.t53 257646024.605554
Riso19613 a_58313_15032.t4 a_58313_15032.t54 227837612.025545
Riso19614 a_58313_15032.t4 a_58313_15032.t55 197709573.195494
Riso19615 a_58313_15032.t4 a_58313_15032.t56 169137972.138131
Riso19616 a_58313_15032.t4 a_58313_15032.t57 143191269.818804
Riso19617 a_58313_15032.t4 a_58313_15032.t58 120319126.416587
Riso19618 a_58313_15032.t4 a_58313_15032.t59 100565832.296558
Riso19619 a_58313_15032.t4 a_58313_15032.t6 226375.145214963
Riso19620 a_58313_15032.t4 a_58313_15032.t60 100565832.296558
Riso19621 a_58313_15032.t4 a_58313_15032.t61 120319126.416587
Riso19622 a_58313_15032.t4 a_58313_15032.t62 143191269.818804
Riso19623 a_58313_15032.t4 a_58313_15032.t63 169137972.138131
Riso19624 a_58313_15032.t4 a_58313_15032.t64 197709573.195494
Riso19625 a_58313_15032.t4 a_58313_15032.t65 227837612.025545
Riso19626 a_58313_15032.t4 a_58313_15032.t66 257646024.605554
Riso19627 a_58313_15032.t4 a_58313_15032.t67 284422000.60782
Riso19628 a_58313_15032.t4 a_58313_15032.t68 304923640.109361
Riso19629 a_58313_15032.t4 a_58313_15032.t69 316110826.565923
Riso19630 a_58313_15032.t4 a_58313_15032.t7 17.808514393306
Riso19631 a_58313_15032.t4 a_58313_15032.t70 279370196.544399
Riso19632 a_58313_15032.t4 a_58313_15032.t71 269483263.809127
Riso19633 a_58313_15032.t4 a_58313_15032.t72 251364469.463329
Riso19634 a_58313_15032.t4 a_58313_15032.t73 227700586.26235
Riso19635 a_58313_15032.t4 a_58313_15032.t74 201356717.652658
Riso19636 a_58313_15032.t4 a_58313_15032.t75 174730372.01026
Riso19637 a_58313_15032.t4 a_58313_15032.t76 149479563.963927
Riso19638 a_58313_15032.t4 a_58313_15032.t77 126548570.408988
Riso19639 a_58313_15032.t4 a_58313_15032.t78 106334788.846729
Riso19640 a_58313_15032.t4 a_58313_15032.t79 88877361.9035834
Riso19641 a_58313_15032.t4 a_58313_15032.t8 17.808514393306
Riso19642 a_58313_15032.t4 a_58313_15032.t80 88877361.9035834
Riso19643 a_58313_15032.t4 a_58313_15032.t81 106334788.846729
Riso19644 a_58313_15032.t4 a_58313_15032.t82 126548570.408988
Riso19645 a_58313_15032.t4 a_58313_15032.t83 149479563.963927
Riso19646 a_58313_15032.t4 a_58313_15032.t84 174730372.01026
Riso19647 a_58313_15032.t4 a_58313_15032.t85 201356717.652658
Riso19648 a_58313_15032.t4 a_58313_15032.t86 227700586.26235
Riso19649 a_58313_15032.t4 a_58313_15032.t87 251364469.463329
Riso19650 a_58313_15032.t4 a_58313_15032.t88 269483263.809127
Riso19651 a_58313_15032.t4 a_58313_15032.t89 279370196.544399
Riso19652 a_58313_15032.t4 a_58313_15032.t9 0.791939371017997
Riso19653 a_58313_15032.t4 a_58313_15032.t90 236125253.334845
Riso19654 a_58313_15032.t4 a_58313_15032.t91 227768762.464676
Riso19655 a_58313_15032.t4 a_58313_15032.t92 212454656.099921
Riso19656 a_58313_15032.t4 a_58313_15032.t93 192453809.60723
Riso19657 a_58313_15032.t4 a_58313_15032.t94 170187824.45124
Riso19658 a_58313_15032.t4 a_58313_15032.t95 147683088.126608
Riso19659 a_58313_15032.t4 a_58313_15032.t96 126340963.874989
Riso19660 a_58313_15032.t4 a_58313_15032.t97 106959559.812015
Riso19661 a_58313_15032.t4 a_58313_15032.t98 89874758.5294083
Riso19662 a_58313_15032.t4 a_58313_15032.t99 75119643.5940551
Riso19663 a_58313_15032.t40 a_58313_15032.t41 4423.58125827247
Riso19664 a_58313_15032.t40 a_58313_15032.t42 5264.48484445922
Riso19665 a_58313_15032.t40 a_58313_15032.t43 6218.42583050287
Riso19666 a_58313_15032.t40 a_58313_15032.t44 7268.87227838171
Riso19667 a_58313_15032.t40 a_58313_15032.t45 8376.54178934271
Riso19668 a_58313_15032.t40 a_58313_15032.t46 9472.46011218058
Riso19669 a_58313_15032.t40 a_58313_15032.t47 10456.8896799741
Riso19670 a_58313_15032.t40 a_58313_15032.t48 11210.6407332262
Riso19671 a_58313_15032.t40 a_58313_15032.t49 11621.9421598232
Riso19672 a_58313_15032.t40 a_58313_15032.t5 566665.753337838
Riso19673 a_58313_15032.t40 a_58313_15032.t50 28938.1213810489
Riso19674 a_58313_15032.t40 a_58313_15032.t51 27913.9990404466
Riso19675 a_58313_15032.t40 a_58313_15032.t52 26037.1922924741
Riso19676 a_58313_15032.t40 a_58313_15032.t53 23586.0062572876
Riso19677 a_58313_15032.t40 a_58313_15032.t54 20857.2181585453
Riso19678 a_58313_15032.t40 a_58313_15032.t55 18099.170121696
Riso19679 a_58313_15032.t40 a_58313_15032.t56 15483.6049781958
Riso19680 a_58313_15032.t40 a_58313_15032.t57 13108.3341615917
Riso19681 a_58313_15032.t40 a_58313_15032.t58 11014.5214655559
Riso19682 a_58313_15032.t40 a_58313_15032.t59 9206.2214173392
Riso19683 a_58313_15032.t40 a_58313_15032.t6 5720.75783920031
Riso19684 a_58313_15032.t40 a_58313_15032.t60 9206.2214173392
Riso19685 a_58313_15032.t40 a_58313_15032.t61 11014.5214655559
Riso19686 a_58313_15032.t40 a_58313_15032.t62 13108.3341615917
Riso19687 a_58313_15032.t40 a_58313_15032.t63 15483.6049781958
Riso19688 a_58313_15032.t40 a_58313_15032.t64 18099.170121696
Riso19689 a_58313_15032.t40 a_58313_15032.t65 20857.2181585453
Riso19690 a_58313_15032.t40 a_58313_15032.t66 23586.0062572876
Riso19691 a_58313_15032.t40 a_58313_15032.t67 26037.1922924741
Riso19692 a_58313_15032.t40 a_58313_15032.t68 27913.9990404466
Riso19693 a_58313_15032.t40 a_58313_15032.t69 28938.1213810489
Riso19694 a_58313_15032.t40 a_58313_15032.t7 70775680.637896
Riso19695 a_58313_15032.t40 a_58313_15032.t70 37534.8606287358
Riso19696 a_58313_15032.t40 a_58313_15032.t71 36206.4990251918
Riso19697 a_58313_15032.t40 a_58313_15032.t72 33772.1433604059
Riso19698 a_58313_15032.t40 a_58313_15032.t73 30592.7757368365
Riso19699 a_58313_15032.t40 a_58313_15032.t74 27053.3379266571
Riso19700 a_58313_15032.t40 a_58313_15032.t75 23475.9478360104
Riso19701 a_58313_15032.t40 a_58313_15032.t76 20083.3684825021
Riso19702 a_58313_15032.t40 a_58313_15032.t77 17002.4684516133
Riso19703 a_58313_15032.t40 a_58313_15032.t78 14286.6401954001
Riso19704 a_58313_15032.t40 a_58313_15032.t79 11941.1427323478
Riso19705 a_58313_15032.t40 a_58313_15032.t8 70775680.637896
Riso19706 a_58313_15032.t40 a_58313_15032.t80 11941.1427323478
Riso19707 a_58313_15032.t40 a_58313_15032.t81 14286.6401954001
Riso19708 a_58313_15032.t40 a_58313_15032.t82 17002.4684516133
Riso19709 a_58313_15032.t40 a_58313_15032.t83 20083.3684825021
Riso19710 a_58313_15032.t40 a_58313_15032.t84 23475.9478360104
Riso19711 a_58313_15032.t40 a_58313_15032.t85 27053.3379266571
Riso19712 a_58313_15032.t40 a_58313_15032.t86 30592.7757368365
Riso19713 a_58313_15032.t40 a_58313_15032.t87 33772.1433604059
Riso19714 a_58313_15032.t40 a_58313_15032.t88 36206.4990251918
Riso19715 a_58313_15032.t40 a_58313_15032.t89 37534.8606287358
Riso19716 a_58313_15032.t40 a_58313_15032.t9 107528913.980201
Riso19717 a_58313_15032.t40 a_58313_15032.t90 48756.4585818577
Riso19718 a_58313_15032.t40 a_58313_15032.t91 47030.9637639726
Riso19719 a_58313_15032.t40 a_58313_15032.t92 43868.8217137426
Riso19720 a_58313_15032.t40 a_58313_15032.t93 39738.9354358012
Riso19721 a_58313_15032.t40 a_58313_15032.t94 35141.3306997133
Riso19722 a_58313_15032.t40 a_58313_15032.t95 30494.4272914126
Riso19723 a_58313_15032.t40 a_58313_15032.t96 26087.5865048944
Riso19724 a_58313_15032.t40 a_58313_15032.t97 22085.6061529047
Riso19725 a_58313_15032.t40 a_58313_15032.t98 18557.8411453499
Riso19726 a_58313_15032.t40 a_58313_15032.t99 15511.122761544
Riso19727 a_58313_15032.t41 a_58313_15032.t42 2824.09145366551
Riso19728 a_58313_15032.t41 a_58313_15032.t43 3335.82558636466
Riso19729 a_58313_15032.t41 a_58313_15032.t44 3899.32931439043
Riso19730 a_58313_15032.t41 a_58313_15032.t45 4493.52990415624
Riso19731 a_58313_15032.t41 a_58313_15032.t46 5081.42666155677
Riso19732 a_58313_15032.t41 a_58313_15032.t47 5609.51615393462
Riso19733 a_58313_15032.t41 a_58313_15032.t48 6013.85997304943
Riso19734 a_58313_15032.t41 a_58313_15032.t49 6234.49938565132
Riso19735 a_58313_15032.t41 a_58313_15032.t5 677971.104646642
Riso19736 a_58313_15032.t41 a_58313_15032.t50 34622.1913068595
Riso19737 a_58313_15032.t41 a_58313_15032.t51 33396.9092945592
Riso19738 a_58313_15032.t41 a_58313_15032.t52 31151.4573034406
Riso19739 a_58313_15032.t41 a_58313_15032.t53 28218.8055697139
Riso19740 a_58313_15032.t41 a_58313_15032.t54 24954.0247518267
Riso19741 a_58313_15032.t41 a_58313_15032.t55 21654.2367141747
Riso19742 a_58313_15032.t41 a_58313_15032.t56 18524.918277038
Riso19743 a_58313_15032.t41 a_58313_15032.t57 15683.0931448812
Riso19744 a_58313_15032.t41 a_58313_15032.t58 13178.0105664953
Riso19745 a_58313_15032.t41 a_58313_15032.t59 11014.5214655559
Riso19746 a_58313_15032.t41 a_58313_15032.t6 6844.43781684872
Riso19747 a_58313_15032.t41 a_58313_15032.t60 11014.5214655559
Riso19748 a_58313_15032.t41 a_58313_15032.t61 13178.0105664953
Riso19749 a_58313_15032.t41 a_58313_15032.t62 15683.0931448812
Riso19750 a_58313_15032.t41 a_58313_15032.t63 18524.918277038
Riso19751 a_58313_15032.t41 a_58313_15032.t64 21654.2367141747
Riso19752 a_58313_15032.t41 a_58313_15032.t65 24954.0247518267
Riso19753 a_58313_15032.t41 a_58313_15032.t66 28218.8055697139
Riso19754 a_58313_15032.t41 a_58313_15032.t67 31151.4573034406
Riso19755 a_58313_15032.t41 a_58313_15032.t68 33396.9092945592
Riso19756 a_58313_15032.t41 a_58313_15032.t69 34622.1913068595
Riso19757 a_58313_15032.t41 a_58313_15032.t7 84677547.7458313
Riso19758 a_58313_15032.t41 a_58313_15032.t70 44907.5151856764
Riso19759 a_58313_15032.t41 a_58313_15032.t71 43318.2347705109
Riso19760 a_58313_15032.t41 a_58313_15032.t72 40405.7192542012
Riso19761 a_58313_15032.t41 a_58313_15032.t73 36601.8553941878
Riso19762 a_58313_15032.t41 a_58313_15032.t74 32367.195812484
Riso19763 a_58313_15032.t41 a_58313_15032.t75 28087.1293055149
Riso19764 a_58313_15032.t41 a_58313_15032.t76 24028.1743424679
Riso19765 a_58313_15032.t41 a_58313_15032.t77 20342.1192298303
Riso19766 a_58313_15032.t41 a_58313_15032.t78 17092.8438465027
Riso19767 a_58313_15032.t41 a_58313_15032.t79 14286.6401954001
Riso19768 a_58313_15032.t41 a_58313_15032.t8 84677547.7458313
Riso19769 a_58313_15032.t41 a_58313_15032.t80 14286.6401954001
Riso19770 a_58313_15032.t41 a_58313_15032.t81 17092.8438465027
Riso19771 a_58313_15032.t41 a_58313_15032.t82 20342.1192298303
Riso19772 a_58313_15032.t41 a_58313_15032.t83 24028.1743424679
Riso19773 a_58313_15032.t41 a_58313_15032.t84 28087.1293055149
Riso19774 a_58313_15032.t41 a_58313_15032.t85 32367.195812484
Riso19775 a_58313_15032.t41 a_58313_15032.t86 36601.8553941878
Riso19776 a_58313_15032.t41 a_58313_15032.t87 40405.7192542012
Riso19777 a_58313_15032.t41 a_58313_15032.t88 43318.2347705109
Riso19778 a_58313_15032.t41 a_58313_15032.t89 44907.5151856764
Riso19779 a_58313_15032.t41 a_58313_15032.t9 128649907.22167
Riso19780 a_58313_15032.t41 a_58313_15032.t90 58333.2765191707
Riso19781 a_58313_15032.t41 a_58313_15032.t91 56268.857378164
Riso19782 a_58313_15032.t41 a_58313_15032.t92 52485.6025648702
Riso19783 a_58313_15032.t41 a_58313_15032.t93 47544.5177270654
Riso19784 a_58313_15032.t41 a_58313_15032.t94 42043.844458399
Riso19785 a_58313_15032.t41 a_58313_15032.t95 36484.1891971543
Riso19786 a_58313_15032.t41 a_58313_15032.t96 31211.7500239043
Riso19787 a_58313_15032.t41 a_58313_15032.t97 26423.6945890543
Riso19788 a_58313_15032.t41 a_58313_15032.t98 22203.0005996652
Riso19789 a_58313_15032.t41 a_58313_15032.t99 18557.8411453499
Riso19790 a_58313_15032.t42 a_58313_15032.t43 2223.51612249624
Riso19791 a_58313_15032.t42 a_58313_15032.t44 2599.12317745546
Riso19792 a_58313_15032.t42 a_58313_15032.t45 2995.19142417122
Riso19793 a_58313_15032.t42 a_58313_15032.t46 3387.05781064736
Riso19794 a_58313_15032.t42 a_58313_15032.t47 3739.05927775723
Riso19795 a_58313_15032.t42 a_58313_15032.t48 4008.57726590039
Riso19796 a_58313_15032.t42 a_58313_15032.t49 4155.64589358396
Riso19797 a_58313_15032.t42 a_58313_15032.t5 806850.467303809
Riso19798 a_58313_15032.t42 a_58313_15032.t50 41203.7195148327
Riso19799 a_58313_15032.t42 a_58313_15032.t51 39745.5167132271
Riso19800 a_58313_15032.t42 a_58313_15032.t52 37073.2140502887
Riso19801 a_58313_15032.t42 a_58313_15032.t53 33583.0779580877
Riso19802 a_58313_15032.t42 a_58313_15032.t54 29697.6764852185
Riso19803 a_58313_15032.t42 a_58313_15032.t55 25770.6130721389
Riso19804 a_58313_15032.t42 a_58313_15032.t56 22046.4247903062
Riso19805 a_58313_15032.t42 a_58313_15032.t57 18664.3810421859
Riso19806 a_58313_15032.t42 a_58313_15032.t58 15683.0931448812
Riso19807 a_58313_15032.t42 a_58313_15032.t59 13108.3341615917
Riso19808 a_58313_15032.t42 a_58313_15032.t6 8145.53572137051
Riso19809 a_58313_15032.t42 a_58313_15032.t60 13108.3341615917
Riso19810 a_58313_15032.t42 a_58313_15032.t61 15683.0931448812
Riso19811 a_58313_15032.t42 a_58313_15032.t62 18664.3810421859
Riso19812 a_58313_15032.t42 a_58313_15032.t63 22046.4247903062
Riso19813 a_58313_15032.t42 a_58313_15032.t64 25770.6130721389
Riso19814 a_58313_15032.t42 a_58313_15032.t65 29697.6764852185
Riso19815 a_58313_15032.t42 a_58313_15032.t66 33583.0779580877
Riso19816 a_58313_15032.t42 a_58313_15032.t67 37073.2140502887
Riso19817 a_58313_15032.t42 a_58313_15032.t68 39745.5167132271
Riso19818 a_58313_15032.t42 a_58313_15032.t69 41203.7195148327
Riso19819 a_58313_15032.t42 a_58313_15032.t7 100774381.829258
Riso19820 a_58313_15032.t42 a_58313_15032.t70 53444.2387952521
Riso19821 a_58313_15032.t42 a_58313_15032.t71 51552.8430751919
Riso19822 a_58313_15032.t42 a_58313_15032.t72 48086.67100789
Riso19823 a_58313_15032.t42 a_58313_15032.t73 43559.7091477506
Riso19824 a_58313_15032.t42 a_58313_15032.t74 38520.0591701147
Riso19825 a_58313_15032.t42 a_58313_15032.t75 33426.3706079166
Riso19826 a_58313_15032.t42 a_58313_15032.t76 28595.8259338829
Riso19827 a_58313_15032.t42 a_58313_15032.t77 24209.0677523682
Riso19828 a_58313_15032.t42 a_58313_15032.t78 20342.1192298304
Riso19829 a_58313_15032.t42 a_58313_15032.t79 17002.4684516133
Riso19830 a_58313_15032.t42 a_58313_15032.t8 100774381.829258
Riso19831 a_58313_15032.t42 a_58313_15032.t80 17002.4684516133
Riso19832 a_58313_15032.t42 a_58313_15032.t81 20342.1192298304
Riso19833 a_58313_15032.t42 a_58313_15032.t82 24209.0677523682
Riso19834 a_58313_15032.t42 a_58313_15032.t83 28595.8259338829
Riso19835 a_58313_15032.t42 a_58313_15032.t84 33426.3706079166
Riso19836 a_58313_15032.t42 a_58313_15032.t85 38520.0591701147
Riso19837 a_58313_15032.t42 a_58313_15032.t86 43559.7091477506
Riso19838 a_58313_15032.t42 a_58313_15032.t87 48086.67100789
Riso19839 a_58313_15032.t42 a_58313_15032.t88 51552.8430751919
Riso19840 a_58313_15032.t42 a_58313_15032.t89 53444.2387952521
Riso19841 a_58313_15032.t42 a_58313_15032.t9 153105695.875486
Riso19842 a_58313_15032.t42 a_58313_15032.t90 69422.1790519909
Riso19843 a_58313_15032.t42 a_58313_15032.t91 66965.3227977699
Riso19844 a_58313_15032.t42 a_58313_15032.t92 62462.8876746294
Riso19845 a_58313_15032.t42 a_58313_15032.t93 56582.5240676163
Riso19846 a_58313_15032.t42 a_58313_15032.t94 50036.1966992512
Riso19847 a_58313_15032.t42 a_58313_15032.t95 43419.6751176693
Riso19848 a_58313_15032.t42 a_58313_15032.t96 37144.9681550697
Riso19849 a_58313_15032.t42 a_58313_15032.t97 31446.7241759272
Riso19850 a_58313_15032.t42 a_58313_15032.t98 26423.6945890543
Riso19851 a_58313_15032.t42 a_58313_15032.t99 22085.6061529047
Riso19852 a_58313_15032.t43 a_58313_15032.t44 1896.98514757839
Riso19853 a_58313_15032.t43 a_58313_15032.t45 2186.05785793095
Riso19854 a_58313_15032.t43 a_58313_15032.t46 2472.06381618191
Riso19855 a_58313_15032.t43 a_58313_15032.t47 2728.97413148561
Riso19856 a_58313_15032.t43 a_58313_15032.t48 2925.68340057586
Riso19857 a_58313_15032.t43 a_58313_15032.t49 3033.02229271086
Riso19858 a_58313_15032.t43 a_58313_15032.t5 953054.275104615
Riso19859 a_58313_15032.t43 a_58313_15032.t50 48669.9613189124
Riso19860 a_58313_15032.t43 a_58313_15032.t51 46947.5276458133
Riso19861 a_58313_15032.t43 a_58313_15032.t52 43790.9954499563
Riso19862 a_58313_15032.t43 a_58313_15032.t53 39668.4358702558
Riso19863 a_58313_15032.t43 a_58313_15032.t54 35078.9875966621
Riso19864 a_58313_15032.t43 a_58313_15032.t55 30440.3281100424
Riso19865 a_58313_15032.t43 a_58313_15032.t56 26041.3053578391
Riso19866 a_58313_15032.t43 a_58313_15032.t57 22046.4247903062
Riso19867 a_58313_15032.t43 a_58313_15032.t58 18524.918277038
Riso19868 a_58313_15032.t43 a_58313_15032.t59 15483.6049781958
Riso19869 a_58313_15032.t43 a_58313_15032.t6 9621.53206431302
Riso19870 a_58313_15032.t43 a_58313_15032.t60 15483.6049781958
Riso19871 a_58313_15032.t43 a_58313_15032.t61 18524.918277038
Riso19872 a_58313_15032.t43 a_58313_15032.t62 22046.4247903062
Riso19873 a_58313_15032.t43 a_58313_15032.t63 26041.3053578391
Riso19874 a_58313_15032.t43 a_58313_15032.t64 30440.3281100424
Riso19875 a_58313_15032.t43 a_58313_15032.t65 35078.9875966621
Riso19876 a_58313_15032.t43 a_58313_15032.t66 39668.4358702558
Riso19877 a_58313_15032.t43 a_58313_15032.t67 43790.9954499563
Riso19878 a_58313_15032.t43 a_58313_15032.t68 46947.5276458133
Riso19879 a_58313_15032.t43 a_58313_15032.t69 48669.9613189124
Riso19880 a_58313_15032.t43 a_58313_15032.t7 119035012.453225
Riso19881 a_58313_15032.t43 a_58313_15032.t70 63128.5006672098
Riso19882 a_58313_15032.t43 a_58313_15032.t71 60894.37817492
Riso19883 a_58313_15032.t43 a_58313_15032.t72 56800.1249757749
Riso19884 a_58313_15032.t43 a_58313_15032.t73 51452.8635823985
Riso19885 a_58313_15032.t43 a_58313_15032.t74 45500.0133941018
Riso19886 a_58313_15032.t43 a_58313_15032.t75 39483.332662074
Riso19887 a_58313_15032.t43 a_58313_15032.t76 33777.4783071082
Riso19888 a_58313_15032.t43 a_58313_15032.t77 28595.8259338829
Riso19889 a_58313_15032.t43 a_58313_15032.t78 24028.174342468
Riso19890 a_58313_15032.t43 a_58313_15032.t79 20083.3684825021
Riso19891 a_58313_15032.t43 a_58313_15032.t8 119035012.453225
Riso19892 a_58313_15032.t43 a_58313_15032.t80 20083.3684825021
Riso19893 a_58313_15032.t43 a_58313_15032.t81 24028.174342468
Riso19894 a_58313_15032.t43 a_58313_15032.t82 28595.8259338829
Riso19895 a_58313_15032.t43 a_58313_15032.t83 33777.4783071082
Riso19896 a_58313_15032.t43 a_58313_15032.t84 39483.332662074
Riso19897 a_58313_15032.t43 a_58313_15032.t85 45500.0133941018
Riso19898 a_58313_15032.t43 a_58313_15032.t86 51452.8635823985
Riso19899 a_58313_15032.t43 a_58313_15032.t87 56800.1249757749
Riso19900 a_58313_15032.t43 a_58313_15032.t88 60894.37817492
Riso19901 a_58313_15032.t43 a_58313_15032.t89 63128.5006672098
Riso19902 a_58313_15032.t43 a_58313_15032.t9 180848922.954216
Riso19903 a_58313_15032.t43 a_58313_15032.t90 82001.6932674902
Riso19904 a_58313_15032.t43 a_58313_15032.t91 79099.6470379983
Riso19905 a_58313_15032.t43 a_58313_15032.t92 73781.3567024553
Riso19906 a_58313_15032.t43 a_58313_15032.t93 66835.4529669577
Riso19907 a_58313_15032.t43 a_58313_15032.t94 59102.9107705044
Riso19908 a_58313_15032.t43 a_58313_15032.t95 51287.4549516332
Riso19909 a_58313_15032.t43 a_58313_15032.t96 43875.7516211293
Riso19910 a_58313_15032.t43 a_58313_15032.t97 37144.9681550697
Riso19911 a_58313_15032.t43 a_58313_15032.t98 31211.7500239043
Riso19912 a_58313_15032.t43 a_58313_15032.t99 26087.5865048944
Riso19913 a_58313_15032.t44 a_58313_15032.t45 1672.78885074819
Riso19914 a_58313_15032.t44 a_58313_15032.t46 1891.64288357905
Riso19915 a_58313_15032.t44 a_58313_15032.t47 2088.23269913361
Riso19916 a_58313_15032.t44 a_58313_15032.t48 2238.75619556313
Riso19917 a_58313_15032.t44 a_58313_15032.t49 2320.89276910515
Riso19918 a_58313_15032.t44 a_58313_15032.t5 1114048.79449063
Riso19919 a_58313_15032.t44 a_58313_15032.t50 56891.5256471499
Riso19920 a_58313_15032.t44 a_58313_15032.t51 54878.130180354
Riso19921 a_58313_15032.t44 a_58313_15032.t52 51188.3813597221
Riso19922 a_58313_15032.t44 a_58313_15032.t53 46369.419155836
Riso19923 a_58313_15032.t44 a_58313_15032.t54 41004.6991706988
Riso19924 a_58313_15032.t44 a_58313_15032.t55 35582.4549773616
Riso19925 a_58313_15032.t44 a_58313_15032.t56 30440.3281100424
Riso19926 a_58313_15032.t44 a_58313_15032.t57 25770.613072139
Riso19927 a_58313_15032.t44 a_58313_15032.t58 21654.2367141748
Riso19928 a_58313_15032.t44 a_58313_15032.t59 18099.1701216961
Riso19929 a_58313_15032.t44 a_58313_15032.t6 11246.8476113014
Riso19930 a_58313_15032.t44 a_58313_15032.t60 18099.1701216961
Riso19931 a_58313_15032.t44 a_58313_15032.t61 21654.2367141748
Riso19932 a_58313_15032.t44 a_58313_15032.t62 25770.613072139
Riso19933 a_58313_15032.t44 a_58313_15032.t63 30440.3281100424
Riso19934 a_58313_15032.t44 a_58313_15032.t64 35582.4549773616
Riso19935 a_58313_15032.t44 a_58313_15032.t65 41004.6991706988
Riso19936 a_58313_15032.t44 a_58313_15032.t66 46369.419155836
Riso19937 a_58313_15032.t44 a_58313_15032.t67 51188.3813597221
Riso19938 a_58313_15032.t44 a_58313_15032.t68 54878.130180354
Riso19939 a_58313_15032.t44 a_58313_15032.t69 56891.5256471499
Riso19940 a_58313_15032.t44 a_58313_15032.t7 139142980.195054
Riso19941 a_58313_15032.t44 a_58313_15032.t70 73792.4711146028
Riso19942 a_58313_15032.t44 a_58313_15032.t71 71180.9498882732
Riso19943 a_58313_15032.t44 a_58313_15032.t72 66395.0757151089
Riso19944 a_58313_15032.t44 a_58313_15032.t73 60144.5291673131
Riso19945 a_58313_15032.t44 a_58313_15032.t74 53186.0948480007
Riso19946 a_58313_15032.t44 a_58313_15032.t75 46153.0474220136
Riso19947 a_58313_15032.t44 a_58313_15032.t76 39483.332662074
Riso19948 a_58313_15032.t44 a_58313_15032.t77 33426.3706079166
Riso19949 a_58313_15032.t44 a_58313_15032.t78 28087.129305515
Riso19950 a_58313_15032.t44 a_58313_15032.t79 23475.9478360104
Riso19951 a_58313_15032.t44 a_58313_15032.t8 139142980.195054
Riso19952 a_58313_15032.t44 a_58313_15032.t80 23475.9478360104
Riso19953 a_58313_15032.t44 a_58313_15032.t81 28087.129305515
Riso19954 a_58313_15032.t44 a_58313_15032.t82 33426.3706079166
Riso19955 a_58313_15032.t44 a_58313_15032.t83 39483.332662074
Riso19956 a_58313_15032.t44 a_58313_15032.t84 46153.0474220136
Riso19957 a_58313_15032.t44 a_58313_15032.t85 53186.0948480007
Riso19958 a_58313_15032.t44 a_58313_15032.t86 60144.5291673131
Riso19959 a_58313_15032.t44 a_58313_15032.t87 66395.0757151089
Riso19960 a_58313_15032.t44 a_58313_15032.t88 71180.9498882732
Riso19961 a_58313_15032.t44 a_58313_15032.t89 73792.4711146028
Riso19962 a_58313_15032.t44 a_58313_15032.t9 211398794.239664
Riso19963 a_58313_15032.t44 a_58313_15032.t90 95853.8143284758
Riso19964 a_58313_15032.t44 a_58313_15032.t91 92461.540469606
Riso19965 a_58313_15032.t44 a_58313_15032.t92 86244.8589102976
Riso19966 a_58313_15032.t44 a_58313_15032.t93 78125.6196546638
Riso19967 a_58313_15032.t44 a_58313_15032.t94 69086.8591797043
Riso19968 a_58313_15032.t44 a_58313_15032.t95 59951.1789138008
Riso19969 a_58313_15032.t44 a_58313_15032.t96 51287.4549516332
Riso19970 a_58313_15032.t44 a_58313_15032.t97 43419.6751176694
Riso19971 a_58313_15032.t44 a_58313_15032.t98 36484.1891971544
Riso19972 a_58313_15032.t44 a_58313_15032.t99 30494.4272914126
Riso19973 a_58313_15032.t45 a_58313_15032.t46 1487.74629706372
Riso19974 a_58313_15032.t45 a_58313_15032.t47 1642.36098288557
Riso19975 a_58313_15032.t45 a_58313_15032.t48 1760.74525952578
Riso19976 a_58313_15032.t45 a_58313_15032.t49 1825.34433591671
Riso19977 a_58313_15032.t45 a_58313_15032.t5 1283813.48922191
Riso19978 a_58313_15032.t45 a_58313_15032.t50 65560.9596360811
Riso19979 a_58313_15032.t45 a_58313_15032.t51 63240.7522338617
Riso19980 a_58313_15032.t45 a_58313_15032.t52 58988.739816458
Riso19981 a_58313_15032.t45 a_58313_15032.t53 53435.4384601847
Riso19982 a_58313_15032.t45 a_58313_15032.t54 47253.2138423065
Riso19983 a_58313_15032.t45 a_58313_15032.t55 41004.6991706988
Riso19984 a_58313_15032.t45 a_58313_15032.t56 35078.9875966621
Riso19985 a_58313_15032.t45 a_58313_15032.t57 29697.6764852185
Riso19986 a_58313_15032.t45 a_58313_15032.t58 24954.0247518267
Riso19987 a_58313_15032.t45 a_58313_15032.t59 20857.2181585453
Riso19988 a_58313_15032.t45 a_58313_15032.t6 12960.7022116241
Riso19989 a_58313_15032.t45 a_58313_15032.t60 20857.2181585453
Riso19990 a_58313_15032.t45 a_58313_15032.t61 24954.0247518267
Riso19991 a_58313_15032.t45 a_58313_15032.t62 29697.6764852185
Riso19992 a_58313_15032.t45 a_58313_15032.t63 35078.9875966621
Riso19993 a_58313_15032.t45 a_58313_15032.t64 41004.6991706988
Riso19994 a_58313_15032.t45 a_58313_15032.t65 47253.2138423065
Riso19995 a_58313_15032.t45 a_58313_15032.t66 53435.4384601847
Riso19996 a_58313_15032.t45 a_58313_15032.t67 58988.739816458
Riso19997 a_58313_15032.t45 a_58313_15032.t68 63240.7522338617
Riso19998 a_58313_15032.t45 a_58313_15032.t69 65560.9596360811
Riso19999 a_58313_15032.t45 a_58313_15032.t7 160346329.342444
Riso20000 a_58313_15032.t45 a_58313_15032.t70 85037.3612793688
Riso20001 a_58313_15032.t45 a_58313_15032.t71 82027.8825255373
Riso20002 a_58313_15032.t45 a_58313_15032.t72 76512.7113305122
Riso20003 a_58313_15032.t45 a_58313_15032.t73 69309.673175672
Riso20004 a_58313_15032.t45 a_58313_15032.t74 61290.8755366669
Riso20005 a_58313_15032.t45 a_58313_15032.t75 53186.0948480007
Riso20006 a_58313_15032.t45 a_58313_15032.t76 45500.0133941017
Riso20007 a_58313_15032.t45 a_58313_15032.t77 38520.0591701147
Riso20008 a_58313_15032.t45 a_58313_15032.t78 32367.195812484
Riso20009 a_58313_15032.t45 a_58313_15032.t79 27053.3379266571
Riso20010 a_58313_15032.t45 a_58313_15032.t8 160346329.342444
Riso20011 a_58313_15032.t45 a_58313_15032.t80 27053.3379266571
Riso20012 a_58313_15032.t45 a_58313_15032.t81 32367.195812484
Riso20013 a_58313_15032.t45 a_58313_15032.t82 38520.0591701147
Riso20014 a_58313_15032.t45 a_58313_15032.t83 45500.0133941017
Riso20015 a_58313_15032.t45 a_58313_15032.t84 53186.0948480007
Riso20016 a_58313_15032.t45 a_58313_15032.t85 61290.8755366669
Riso20017 a_58313_15032.t45 a_58313_15032.t86 69309.673175672
Riso20018 a_58313_15032.t45 a_58313_15032.t87 76512.7113305122
Riso20019 a_58313_15032.t45 a_58313_15032.t88 82027.8825255373
Riso20020 a_58313_15032.t45 a_58313_15032.t89 85037.3612793688
Riso20021 a_58313_15032.t45 a_58313_15032.t9 243612869.554979
Riso20022 a_58313_15032.t45 a_58313_15032.t90 110460.529589761
Riso20023 a_58313_15032.t45 a_58313_15032.t91 106551.322954746
Riso20024 a_58313_15032.t45 a_58313_15032.t92 99387.3103158872
Riso20025 a_58313_15032.t45 a_58313_15032.t93 90030.818095662
Riso20026 a_58313_15032.t45 a_58313_15032.t94 79614.6831103857
Riso20027 a_58313_15032.t45 a_58313_15032.t95 69086.8591797042
Riso20028 a_58313_15032.t45 a_58313_15032.t96 59102.9107705043
Riso20029 a_58313_15032.t45 a_58313_15032.t97 50036.1966992511
Riso20030 a_58313_15032.t45 a_58313_15032.t98 42043.844458399
Riso20031 a_58313_15032.t45 a_58313_15032.t99 35141.3306997133
Riso20032 a_58313_15032.t46 a_58313_15032.t47 1313.67185871014
Riso20033 a_58313_15032.t46 a_58313_15032.t48 1408.36364349838
Riso20034 a_58313_15032.t46 a_58313_15032.t49 1460.03437218576
Riso20035 a_58313_15032.t46 a_58313_15032.t5 1451777.16221817
Riso20036 a_58313_15032.t46 a_58313_15032.t50 74138.4202081071
Riso20037 a_58313_15032.t46 a_58313_15032.t51 71514.6558167598
Riso20038 a_58313_15032.t46 a_58313_15032.t52 66706.3448176317
Riso20039 a_58313_15032.t46 a_58313_15032.t53 60426.4948615145
Riso20040 a_58313_15032.t46 a_58313_15032.t54 53435.4384601847
Riso20041 a_58313_15032.t46 a_58313_15032.t55 46369.419155836
Riso20042 a_58313_15032.t46 a_58313_15032.t56 39668.4358702558
Riso20043 a_58313_15032.t46 a_58313_15032.t57 33583.0779580877
Riso20044 a_58313_15032.t46 a_58313_15032.t58 28218.8055697139
Riso20045 a_58313_15032.t46 a_58313_15032.t59 23586.0062572876
Riso20046 a_58313_15032.t46 a_58313_15032.t6 14656.3746487431
Riso20047 a_58313_15032.t46 a_58313_15032.t60 23586.0062572876
Riso20048 a_58313_15032.t46 a_58313_15032.t61 28218.8055697139
Riso20049 a_58313_15032.t46 a_58313_15032.t62 33583.0779580877
Riso20050 a_58313_15032.t46 a_58313_15032.t63 39668.4358702558
Riso20051 a_58313_15032.t46 a_58313_15032.t64 46369.419155836
Riso20052 a_58313_15032.t46 a_58313_15032.t65 53435.4384601847
Riso20053 a_58313_15032.t46 a_58313_15032.t66 60426.4948615145
Riso20054 a_58313_15032.t46 a_58313_15032.t67 66706.3448176317
Riso20055 a_58313_15032.t46 a_58313_15032.t68 71514.6558167598
Riso20056 a_58313_15032.t46 a_58313_15032.t69 74138.4202081071
Riso20057 a_58313_15032.t46 a_58313_15032.t7 181324733.646443
Riso20058 a_58313_15032.t46 a_58313_15032.t70 96162.9551933647
Riso20059 a_58313_15032.t46 a_58313_15032.t71 92759.740815518
Riso20060 a_58313_15032.t46 a_58313_15032.t72 86523.0096595667
Riso20061 a_58313_15032.t46 a_58313_15032.t73 78377.5848143106
Riso20062 a_58313_15032.t46 a_58313_15032.t74 69309.673175672
Riso20063 a_58313_15032.t46 a_58313_15032.t75 60144.529167313
Riso20064 a_58313_15032.t46 a_58313_15032.t76 51452.8635823984
Riso20065 a_58313_15032.t46 a_58313_15032.t77 43559.7091477506
Riso20066 a_58313_15032.t46 a_58313_15032.t78 36601.8553941878
Riso20067 a_58313_15032.t46 a_58313_15032.t79 30592.7757368366
Riso20068 a_58313_15032.t46 a_58313_15032.t8 181324733.646443
Riso20069 a_58313_15032.t46 a_58313_15032.t80 30592.7757368366
Riso20070 a_58313_15032.t46 a_58313_15032.t81 36601.8553941878
Riso20071 a_58313_15032.t46 a_58313_15032.t82 43559.7091477506
Riso20072 a_58313_15032.t46 a_58313_15032.t83 51452.8635823984
Riso20073 a_58313_15032.t46 a_58313_15032.t84 60144.529167313
Riso20074 a_58313_15032.t46 a_58313_15032.t85 69309.673175672
Riso20075 a_58313_15032.t46 a_58313_15032.t86 78377.5848143106
Riso20076 a_58313_15032.t46 a_58313_15032.t87 86523.0096595667
Riso20077 a_58313_15032.t46 a_58313_15032.t88 92759.740815518
Riso20078 a_58313_15032.t46 a_58313_15032.t89 96162.9551933647
Riso20079 a_58313_15032.t46 a_58313_15032.t9 275485188.005546
Riso20080 a_58313_15032.t46 a_58313_15032.t90 124912.283233706
Riso20081 a_58313_15032.t46 a_58313_15032.t91 120491.6279261
Riso20082 a_58313_15032.t46 a_58313_15032.t92 112390.334376643
Riso20083 a_58313_15032.t46 a_58313_15032.t93 101809.715121718
Riso20084 a_58313_15032.t46 a_58313_15032.t94 90030.8180956621
Riso20085 a_58313_15032.t46 a_58313_15032.t95 78125.6196546637
Riso20086 a_58313_15032.t46 a_58313_15032.t96 66835.4529669577
Riso20087 a_58313_15032.t46 a_58313_15032.t97 56582.5240676163
Riso20088 a_58313_15032.t46 a_58313_15032.t98 47544.5177270654
Riso20089 a_58313_15032.t46 a_58313_15032.t99 39738.9354358012
Riso20090 a_58313_15032.t47 a_58313_15032.t48 1138.69531617564
Riso20091 a_58313_15032.t47 a_58313_15032.t49 1180.47232242777
Riso20092 a_58313_15032.t47 a_58313_15032.t5 1602653.73994028
Riso20093 a_58313_15032.t47 a_58313_15032.t50 81843.2880141497
Riso20094 a_58313_15032.t47 a_58313_15032.t51 78946.8477587527
Riso20095 a_58313_15032.t47 a_58313_15032.t52 73638.8309321381
Riso20096 a_58313_15032.t47 a_58313_15032.t53 66706.3448176317
Riso20097 a_58313_15032.t47 a_58313_15032.t54 58988.7398164581
Riso20098 a_58313_15032.t47 a_58313_15032.t55 51188.381359722
Riso20099 a_58313_15032.t47 a_58313_15032.t56 43790.9954499563
Riso20100 a_58313_15032.t47 a_58313_15032.t57 37073.2140502887
Riso20101 a_58313_15032.t47 a_58313_15032.t58 31151.4573034406
Riso20102 a_58313_15032.t47 a_58313_15032.t59 26037.1922924741
Riso20103 a_58313_15032.t47 a_58313_15032.t6 16179.5448062325
Riso20104 a_58313_15032.t47 a_58313_15032.t60 26037.1922924741
Riso20105 a_58313_15032.t47 a_58313_15032.t61 31151.4573034406
Riso20106 a_58313_15032.t47 a_58313_15032.t62 37073.2140502887
Riso20107 a_58313_15032.t47 a_58313_15032.t63 43790.9954499563
Riso20108 a_58313_15032.t47 a_58313_15032.t64 51188.381359722
Riso20109 a_58313_15032.t47 a_58313_15032.t65 58988.7398164581
Riso20110 a_58313_15032.t47 a_58313_15032.t66 66706.3448176317
Riso20111 a_58313_15032.t47 a_58313_15032.t67 73638.8309321381
Riso20112 a_58313_15032.t47 a_58313_15032.t68 78946.8477587526
Riso20113 a_58313_15032.t47 a_58313_15032.t69 81843.2880141497
Riso20114 a_58313_15032.t47 a_58313_15032.t7 200168986.04338
Riso20115 a_58313_15032.t47 a_58313_15032.t70 106156.732448444
Riso20116 a_58313_15032.t47 a_58313_15032.t71 102399.837525162
Riso20117 a_58313_15032.t47 a_58313_15032.t72 95514.9513510219
Riso20118 a_58313_15032.t47 a_58313_15032.t73 86523.0096595666
Riso20119 a_58313_15032.t47 a_58313_15032.t74 76512.7113305122
Riso20120 a_58313_15032.t47 a_58313_15032.t75 66395.0757151088
Riso20121 a_58313_15032.t47 a_58313_15032.t76 56800.1249757748
Riso20122 a_58313_15032.t47 a_58313_15032.t77 48086.6710078899
Riso20123 a_58313_15032.t47 a_58313_15032.t78 40405.7192542012
Riso20124 a_58313_15032.t47 a_58313_15032.t79 33772.1433604059
Riso20125 a_58313_15032.t47 a_58313_15032.t8 200168986.04338
Riso20126 a_58313_15032.t47 a_58313_15032.t80 33772.1433604059
Riso20127 a_58313_15032.t47 a_58313_15032.t81 40405.7192542012
Riso20128 a_58313_15032.t47 a_58313_15032.t82 48086.6710078899
Riso20129 a_58313_15032.t47 a_58313_15032.t83 56800.1249757748
Riso20130 a_58313_15032.t47 a_58313_15032.t84 66395.0757151088
Riso20131 a_58313_15032.t47 a_58313_15032.t85 76512.7113305122
Riso20132 a_58313_15032.t47 a_58313_15032.t86 86523.0096595666
Riso20133 a_58313_15032.t47 a_58313_15032.t87 95514.9513510219
Riso20134 a_58313_15032.t47 a_58313_15032.t88 102399.837525162
Riso20135 a_58313_15032.t47 a_58313_15032.t89 106156.732448444
Riso20136 a_58313_15032.t47 a_58313_15032.t9 304115106.880906
Riso20137 a_58313_15032.t47 a_58313_15032.t90 137893.847002736
Riso20138 a_58313_15032.t47 a_58313_15032.t91 133013.773155247
Riso20139 a_58313_15032.t47 a_58313_15032.t92 124070.549123845
Riso20140 a_58313_15032.t47 a_58313_15032.t93 112390.334376643
Riso20141 a_58313_15032.t47 a_58313_15032.t94 99387.3103158873
Riso20142 a_58313_15032.t47 a_58313_15032.t95 86244.8589102976
Riso20143 a_58313_15032.t47 a_58313_15032.t96 73781.3567024553
Riso20144 a_58313_15032.t47 a_58313_15032.t97 62462.8876746295
Riso20145 a_58313_15032.t47 a_58313_15032.t98 52485.6025648704
Riso20146 a_58313_15032.t47 a_58313_15032.t99 43868.8217137426
Riso20147 a_58313_15032.t48 a_58313_15032.t49 961.166387367938
Riso20148 a_58313_15032.t48 a_58313_15032.t5 1718175.84846858
Riso20149 a_58313_15032.t48 a_58313_15032.t50 87742.6965792437
Riso20150 a_58313_15032.t48 a_58313_15032.t51 84637.4758011479
Riso20151 a_58313_15032.t48 a_58313_15032.t52 78946.8477587527
Riso20152 a_58313_15032.t48 a_58313_15032.t53 71514.6558167599
Riso20153 a_58313_15032.t48 a_58313_15032.t54 63240.7522338618
Riso20154 a_58313_15032.t48 a_58313_15032.t55 54878.1301803539
Riso20155 a_58313_15032.t48 a_58313_15032.t56 46947.5276458133
Riso20156 a_58313_15032.t48 a_58313_15032.t57 39745.5167132271
Riso20157 a_58313_15032.t48 a_58313_15032.t58 33396.9092945593
Riso20158 a_58313_15032.t48 a_58313_15032.t59 27913.9990404466
Riso20159 a_58313_15032.t48 a_58313_15032.t6 17345.7949352927
Riso20160 a_58313_15032.t48 a_58313_15032.t60 27913.9990404466
Riso20161 a_58313_15032.t48 a_58313_15032.t61 33396.9092945593
Riso20162 a_58313_15032.t48 a_58313_15032.t62 39745.5167132271
Riso20163 a_58313_15032.t48 a_58313_15032.t63 46947.5276458133
Riso20164 a_58313_15032.t48 a_58313_15032.t64 54878.130180354
Riso20165 a_58313_15032.t48 a_58313_15032.t65 63240.7522338618
Riso20166 a_58313_15032.t48 a_58313_15032.t66 71514.6558167599
Riso20167 a_58313_15032.t48 a_58313_15032.t67 78946.8477587527
Riso20168 a_58313_15032.t48 a_58313_15032.t68 84637.4758011479
Riso20169 a_58313_15032.t48 a_58313_15032.t69 87742.6965792437
Riso20170 a_58313_15032.t48 a_58313_15032.t7 214597519.639517
Riso20171 a_58313_15032.t48 a_58313_15032.t70 113808.696975339
Riso20172 a_58313_15032.t48 a_58313_15032.t71 109780.998439124
Riso20173 a_58313_15032.t48 a_58313_15032.t72 102399.837525162
Riso20174 a_58313_15032.t48 a_58313_15032.t73 92759.740815518
Riso20175 a_58313_15032.t48 a_58313_15032.t74 82027.8825255373
Riso20176 a_58313_15032.t48 a_58313_15032.t75 71180.9498882732
Riso20177 a_58313_15032.t48 a_58313_15032.t76 60894.37817492
Riso20178 a_58313_15032.t48 a_58313_15032.t77 51552.8430751919
Riso20179 a_58313_15032.t48 a_58313_15032.t78 43318.2347705109
Riso20180 a_58313_15032.t48 a_58313_15032.t79 36206.499025192
Riso20181 a_58313_15032.t48 a_58313_15032.t8 214597519.639517
Riso20182 a_58313_15032.t48 a_58313_15032.t80 36206.499025192
Riso20183 a_58313_15032.t48 a_58313_15032.t81 43318.2347705109
Riso20184 a_58313_15032.t48 a_58313_15032.t82 51552.8430751919
Riso20185 a_58313_15032.t48 a_58313_15032.t83 60894.3781749199
Riso20186 a_58313_15032.t48 a_58313_15032.t84 71180.9498882732
Riso20187 a_58313_15032.t48 a_58313_15032.t85 82027.8825255373
Riso20188 a_58313_15032.t48 a_58313_15032.t86 92759.740815518
Riso20189 a_58313_15032.t48 a_58313_15032.t87 102399.837525162
Riso20190 a_58313_15032.t48 a_58313_15032.t88 109780.998439124
Riso20191 a_58313_15032.t48 a_58313_15032.t89 113808.696975339
Riso20192 a_58313_15032.t48 a_58313_15032.t9 326036260.219681
Riso20193 a_58313_15032.t48 a_58313_15032.t90 147833.478728443
Riso20194 a_58313_15032.t48 a_58313_15032.t91 142601.640549967
Riso20195 a_58313_15032.t48 a_58313_15032.t92 133013.773155247
Riso20196 a_58313_15032.t48 a_58313_15032.t93 120491.6279261
Riso20197 a_58313_15032.t48 a_58313_15032.t94 106551.322954747
Riso20198 a_58313_15032.t48 a_58313_15032.t95 92461.540469606
Riso20199 a_58313_15032.t48 a_58313_15032.t96 79099.6470379983
Riso20200 a_58313_15032.t48 a_58313_15032.t97 66965.32279777
Riso20201 a_58313_15032.t48 a_58313_15032.t98 56268.857378164
Riso20202 a_58313_15032.t48 a_58313_15032.t99 47030.9637639726
Riso20203 a_58313_15032.t49 a_58313_15032.t5 1781213.11765206
Riso20204 a_58313_15032.t49 a_58313_15032.t50 90961.8432038919
Riso20205 a_58313_15032.t49 a_58313_15032.t51 87742.6965792437
Riso20206 a_58313_15032.t49 a_58313_15032.t52 81843.2880141497
Riso20207 a_58313_15032.t49 a_58313_15032.t53 74138.4202081071
Riso20208 a_58313_15032.t49 a_58313_15032.t54 65560.9596360811
Riso20209 a_58313_15032.t49 a_58313_15032.t55 56891.5256471498
Riso20210 a_58313_15032.t49 a_58313_15032.t56 48669.9613189124
Riso20211 a_58313_15032.t49 a_58313_15032.t57 41203.7195148327
Riso20212 a_58313_15032.t49 a_58313_15032.t58 34622.1913068596
Riso20213 a_58313_15032.t49 a_58313_15032.t59 28938.1213810489
Riso20214 a_58313_15032.t49 a_58313_15032.t6 17982.1858760174
Riso20215 a_58313_15032.t49 a_58313_15032.t60 28938.1213810489
Riso20216 a_58313_15032.t49 a_58313_15032.t61 34622.1913068596
Riso20217 a_58313_15032.t49 a_58313_15032.t62 41203.7195148327
Riso20218 a_58313_15032.t49 a_58313_15032.t63 48669.9613189124
Riso20219 a_58313_15032.t49 a_58313_15032.t64 56891.5256471498
Riso20220 a_58313_15032.t49 a_58313_15032.t65 65560.9596360812
Riso20221 a_58313_15032.t49 a_58313_15032.t66 74138.4202081071
Riso20222 a_58313_15032.t49 a_58313_15032.t67 81843.2880141497
Riso20223 a_58313_15032.t49 a_58313_15032.t68 87742.6965792437
Riso20224 a_58313_15032.t49 a_58313_15032.t69 90961.8432038919
Riso20225 a_58313_15032.t49 a_58313_15032.t7 222470777.562261
Riso20226 a_58313_15032.t49 a_58313_15032.t70 117984.165669681
Riso20227 a_58313_15032.t49 a_58313_15032.t71 113808.696975339
Riso20228 a_58313_15032.t49 a_58313_15032.t72 106156.732448444
Riso20229 a_58313_15032.t49 a_58313_15032.t73 96162.9551933647
Riso20230 a_58313_15032.t49 a_58313_15032.t74 85037.3612793689
Riso20231 a_58313_15032.t49 a_58313_15032.t75 73792.4711146028
Riso20232 a_58313_15032.t49 a_58313_15032.t76 63128.5006672098
Riso20233 a_58313_15032.t49 a_58313_15032.t77 53444.2387952521
Riso20234 a_58313_15032.t49 a_58313_15032.t78 44907.5151856765
Riso20235 a_58313_15032.t49 a_58313_15032.t79 37534.8606287359
Riso20236 a_58313_15032.t49 a_58313_15032.t8 222470777.562261
Riso20237 a_58313_15032.t49 a_58313_15032.t80 37534.8606287359
Riso20238 a_58313_15032.t49 a_58313_15032.t81 44907.5151856765
Riso20239 a_58313_15032.t49 a_58313_15032.t82 53444.2387952521
Riso20240 a_58313_15032.t49 a_58313_15032.t83 63128.5006672098
Riso20241 a_58313_15032.t49 a_58313_15032.t84 73792.4711146028
Riso20242 a_58313_15032.t49 a_58313_15032.t85 85037.3612793689
Riso20243 a_58313_15032.t49 a_58313_15032.t86 96162.9551933647
Riso20244 a_58313_15032.t49 a_58313_15032.t87 106156.732448444
Riso20245 a_58313_15032.t49 a_58313_15032.t88 113808.696975339
Riso20246 a_58313_15032.t49 a_58313_15032.t89 117984.165669681
Riso20247 a_58313_15032.t49 a_58313_15032.t9 337998036.726644
Riso20248 a_58313_15032.t49 a_58313_15032.t90 153257.265124486
Riso20249 a_58313_15032.t49 a_58313_15032.t91 147833.478728443
Riso20250 a_58313_15032.t49 a_58313_15032.t92 137893.847002736
Riso20251 a_58313_15032.t49 a_58313_15032.t93 124912.283233706
Riso20252 a_58313_15032.t49 a_58313_15032.t94 110460.529589761
Riso20253 a_58313_15032.t49 a_58313_15032.t95 95853.8143284757
Riso20254 a_58313_15032.t49 a_58313_15032.t96 82001.6932674902
Riso20255 a_58313_15032.t49 a_58313_15032.t97 69422.1790519909
Riso20256 a_58313_15032.t49 a_58313_15032.t98 58333.2765191707
Riso20257 a_58313_15032.t49 a_58313_15032.t99 48756.4585818577
Riso20258 a_58313_15032.t5 a_58313_15032.t50 1665869.88600301
Riso20259 a_58313_15032.t5 a_58313_15032.t51 1606914.62265584
Riso20260 a_58313_15032.t5 a_58313_15032.t52 1498873.19860742
Riso20261 a_58313_15032.t5 a_58313_15032.t53 1357766.69942457
Riso20262 a_58313_15032.t5 a_58313_15032.t54 1200679.58726824
Riso20263 a_58313_15032.t5 a_58313_15032.t55 1041908.07932419
Riso20264 a_58313_15032.t5 a_58313_15032.t56 891338.830199065
Riso20265 a_58313_15032.t5 a_58313_15032.t57 754602.513684965
Riso20266 a_58313_15032.t5 a_58313_15032.t58 634068.790319598
Riso20267 a_58313_15032.t5 a_58313_15032.t59 529971.065539344
Riso20268 a_58313_15032.t5 a_58313_15032.t6 1192.97254526182
Riso20269 a_58313_15032.t5 a_58313_15032.t60 529971.065539344
Riso20270 a_58313_15032.t5 a_58313_15032.t61 634068.790319598
Riso20271 a_58313_15032.t5 a_58313_15032.t62 754602.513684965
Riso20272 a_58313_15032.t5 a_58313_15032.t63 891338.830199065
Riso20273 a_58313_15032.t5 a_58313_15032.t64 1041908.07932419
Riso20274 a_58313_15032.t5 a_58313_15032.t65 1200679.58726824
Riso20275 a_58313_15032.t5 a_58313_15032.t66 1357766.69942457
Riso20276 a_58313_15032.t5 a_58313_15032.t67 1498873.19860742
Riso20277 a_58313_15032.t5 a_58313_15032.t68 1606914.62265584
Riso20278 a_58313_15032.t5 a_58313_15032.t69 1665869.88600301
Riso20279 a_58313_15032.t5 a_58313_15032.t7 1632.31693613907
Riso20280 a_58313_15032.t5 a_58313_15032.t70 1472250.73726794
Riso20281 a_58313_15032.t5 a_58313_15032.t71 1420147.67048104
Riso20282 a_58313_15032.t5 a_58313_15032.t72 1324663.58282974
Riso20283 a_58313_15032.t5 a_58313_15032.t73 1199957.476308
Riso20284 a_58313_15032.t5 a_58313_15032.t74 1061128.13637537
Riso20285 a_58313_15032.t5 a_58313_15032.t75 920810.173014729
Riso20286 a_58313_15032.t5 a_58313_15032.t76 787741.144096617
Riso20287 a_58313_15032.t5 a_58313_15032.t77 666897.286787811
Riso20288 a_58313_15032.t5 a_58313_15032.t78 560372.842963396
Riso20289 a_58313_15032.t5 a_58313_15032.t79 468374.090033562
Riso20290 a_58313_15032.t5 a_58313_15032.t8 1632.31693613907
Riso20291 a_58313_15032.t5 a_58313_15032.t80 468374.090033562
Riso20292 a_58313_15032.t5 a_58313_15032.t81 560372.842963396
Riso20293 a_58313_15032.t5 a_58313_15032.t82 666897.286787811
Riso20294 a_58313_15032.t5 a_58313_15032.t83 787741.144096617
Riso20295 a_58313_15032.t5 a_58313_15032.t84 920810.173014729
Riso20296 a_58313_15032.t5 a_58313_15032.t85 1061128.13637537
Riso20297 a_58313_15032.t5 a_58313_15032.t86 1199957.476308
Riso20298 a_58313_15032.t5 a_58313_15032.t87 1324663.58282974
Riso20299 a_58313_15032.t5 a_58313_15032.t88 1420147.67048104
Riso20300 a_58313_15032.t5 a_58313_15032.t89 1472250.73726794
Riso20301 a_58313_15032.t5 a_58313_15032.t9 2479.9657994464
Riso20302 a_58313_15032.t5 a_58313_15032.t90 1244354.56111568
Riso20303 a_58313_15032.t5 a_58313_15032.t91 1200316.75752475
Riso20304 a_58313_15032.t5 a_58313_15032.t92 1119613.0723608
Riso20305 a_58313_15032.t5 a_58313_15032.t93 1014210.77333579
Riso20306 a_58313_15032.t5 a_58313_15032.t94 896871.438405368
Riso20307 a_58313_15032.t5 a_58313_15032.t95 778273.910624001
Riso20308 a_58313_15032.t5 a_58313_15032.t96 665803.222794861
Riso20309 a_58313_15032.t5 a_58313_15032.t97 563665.318415835
Riso20310 a_58313_15032.t5 a_58313_15032.t98 473630.262438072
Riso20311 a_58313_15032.t5 a_58313_15032.t99 395872.401682891
Riso20312 a_58313_15032.t50 a_58313_15032.t51 963.556960007447
Riso20313 a_58313_15032.t50 a_58313_15032.t52 1184.34121381046
Riso20314 a_58313_15032.t50 a_58313_15032.t53 1466.57562855419
Riso20315 a_58313_15032.t50 a_58313_15032.t54 1836.92753388595
Riso20316 a_58313_15032.t50 a_58313_15032.t55 2342.53643413247
Riso20317 a_58313_15032.t50 a_58313_15032.t56 3076.44335850424
Riso20318 a_58313_15032.t50 a_58313_15032.t57 4252.78920943056
Riso20319 a_58313_15032.t50 a_58313_15032.t58 6499.57447315085
Riso20320 a_58313_15032.t50 a_58313_15032.t59 12784.8372414534
Riso20321 a_58313_15032.t50 a_58313_15032.t6 16817.7415933547
Riso20322 a_58313_15032.t50 a_58313_15032.t60 26305.2117640433
Riso20323 a_58313_15032.t50 a_58313_15032.t61 31472.121568285
Riso20324 a_58313_15032.t50 a_58313_15032.t62 37454.8351992789
Riso20325 a_58313_15032.t50 a_58313_15032.t63 44241.7675350625
Riso20326 a_58313_15032.t50 a_58313_15032.t64 51715.3000369899
Riso20327 a_58313_15032.t50 a_58313_15032.t65 59595.9531709761
Riso20328 a_58313_15032.t50 a_58313_15032.t66 67393.0010088028
Riso20329 a_58313_15032.t50 a_58313_15032.t67 74396.8481688551
Riso20330 a_58313_15032.t50 a_58313_15032.t68 79759.5042149741
Riso20331 a_58313_15032.t50 a_58313_15032.t69 82685.759604736
Riso20332 a_58313_15032.t50 a_58313_15032.t7 208064585.413097
Riso20333 a_58313_15032.t50 a_58313_15032.t70 110343.979563321
Riso20334 a_58313_15032.t50 a_58313_15032.t71 106438.897642704
Riso20335 a_58313_15032.t50 a_58313_15032.t72 99282.4439560378
Riso20336 a_58313_15032.t50 a_58313_15032.t73 89935.8240351733
Riso20337 a_58313_15032.t50 a_58313_15032.t74 79530.6794082851
Riso20338 a_58313_15032.t50 a_58313_15032.t75 69013.9636821545
Riso20339 a_58313_15032.t50 a_58313_15032.t76 59040.5496190725
Riso20340 a_58313_15032.t50 a_58313_15032.t77 49983.4020940657
Riso20341 a_58313_15032.t50 a_58313_15032.t78 41999.4828099309
Riso20342 a_58313_15032.t50 a_58313_15032.t79 35104.2520885805
Riso20343 a_58313_15032.t50 a_58313_15032.t8 208064585.413097
Riso20344 a_58313_15032.t50 a_58313_15032.t80 35104.2520885805
Riso20345 a_58313_15032.t50 a_58313_15032.t81 41999.4828099309
Riso20346 a_58313_15032.t50 a_58313_15032.t82 49983.4020940657
Riso20347 a_58313_15032.t50 a_58313_15032.t83 59040.5496190725
Riso20348 a_58313_15032.t50 a_58313_15032.t84 69013.9636821545
Riso20349 a_58313_15032.t50 a_58313_15032.t85 79530.6794082851
Riso20350 a_58313_15032.t50 a_58313_15032.t86 89935.8240351733
Riso20351 a_58313_15032.t50 a_58313_15032.t87 99282.4439560378
Riso20352 a_58313_15032.t50 a_58313_15032.t88 106438.897642704
Riso20353 a_58313_15032.t50 a_58313_15032.t89 110343.979563321
Riso20354 a_58313_15032.t50 a_58313_15032.t9 316110826.565923
Riso20355 a_58313_15032.t50 a_58313_15032.t90 143332.913362752
Riso20356 a_58313_15032.t50 a_58313_15032.t91 138260.350538597
Riso20357 a_58313_15032.t50 a_58313_15032.t92 128964.371181002
Riso20358 a_58313_15032.t50 a_58313_15032.t93 116823.44361383
Riso20359 a_58313_15032.t50 a_58313_15032.t94 103307.530020403
Riso20360 a_58313_15032.t50 a_58313_15032.t95 89646.6895287012
Riso20361 a_58313_15032.t50 a_58313_15032.t96 76691.5786156109
Riso20362 a_58313_15032.t50 a_58313_15032.t97 64926.665417329
Riso20363 a_58313_15032.t50 a_58313_15032.t98 54555.8376152429
Riso20364 a_58313_15032.t50 a_58313_15032.t99 45599.1776188327
Riso20365 a_58313_15032.t51 a_58313_15032.t52 1142.42728719483
Riso20366 a_58313_15032.t51 a_58313_15032.t53 1414.673404301
Riso20367 a_58313_15032.t51 a_58313_15032.t54 1771.91852722831
Riso20368 a_58313_15032.t51 a_58313_15032.t55 2259.63388962103
Riso20369 a_58313_15032.t51 a_58313_15032.t56 2967.56779151235
Riso20370 a_58313_15032.t51 a_58313_15032.t57 4102.28267233026
Riso20371 a_58313_15032.t51 a_58313_15032.t58 6269.55403282189
Riso20372 a_58313_15032.t51 a_58313_15032.t59 12332.3808685075
Riso20373 a_58313_15032.t51 a_58313_15032.t6 16222.5604253225
Riso20374 a_58313_15032.t51 a_58313_15032.t60 25374.2682972199
Riso20375 a_58313_15032.t51 a_58313_15032.t61 30358.3207662282
Riso20376 a_58313_15032.t51 a_58313_15032.t62 36129.3057018363
Riso20377 a_58313_15032.t51 a_58313_15032.t63 42676.0479804385
Riso20378 a_58313_15032.t51 a_58313_15032.t64 49885.0915925151
Riso20379 a_58313_15032.t51 a_58313_15032.t65 57486.8478061802
Riso20380 a_58313_15032.t51 a_58313_15032.t66 65007.957521545
Riso20381 a_58313_15032.t51 a_58313_15032.t67 71763.9379921076
Riso20382 a_58313_15032.t51 a_58313_15032.t68 76936.809228443
Riso20383 a_58313_15032.t51 a_58313_15032.t69 79759.5042149741
Riso20384 a_58313_15032.t51 a_58313_15032.t7 200701163.738142
Riso20385 a_58313_15032.t51 a_58313_15032.t70 106438.897642704
Riso20386 a_58313_15032.t51 a_58313_15032.t71 102672.016871502
Riso20387 a_58313_15032.t51 a_58313_15032.t72 95768.8306310361
Riso20388 a_58313_15032.t51 a_58313_15032.t73 86752.9883077921
Riso20389 a_58313_15032.t51 a_58313_15032.t74 76716.082549256
Riso20390 a_58313_15032.t51 a_58313_15032.t75 66571.554201258
Riso20391 a_58313_15032.t51 a_58313_15032.t76 56951.1000286811
Riso20392 a_58313_15032.t51 a_58313_15032.t77 48214.4856509492
Riso20393 a_58313_15032.t51 a_58313_15032.t78 40513.1178841288
Riso20394 a_58313_15032.t51 a_58313_15032.t79 33861.9099081515
Riso20395 a_58313_15032.t51 a_58313_15032.t8 200701163.738142
Riso20396 a_58313_15032.t51 a_58313_15032.t80 33861.9099081515
Riso20397 a_58313_15032.t51 a_58313_15032.t81 40513.1178841288
Riso20398 a_58313_15032.t51 a_58313_15032.t82 48214.4856509492
Riso20399 a_58313_15032.t51 a_58313_15032.t83 56951.1000286811
Riso20400 a_58313_15032.t51 a_58313_15032.t84 66571.554201258
Riso20401 a_58313_15032.t51 a_58313_15032.t85 76716.082549256
Riso20402 a_58313_15032.t51 a_58313_15032.t86 86752.9883077921
Riso20403 a_58313_15032.t51 a_58313_15032.t87 95768.8306310361
Riso20404 a_58313_15032.t51 a_58313_15032.t88 102672.016871502
Riso20405 a_58313_15032.t51 a_58313_15032.t89 106438.897642704
Riso20406 a_58313_15032.t51 a_58313_15032.t9 304923640.109361
Riso20407 a_58313_15032.t51 a_58313_15032.t90 138260.350538597
Riso20408 a_58313_15032.t51 a_58313_15032.t91 133367.306102796
Riso20409 a_58313_15032.t51 a_58313_15032.t92 124400.312169395
Riso20410 a_58313_15032.t51 a_58313_15032.t93 112689.052962287
Riso20411 a_58313_15032.t51 a_58313_15032.t94 99651.4685901123
Riso20412 a_58313_15032.t51 a_58313_15032.t95 86474.0862937344
Riso20413 a_58313_15032.t51 a_58313_15032.t96 73977.4577519208
Riso20414 a_58313_15032.t51 a_58313_15032.t97 62628.9057362794
Riso20415 a_58313_15032.t51 a_58313_15032.t98 52625.1023274772
Riso20416 a_58313_15032.t51 a_58313_15032.t99 43985.4192169787
Riso20417 a_58313_15032.t52 a_58313_15032.t53 1319.55738070574
Riso20418 a_58313_15032.t52 a_58313_15032.t54 1652.78301232266
Riso20419 a_58313_15032.t52 a_58313_15032.t55 2107.70667468335
Riso20420 a_58313_15032.t52 a_58313_15032.t56 2768.04241185944
Riso20421 a_58313_15032.t52 a_58313_15032.t57 3826.46437089789
Riso20422 a_58313_15032.t52 a_58313_15032.t58 5848.01854095169
Riso20423 a_58313_15032.t52 a_58313_15032.t59 11503.2092546859
Riso20424 a_58313_15032.t52 a_58313_15032.t6 15131.8313315972
Riso20425 a_58313_15032.t52 a_58313_15032.t60 23668.2211666713
Riso20426 a_58313_15032.t52 a_58313_15032.t61 28317.169256958
Riso20427 a_58313_15032.t52 a_58313_15032.t62 33700.1401550968
Riso20428 a_58313_15032.t52 a_58313_15032.t63 39806.7101005298
Riso20429 a_58313_15032.t52 a_58313_15032.t64 46531.051335209
Riso20430 a_58313_15032.t52 a_58313_15032.t65 53621.7010127745
Riso20431 a_58313_15032.t52 a_58313_15032.t66 60637.1264854199
Riso20432 a_58313_15032.t52 a_58313_15032.t67 66938.8664253458
Riso20433 a_58313_15032.t52 a_58313_15032.t68 71763.9379921076
Riso20434 a_58313_15032.t52 a_58313_15032.t69 74396.8481688551
Riso20435 a_58313_15032.t52 a_58313_15032.t7 187206956.122676
Riso20436 a_58313_15032.t52 a_58313_15032.t70 99282.4439560377
Riso20437 a_58313_15032.t52 a_58313_15032.t71 95768.830631036
Riso20438 a_58313_15032.t52 a_58313_15032.t72 89329.7823487268
Riso20439 a_58313_15032.t52 a_58313_15032.t73 80920.1230982272
Riso20440 a_58313_15032.t52 a_58313_15032.t74 71558.0519425401
Riso20441 a_58313_15032.t52 a_58313_15032.t75 62095.5942369796
Riso20442 a_58313_15032.t52 a_58313_15032.t76 53121.9744102624
Riso20443 a_58313_15032.t52 a_58313_15032.t77 44972.769124105
Riso20444 a_58313_15032.t52 a_58313_15032.t78 37789.2053083575
Riso20445 a_58313_15032.t52 a_58313_15032.t79 31585.1934504783
Riso20446 a_58313_15032.t52 a_58313_15032.t8 187206956.122676
Riso20447 a_58313_15032.t52 a_58313_15032.t80 31585.1934504783
Riso20448 a_58313_15032.t52 a_58313_15032.t81 37789.2053083575
Riso20449 a_58313_15032.t52 a_58313_15032.t82 44972.769124105
Riso20450 a_58313_15032.t52 a_58313_15032.t83 53121.9744102624
Riso20451 a_58313_15032.t52 a_58313_15032.t84 62095.5942369796
Riso20452 a_58313_15032.t52 a_58313_15032.t85 71558.0519425401
Riso20453 a_58313_15032.t52 a_58313_15032.t86 80920.1230982272
Riso20454 a_58313_15032.t52 a_58313_15032.t87 89329.7823487268
Riso20455 a_58313_15032.t52 a_58313_15032.t88 95768.830631036
Riso20456 a_58313_15032.t52 a_58313_15032.t89 99282.4439560377
Riso20457 a_58313_15032.t52 a_58313_15032.t9 284422000.60782
Riso20458 a_58313_15032.t52 a_58313_15032.t90 128964.371181002
Riso20459 a_58313_15032.t52 a_58313_15032.t91 124400.312169395
Riso20460 a_58313_15032.t52 a_58313_15032.t92 116036.216971457
Riso20461 a_58313_15032.t52 a_58313_15032.t93 105112.368062506
Riso20462 a_58313_15032.t52 a_58313_15032.t94 92951.3698896609
Riso20463 a_58313_15032.t52 a_58313_15032.t95 80659.9731512326
Riso20464 a_58313_15032.t52 a_58313_15032.t96 69003.5594686443
Riso20465 a_58313_15032.t52 a_58313_15032.t97 58418.0310159044
Riso20466 a_58313_15032.t52 a_58313_15032.t98 49086.8365627672
Riso20467 a_58313_15032.t52 a_58313_15032.t99 41028.0453387604
Riso20468 a_58313_15032.t53 a_58313_15032.t54 1497.18717873619
Riso20469 a_58313_15032.t53 a_58313_15032.t55 1909.28354559864
Riso20470 a_58313_15032.t53 a_58313_15032.t56 2507.45414149071
Riso20471 a_58313_15032.t53 a_58313_15032.t57 3466.23443808773
Riso20472 a_58313_15032.t53 a_58313_15032.t58 5297.47602392173
Riso20473 a_58313_15032.t53 a_58313_15032.t59 10420.277363713
Riso20474 a_58313_15032.t53 a_58313_15032.t6 13707.2947214217
Riso20475 a_58313_15032.t53 a_58313_15032.t60 21440.0541450598
Riso20476 a_58313_15032.t53 a_58313_15032.t61 25651.3422715066
Riso20477 a_58313_15032.t53 a_58313_15032.t62 30527.5510370346
Riso20478 a_58313_15032.t53 a_58313_15032.t63 36059.2379918211
Riso20479 a_58313_15032.t53 a_58313_15032.t64 42150.5381848578
Riso20480 a_58313_15032.t53 a_58313_15032.t65 48573.6619143558
Riso20481 a_58313_15032.t53 a_58313_15032.t66 54928.6431748804
Riso20482 a_58313_15032.t53 a_58313_15032.t67 60637.1264854199
Riso20483 a_58313_15032.t53 a_58313_15032.t68 65007.957521545
Riso20484 a_58313_15032.t53 a_58313_15032.t69 67393.0010088028
Riso20485 a_58313_15032.t53 a_58313_15032.t7 169582971.501635
Riso20486 a_58313_15032.t53 a_58313_15032.t70 89935.8240351732
Riso20487 a_58313_15032.t53 a_58313_15032.t71 86752.9883077921
Riso20488 a_58313_15032.t53 a_58313_15032.t72 80920.1230982272
Riso20489 a_58313_15032.t53 a_58313_15032.t73 73302.1636241071
Riso20490 a_58313_15032.t53 a_58313_15032.t74 64821.4539385611
Riso20491 a_58313_15032.t53 a_58313_15032.t75 56249.8082654914
Riso20492 a_58313_15032.t53 a_58313_15032.t76 48120.9804331352
Riso20493 a_58313_15032.t53 a_58313_15032.t77 40738.9553394854
Riso20494 a_58313_15032.t53 a_58313_15032.t78 34231.6645684748
Riso20495 a_58313_15032.t53 a_58313_15032.t79 28611.709050363
Riso20496 a_58313_15032.t53 a_58313_15032.t8 169582971.501635
Riso20497 a_58313_15032.t53 a_58313_15032.t80 28611.709050363
Riso20498 a_58313_15032.t53 a_58313_15032.t81 34231.6645684748
Riso20499 a_58313_15032.t53 a_58313_15032.t82 40738.9553394854
Riso20500 a_58313_15032.t53 a_58313_15032.t83 48120.9804331352
Riso20501 a_58313_15032.t53 a_58313_15032.t84 56249.8082654914
Riso20502 a_58313_15032.t53 a_58313_15032.t85 64821.4539385611
Riso20503 a_58313_15032.t53 a_58313_15032.t86 73302.1636241071
Riso20504 a_58313_15032.t53 a_58313_15032.t87 80920.1230982272
Riso20505 a_58313_15032.t53 a_58313_15032.t88 86752.9883077921
Riso20506 a_58313_15032.t53 a_58313_15032.t89 89935.8240351732
Riso20507 a_58313_15032.t53 a_58313_15032.t9 257646024.605554
Riso20508 a_58313_15032.t53 a_58313_15032.t90 116823.44361383
Riso20509 a_58313_15032.t53 a_58313_15032.t91 112689.052962287
Riso20510 a_58313_15032.t53 a_58313_15032.t92 105112.368062506
Riso20511 a_58313_15032.t53 a_58313_15032.t93 95216.9090657747
Riso20512 a_58313_15032.t53 a_58313_15032.t94 84200.7681632666
Riso20513 a_58313_15032.t53 a_58313_15032.t95 73066.5046402687
Riso20514 a_58313_15032.t53 a_58313_15032.t96 62507.4457768241
Riso20515 a_58313_15032.t53 a_58313_15032.t97 52918.4571670505
Riso20516 a_58313_15032.t53 a_58313_15032.t98 44465.7173982055
Riso20517 a_58313_15032.t53 a_58313_15032.t99 37165.5946314914
Riso20518 a_58313_15032.t54 a_58313_15032.t55 1688.38857255739
Riso20519 a_58313_15032.t54 a_58313_15032.t56 2217.35369189348
Riso20520 a_58313_15032.t54 a_58313_15032.t57 3065.2076945634
Riso20521 a_58313_15032.t54 a_58313_15032.t58 4684.58338878202
Riso20522 a_58313_15032.t54 a_58313_15032.t59 9214.70111881957
Riso20523 a_58313_15032.t54 a_58313_15032.t6 12121.4262919069
Riso20524 a_58313_15032.t54 a_58313_15032.t60 18959.5424403979
Riso20525 a_58313_15032.t54 a_58313_15032.t61 22683.6046755909
Riso20526 a_58313_15032.t54 a_58313_15032.t62 26995.6594126155
Riso20527 a_58313_15032.t54 a_58313_15032.t63 31887.3566479248
Riso20528 a_58313_15032.t54 a_58313_15032.t64 37273.9225467658
Riso20529 a_58313_15032.t54 a_58313_15032.t65 42953.9215861995
Riso20530 a_58313_15032.t54 a_58313_15032.t66 48573.6619143558
Riso20531 a_58313_15032.t54 a_58313_15032.t67 53621.7010127745
Riso20532 a_58313_15032.t54 a_58313_15032.t68 57486.8478061802
Riso20533 a_58313_15032.t54 a_58313_15032.t69 59595.9531709761
Riso20534 a_58313_15032.t54 a_58313_15032.t7 149963032.910291
Riso20535 a_58313_15032.t54 a_58313_15032.t70 79530.679408285
Riso20536 a_58313_15032.t54 a_58313_15032.t71 76716.082549256
Riso20537 a_58313_15032.t54 a_58313_15032.t72 71558.0519425401
Riso20538 a_58313_15032.t54 a_58313_15032.t73 64821.4539385611
Riso20539 a_58313_15032.t54 a_58313_15032.t74 57321.9217955953
Riso20540 a_58313_15032.t54 a_58313_15032.t75 49741.974523864
Riso20541 a_58313_15032.t54 a_58313_15032.t76 42553.6131869242
Riso20542 a_58313_15032.t54 a_58313_15032.t77 36025.6530842027
Riso20543 a_58313_15032.t54 a_58313_15032.t78 30271.2247273409
Riso20544 a_58313_15032.t54 a_58313_15032.t79 25301.4711792446
Riso20545 a_58313_15032.t54 a_58313_15032.t8 149963032.910291
Riso20546 a_58313_15032.t54 a_58313_15032.t80 25301.4711792446
Riso20547 a_58313_15032.t54 a_58313_15032.t81 30271.2247273409
Riso20548 a_58313_15032.t54 a_58313_15032.t82 36025.6530842027
Riso20549 a_58313_15032.t54 a_58313_15032.t83 42553.6131869241
Riso20550 a_58313_15032.t54 a_58313_15032.t84 49741.9745238639
Riso20551 a_58313_15032.t54 a_58313_15032.t85 57321.9217955953
Riso20552 a_58313_15032.t54 a_58313_15032.t86 64821.4539385611
Riso20553 a_58313_15032.t54 a_58313_15032.t87 71558.0519425401
Riso20554 a_58313_15032.t54 a_58313_15032.t88 76716.082549256
Riso20555 a_58313_15032.t54 a_58313_15032.t89 79530.679408285
Riso20556 a_58313_15032.t54 a_58313_15032.t9 227837612.025545
Riso20557 a_58313_15032.t54 a_58313_15032.t90 103307.530020403
Riso20558 a_58313_15032.t54 a_58313_15032.t91 99651.4685901123
Riso20559 a_58313_15032.t54 a_58313_15032.t92 92951.3698896608
Riso20560 a_58313_15032.t54 a_58313_15032.t93 84200.7681632665
Riso20561 a_58313_15032.t54 a_58313_15032.t94 74459.1420667377
Riso20562 a_58313_15032.t54 a_58313_15032.t95 64613.0595718624
Riso20563 a_58313_15032.t54 a_58313_15032.t96 55275.6333089596
Riso20564 a_58313_15032.t54 a_58313_15032.t97 46796.0448117736
Riso20565 a_58313_15032.t54 a_58313_15032.t98 39321.2465999425
Riso20566 a_58313_15032.t54 a_58313_15032.t99 32865.7131167156
Riso20567 a_58313_15032.t55 a_58313_15032.t56 1924.14258624939
Riso20568 a_58313_15032.t55 a_58313_15032.t57 2659.88086716661
Riso20569 a_58313_15032.t55 a_58313_15032.t58 4065.11889832726
Riso20570 a_58313_15032.t55 a_58313_15032.t59 7996.19785833078
Riso20571 a_58313_15032.t55 a_58313_15032.t6 10518.5530930902
Riso20572 a_58313_15032.t55 a_58313_15032.t60 16452.4329874589
Riso20573 a_58313_15032.t55 a_58313_15032.t61 19684.0449611261
Riso20574 a_58313_15032.t55 a_58313_15032.t62 23425.89642311
Riso20575 a_58313_15032.t55 a_58313_15032.t63 27670.7415300985
Riso20576 a_58313_15032.t55 a_58313_15032.t64 32345.0164901514
Riso20577 a_58313_15032.t55 a_58313_15032.t65 37273.9225467658
Riso20578 a_58313_15032.t55 a_58313_15032.t66 42150.5381848578
Riso20579 a_58313_15032.t55 a_58313_15032.t67 46531.051335209
Riso20580 a_58313_15032.t55 a_58313_15032.t68 49885.0915925151
Riso20581 a_58313_15032.t55 a_58313_15032.t69 51715.3000369899
Riso20582 a_58313_15032.t55 a_58313_15032.t7 130132715.876918
Riso20583 a_58313_15032.t55 a_58313_15032.t70 69013.9636821544
Riso20584 a_58313_15032.t55 a_58313_15032.t71 66571.554201258
Riso20585 a_58313_15032.t55 a_58313_15032.t72 62095.5942369796
Riso20586 a_58313_15032.t55 a_58313_15032.t73 56249.8082654914
Riso20587 a_58313_15032.t55 a_58313_15032.t74 49741.974523864
Riso20588 a_58313_15032.t55 a_58313_15032.t75 43164.3593240947
Riso20589 a_58313_15032.t55 a_58313_15032.t76 36926.5488095514
Riso20590 a_58313_15032.t55 a_58313_15032.t77 31261.8115685311
Riso20591 a_58313_15032.t55 a_58313_15032.t78 26268.3183331313
Riso20592 a_58313_15032.t55 a_58313_15032.t79 21955.7386666504
Riso20593 a_58313_15032.t55 a_58313_15032.t8 130132715.876918
Riso20594 a_58313_15032.t55 a_58313_15032.t80 21955.7386666504
Riso20595 a_58313_15032.t55 a_58313_15032.t81 26268.3183331313
Riso20596 a_58313_15032.t55 a_58313_15032.t82 31261.8115685311
Riso20597 a_58313_15032.t55 a_58313_15032.t83 36926.5488095514
Riso20598 a_58313_15032.t55 a_58313_15032.t84 43164.3593240947
Riso20599 a_58313_15032.t55 a_58313_15032.t85 49741.974523864
Riso20600 a_58313_15032.t55 a_58313_15032.t86 56249.8082654914
Riso20601 a_58313_15032.t55 a_58313_15032.t87 62095.5942369796
Riso20602 a_58313_15032.t55 a_58313_15032.t88 66571.554201258
Riso20603 a_58313_15032.t55 a_58313_15032.t89 69013.9636821544
Riso20604 a_58313_15032.t55 a_58313_15032.t9 197709573.195494
Riso20605 a_58313_15032.t55 a_58313_15032.t90 89646.6895287012
Riso20606 a_58313_15032.t55 a_58313_15032.t91 86474.0862937344
Riso20607 a_58313_15032.t55 a_58313_15032.t92 80659.9731512325
Riso20608 a_58313_15032.t55 a_58313_15032.t93 73066.5046402687
Riso20609 a_58313_15032.t55 a_58313_15032.t94 64613.0595718625
Riso20610 a_58313_15032.t55 a_58313_15032.t95 56068.9708658626
Riso20611 a_58313_15032.t55 a_58313_15032.t96 47966.276386358
Riso20612 a_58313_15032.t55 a_58313_15032.t97 40607.9837508817
Riso20613 a_58313_15032.t55 a_58313_15032.t98 34121.6132563652
Riso20614 a_58313_15032.t55 a_58313_15032.t99 28519.725322362
Riso20615 a_58313_15032.t56 a_58313_15032.t57 2275.49353696054
Riso20616 a_58313_15032.t56 a_58313_15032.t58 3477.65642224923
Riso20617 a_58313_15032.t56 a_58313_15032.t59 6840.64341809098
Riso20618 a_58313_15032.t56 a_58313_15032.t6 8998.48556262566
Riso20619 a_58313_15032.t56 a_58313_15032.t60 14074.8427466673
Riso20620 a_58313_15032.t56 a_58313_15032.t61 16839.4448199462
Riso20621 a_58313_15032.t56 a_58313_15032.t62 20040.5501488029
Riso20622 a_58313_15032.t56 a_58313_15032.t63 23671.9600083882
Riso20623 a_58313_15032.t56 a_58313_15032.t64 27670.7415300985
Riso20624 a_58313_15032.t56 a_58313_15032.t65 31887.3566479248
Riso20625 a_58313_15032.t56 a_58313_15032.t66 36059.2379918211
Riso20626 a_58313_15032.t56 a_58313_15032.t67 39806.7101005298
Riso20627 a_58313_15032.t56 a_58313_15032.t68 42676.0479804385
Riso20628 a_58313_15032.t56 a_58313_15032.t69 44241.7675350625
Riso20629 a_58313_15032.t56 a_58313_15032.t7 111326848.348844
Riso20630 a_58313_15032.t56 a_58313_15032.t70 59040.5496190724
Riso20631 a_58313_15032.t56 a_58313_15032.t71 56951.1000286811
Riso20632 a_58313_15032.t56 a_58313_15032.t72 53121.9744102624
Riso20633 a_58313_15032.t56 a_58313_15032.t73 48120.9804331352
Riso20634 a_58313_15032.t56 a_58313_15032.t74 42553.6131869242
Riso20635 a_58313_15032.t56 a_58313_15032.t75 36926.5488095514
Riso20636 a_58313_15032.t56 a_58313_15032.t76 31590.1829272149
Riso20637 a_58313_15032.t56 a_58313_15032.t77 26744.0737876532
Riso20638 a_58313_15032.t56 a_58313_15032.t78 22472.2051771946
Riso20639 a_58313_15032.t56 a_58313_15032.t79 18782.8492816586
Riso20640 a_58313_15032.t56 a_58313_15032.t8 111326848.348844
Riso20641 a_58313_15032.t56 a_58313_15032.t80 18782.8492816586
Riso20642 a_58313_15032.t56 a_58313_15032.t81 22472.2051771946
Riso20643 a_58313_15032.t56 a_58313_15032.t82 26744.0737876532
Riso20644 a_58313_15032.t56 a_58313_15032.t83 31590.1829272149
Riso20645 a_58313_15032.t56 a_58313_15032.t84 36926.5488095514
Riso20646 a_58313_15032.t56 a_58313_15032.t85 42553.6131869242
Riso20647 a_58313_15032.t56 a_58313_15032.t86 48120.9804331352
Riso20648 a_58313_15032.t56 a_58313_15032.t87 53121.9744102624
Riso20649 a_58313_15032.t56 a_58313_15032.t88 56951.1000286811
Riso20650 a_58313_15032.t56 a_58313_15032.t89 59040.5496190724
Riso20651 a_58313_15032.t56 a_58313_15032.t9 169137972.138131
Riso20652 a_58313_15032.t56 a_58313_15032.t90 76691.578615611
Riso20653 a_58313_15032.t56 a_58313_15032.t91 73977.4577519209
Riso20654 a_58313_15032.t56 a_58313_15032.t92 69003.5594686442
Riso20655 a_58313_15032.t56 a_58313_15032.t93 62507.4457768241
Riso20656 a_58313_15032.t56 a_58313_15032.t94 55275.6333089597
Riso20657 a_58313_15032.t56 a_58313_15032.t95 47966.276386358
Riso20658 a_58313_15032.t56 a_58313_15032.t96 41034.5264919655
Riso20659 a_58313_15032.t56 a_58313_15032.t97 34739.602707305
Riso20660 a_58313_15032.t56 a_58313_15032.t98 29190.5969902459
Riso20661 a_58313_15032.t56 a_58313_15032.t99 24398.2546165891
Riso20662 a_58313_15032.t57 a_58313_15032.t58 2944.16465327316
Riso20663 a_58313_15032.t57 a_58313_15032.t59 5791.25080566852
Riso20664 a_58313_15032.t57 a_58313_15032.t6 7618.06800607879
Riso20665 a_58313_15032.t57 a_58313_15032.t60 11915.6838639957
Riso20666 a_58313_15032.t57 a_58313_15032.t61 14256.1806573072
Riso20667 a_58313_15032.t57 a_58313_15032.t62 16966.2186876106
Riso20668 a_58313_15032.t57 a_58313_15032.t63 20040.5501488029
Riso20669 a_58313_15032.t57 a_58313_15032.t64 23425.89642311
Riso20670 a_58313_15032.t57 a_58313_15032.t65 26995.6594126155
Riso20671 a_58313_15032.t57 a_58313_15032.t66 30527.5510370346
Riso20672 a_58313_15032.t57 a_58313_15032.t67 33700.1401550968
Riso20673 a_58313_15032.t57 a_58313_15032.t68 36129.3057018363
Riso20674 a_58313_15032.t57 a_58313_15032.t69 37454.8351992789
Riso20675 a_58313_15032.t57 a_58313_15032.t7 94248692.8185336
Riso20676 a_58313_15032.t57 a_58313_15032.t70 49983.4020940657
Riso20677 a_58313_15032.t57 a_58313_15032.t71 48214.4856509492
Riso20678 a_58313_15032.t57 a_58313_15032.t72 44972.7691241051
Riso20679 a_58313_15032.t57 a_58313_15032.t73 40738.9553394854
Riso20680 a_58313_15032.t57 a_58313_15032.t74 36025.6530842028
Riso20681 a_58313_15032.t57 a_58313_15032.t75 31261.8115685311
Riso20682 a_58313_15032.t57 a_58313_15032.t76 26744.0737876532
Riso20683 a_58313_15032.t57 a_58313_15032.t77 22641.3846481166
Riso20684 a_58313_15032.t57 a_58313_15032.t78 19024.8443579734
Riso20685 a_58313_15032.t57 a_58313_15032.t79 15901.4561038926
Riso20686 a_58313_15032.t57 a_58313_15032.t8 94248692.8185336
Riso20687 a_58313_15032.t57 a_58313_15032.t80 15901.4561038926
Riso20688 a_58313_15032.t57 a_58313_15032.t81 19024.8443579734
Riso20689 a_58313_15032.t57 a_58313_15032.t82 22641.3846481166
Riso20690 a_58313_15032.t57 a_58313_15032.t83 26744.0737876532
Riso20691 a_58313_15032.t57 a_58313_15032.t84 31261.8115685311
Riso20692 a_58313_15032.t57 a_58313_15032.t85 36025.6530842028
Riso20693 a_58313_15032.t57 a_58313_15032.t86 40738.9553394854
Riso20694 a_58313_15032.t57 a_58313_15032.t87 44972.7691241051
Riso20695 a_58313_15032.t57 a_58313_15032.t88 48214.4856509492
Riso20696 a_58313_15032.t57 a_58313_15032.t89 49983.4020940657
Riso20697 a_58313_15032.t57 a_58313_15032.t9 143191269.818804
Riso20698 a_58313_15032.t57 a_58313_15032.t90 64926.6654173291
Riso20699 a_58313_15032.t57 a_58313_15032.t91 62628.9057362794
Riso20700 a_58313_15032.t57 a_58313_15032.t92 58418.0310159044
Riso20701 a_58313_15032.t57 a_58313_15032.t93 52918.4571670505
Riso20702 a_58313_15032.t57 a_58313_15032.t94 46796.0448117737
Riso20703 a_58313_15032.t57 a_58313_15032.t95 40607.9837508817
Riso20704 a_58313_15032.t57 a_58313_15032.t96 34739.602707305
Riso20705 a_58313_15032.t57 a_58313_15032.t97 29410.3551188214
Riso20706 a_58313_15032.t57 a_58313_15032.t98 24712.5976323559
Riso20707 a_58313_15032.t57 a_58313_15032.t99 20655.4271388493
Riso20708 a_58313_15032.t58 a_58313_15032.t59 4866.20614985211
Riso20709 a_58313_15032.t58 a_58313_15032.t6 6401.2232633556
Riso20710 a_58313_15032.t58 a_58313_15032.t60 10012.3748814183
Riso20711 a_58313_15032.t58 a_58313_15032.t61 11979.0208222527
Riso20712 a_58313_15032.t58 a_58313_15032.t62 14256.1806573072
Riso20713 a_58313_15032.t58 a_58313_15032.t63 16839.4448199462
Riso20714 a_58313_15032.t58 a_58313_15032.t64 19684.0449611261
Riso20715 a_58313_15032.t58 a_58313_15032.t65 22683.6046755909
Riso20716 a_58313_15032.t58 a_58313_15032.t66 25651.3422715066
Riso20717 a_58313_15032.t58 a_58313_15032.t67 28317.169256958
Riso20718 a_58313_15032.t58 a_58313_15032.t68 30358.3207662282
Riso20719 a_58313_15032.t58 a_58313_15032.t69 31472.121568285
Riso20720 a_58313_15032.t58 a_58313_15032.t7 79194216.2408429
Riso20721 a_58313_15032.t58 a_58313_15032.t70 41999.4828099309
Riso20722 a_58313_15032.t58 a_58313_15032.t71 40513.1178841289
Riso20723 a_58313_15032.t58 a_58313_15032.t72 37789.2053083575
Riso20724 a_58313_15032.t58 a_58313_15032.t73 34231.6645684748
Riso20725 a_58313_15032.t58 a_58313_15032.t74 30271.224727341
Riso20726 a_58313_15032.t58 a_58313_15032.t75 26268.3183331313
Riso20727 a_58313_15032.t58 a_58313_15032.t76 22472.2051771946
Riso20728 a_58313_15032.t58 a_58313_15032.t77 19024.8443579734
Riso20729 a_58313_15032.t58 a_58313_15032.t78 15985.9791470493
Riso20730 a_58313_15032.t58 a_58313_15032.t79 13361.4941022111
Riso20731 a_58313_15032.t58 a_58313_15032.t8 79194216.2408429
Riso20732 a_58313_15032.t58 a_58313_15032.t80 13361.4941022111
Riso20733 a_58313_15032.t58 a_58313_15032.t81 15985.9791470493
Riso20734 a_58313_15032.t58 a_58313_15032.t82 19024.8443579734
Riso20735 a_58313_15032.t58 a_58313_15032.t83 22472.2051771946
Riso20736 a_58313_15032.t58 a_58313_15032.t84 26268.3183331313
Riso20737 a_58313_15032.t58 a_58313_15032.t85 30271.224727341
Riso20738 a_58313_15032.t58 a_58313_15032.t86 34231.6645684748
Riso20739 a_58313_15032.t58 a_58313_15032.t87 37789.2053083575
Riso20740 a_58313_15032.t58 a_58313_15032.t88 40513.1178841289
Riso20741 a_58313_15032.t58 a_58313_15032.t89 41999.4828099309
Riso20742 a_58313_15032.t58 a_58313_15032.t9 120319126.416587
Riso20743 a_58313_15032.t58 a_58313_15032.t90 54555.8376152429
Riso20744 a_58313_15032.t58 a_58313_15032.t91 52625.1023274772
Riso20745 a_58313_15032.t58 a_58313_15032.t92 49086.8365627672
Riso20746 a_58313_15032.t58 a_58313_15032.t93 44465.7173982055
Riso20747 a_58313_15032.t58 a_58313_15032.t94 39321.2465999426
Riso20748 a_58313_15032.t58 a_58313_15032.t95 34121.6132563652
Riso20749 a_58313_15032.t58 a_58313_15032.t96 29190.5969902459
Riso20750 a_58313_15032.t58 a_58313_15032.t97 24712.5976323559
Riso20751 a_58313_15032.t58 a_58313_15032.t98 20765.2195722007
Riso20752 a_58313_15032.t58 a_58313_15032.t99 17356.106641506
Riso20753 a_58313_15032.t59 a_58313_15032.t6 5350.30767233608
Riso20754 a_58313_15032.t59 a_58313_15032.t60 8368.60142857693
Riso20755 a_58313_15032.t59 a_58313_15032.t61 10012.3748814183
Riso20756 a_58313_15032.t59 a_58313_15032.t62 11915.6838639957
Riso20757 a_58313_15032.t59 a_58313_15032.t63 14074.8427466673
Riso20758 a_58313_15032.t59 a_58313_15032.t64 16452.4329874589
Riso20759 a_58313_15032.t59 a_58313_15032.t65 18959.5424403979
Riso20760 a_58313_15032.t59 a_58313_15032.t66 21440.0541450598
Riso20761 a_58313_15032.t59 a_58313_15032.t67 23668.2211666713
Riso20762 a_58313_15032.t59 a_58313_15032.t68 25374.2682972199
Riso20763 a_58313_15032.t59 a_58313_15032.t69 26305.2117640433
Riso20764 a_58313_15032.t59 a_58313_15032.t7 66192570.5956254
Riso20765 a_58313_15032.t59 a_58313_15032.t70 35104.2520885804
Riso20766 a_58313_15032.t59 a_58313_15032.t71 33861.9099081515
Riso20767 a_58313_15032.t59 a_58313_15032.t72 31585.1934504784
Riso20768 a_58313_15032.t59 a_58313_15032.t73 28611.709050363
Riso20769 a_58313_15032.t59 a_58313_15032.t74 25301.4711792446
Riso20770 a_58313_15032.t59 a_58313_15032.t75 21955.7386666504
Riso20771 a_58313_15032.t59 a_58313_15032.t76 18782.8492816586
Riso20772 a_58313_15032.t59 a_58313_15032.t77 15901.4561038926
Riso20773 a_58313_15032.t59 a_58313_15032.t78 13361.4941022111
Riso20774 a_58313_15032.t59 a_58313_15032.t79 11167.8817419436
Riso20775 a_58313_15032.t59 a_58313_15032.t8 66192570.5956254
Riso20776 a_58313_15032.t59 a_58313_15032.t80 11167.8817419436
Riso20777 a_58313_15032.t59 a_58313_15032.t81 13361.4941022111
Riso20778 a_58313_15032.t59 a_58313_15032.t82 15901.4561038926
Riso20779 a_58313_15032.t59 a_58313_15032.t83 18782.8492816586
Riso20780 a_58313_15032.t59 a_58313_15032.t84 21955.7386666504
Riso20781 a_58313_15032.t59 a_58313_15032.t85 25301.4711792446
Riso20782 a_58313_15032.t59 a_58313_15032.t86 28611.709050363
Riso20783 a_58313_15032.t59 a_58313_15032.t87 31585.1934504784
Riso20784 a_58313_15032.t59 a_58313_15032.t88 33861.9099081515
Riso20785 a_58313_15032.t59 a_58313_15032.t89 35104.2520885804
Riso20786 a_58313_15032.t59 a_58313_15032.t9 100565832.296558
Riso20787 a_58313_15032.t59 a_58313_15032.t90 45599.1776188327
Riso20788 a_58313_15032.t59 a_58313_15032.t91 43985.4192169787
Riso20789 a_58313_15032.t59 a_58313_15032.t92 41028.0453387604
Riso20790 a_58313_15032.t59 a_58313_15032.t93 37165.5946314915
Riso20791 a_58313_15032.t59 a_58313_15032.t94 32865.7131167157
Riso20792 a_58313_15032.t59 a_58313_15032.t95 28519.7253223621
Riso20793 a_58313_15032.t59 a_58313_15032.t96 24398.2546165891
Riso20794 a_58313_15032.t59 a_58313_15032.t97 20655.4271388493
Riso20795 a_58313_15032.t59 a_58313_15032.t98 17356.106641506
Riso20796 a_58313_15032.t59 a_58313_15032.t99 14506.6820364666
Riso20797 a_58313_15032.t6 a_58313_15032.t60 5350.30767233608
Riso20798 a_58313_15032.t6 a_58313_15032.t61 6401.2232633556
Riso20799 a_58313_15032.t6 a_58313_15032.t62 7618.06800607879
Riso20800 a_58313_15032.t6 a_58313_15032.t63 8998.48556262566
Riso20801 a_58313_15032.t6 a_58313_15032.t64 10518.5530930902
Riso20802 a_58313_15032.t6 a_58313_15032.t65 12121.4262919069
Riso20803 a_58313_15032.t6 a_58313_15032.t66 13707.2947214217
Riso20804 a_58313_15032.t6 a_58313_15032.t67 15131.8313315972
Riso20805 a_58313_15032.t6 a_58313_15032.t68 16222.5604253225
Riso20806 a_58313_15032.t6 a_58313_15032.t69 16817.7415933547
Riso20807 a_58313_15032.t6 a_58313_15032.t7 149000.435222861
Riso20808 a_58313_15032.t6 a_58313_15032.t70 14863.0650376937
Riso20809 a_58313_15032.t6 a_58313_15032.t71 14337.0600232529
Riso20810 a_58313_15032.t6 a_58313_15032.t72 13373.1031585006
Riso20811 a_58313_15032.t6 a_58313_15032.t73 12114.1362414457
Riso20812 a_58313_15032.t6 a_58313_15032.t74 10712.5886270848
Riso20813 a_58313_15032.t6 a_58313_15032.t75 9296.01265765719
Riso20814 a_58313_15032.t6 a_58313_15032.t76 7952.61809771772
Riso20815 a_58313_15032.t6 a_58313_15032.t77 6732.64240667503
Riso20816 a_58313_15032.t6 a_58313_15032.t78 5657.2279432362
Riso20817 a_58313_15032.t6 a_58313_15032.t79 4728.45717507187
Riso20818 a_58313_15032.t6 a_58313_15032.t8 149000.435222861
Riso20819 a_58313_15032.t6 a_58313_15032.t80 4728.45717507187
Riso20820 a_58313_15032.t6 a_58313_15032.t81 5657.2279432362
Riso20821 a_58313_15032.t6 a_58313_15032.t82 6732.64240667503
Riso20822 a_58313_15032.t6 a_58313_15032.t83 7952.61809771772
Riso20823 a_58313_15032.t6 a_58313_15032.t84 9296.01265765719
Riso20824 a_58313_15032.t6 a_58313_15032.t85 10712.5886270848
Riso20825 a_58313_15032.t6 a_58313_15032.t86 12114.1362414457
Riso20826 a_58313_15032.t6 a_58313_15032.t87 13373.1031585006
Riso20827 a_58313_15032.t6 a_58313_15032.t88 14337.0600232529
Riso20828 a_58313_15032.t6 a_58313_15032.t89 14863.0650376937
Riso20829 a_58313_15032.t6 a_58313_15032.t9 226375.145214963
Riso20830 a_58313_15032.t6 a_58313_15032.t90 12562.3457361171
Riso20831 a_58313_15032.t6 a_58313_15032.t91 12117.7633546515
Riso20832 a_58313_15032.t6 a_58313_15032.t92 11303.0216187435
Riso20833 a_58313_15032.t6 a_58313_15032.t93 10238.9357359011
Riso20834 a_58313_15032.t6 a_58313_15032.t94 9054.33984988583
Riso20835 a_58313_15032.t6 a_58313_15032.t95 7857.04191407686
Riso20836 a_58313_15032.t6 a_58313_15032.t96 6721.59731505375
Riso20837 a_58313_15032.t6 a_58313_15032.t97 5690.46703461231
Riso20838 a_58313_15032.t6 a_58313_15032.t98 4781.52071263378
Riso20839 a_58313_15032.t6 a_58313_15032.t99 3996.51846244584
Riso20840 a_58313_15032.t60 a_58313_15032.t61 4866.20614985211
Riso20841 a_58313_15032.t60 a_58313_15032.t62 5791.25080566852
Riso20842 a_58313_15032.t60 a_58313_15032.t63 6840.64341809098
Riso20843 a_58313_15032.t60 a_58313_15032.t64 7996.19785833078
Riso20844 a_58313_15032.t60 a_58313_15032.t65 9214.70111881957
Riso20845 a_58313_15032.t60 a_58313_15032.t66 10420.277363713
Riso20846 a_58313_15032.t60 a_58313_15032.t67 11503.2092546859
Riso20847 a_58313_15032.t60 a_58313_15032.t68 12332.3808685075
Riso20848 a_58313_15032.t60 a_58313_15032.t69 12784.8372414534
Riso20849 a_58313_15032.t60 a_58313_15032.t7 66192570.5956254
Riso20850 a_58313_15032.t60 a_58313_15032.t70 35104.2520885804
Riso20851 a_58313_15032.t60 a_58313_15032.t71 33861.9099081515
Riso20852 a_58313_15032.t60 a_58313_15032.t72 31585.1934504784
Riso20853 a_58313_15032.t60 a_58313_15032.t73 28611.709050363
Riso20854 a_58313_15032.t60 a_58313_15032.t74 25301.4711792446
Riso20855 a_58313_15032.t60 a_58313_15032.t75 21955.7386666504
Riso20856 a_58313_15032.t60 a_58313_15032.t76 18782.8492816586
Riso20857 a_58313_15032.t60 a_58313_15032.t77 15901.4561038926
Riso20858 a_58313_15032.t60 a_58313_15032.t78 13361.4941022111
Riso20859 a_58313_15032.t60 a_58313_15032.t79 11167.8817419436
Riso20860 a_58313_15032.t60 a_58313_15032.t8 66192570.5956254
Riso20861 a_58313_15032.t60 a_58313_15032.t80 11167.8817419436
Riso20862 a_58313_15032.t60 a_58313_15032.t81 13361.4941022111
Riso20863 a_58313_15032.t60 a_58313_15032.t82 15901.4561038926
Riso20864 a_58313_15032.t60 a_58313_15032.t83 18782.8492816586
Riso20865 a_58313_15032.t60 a_58313_15032.t84 21955.7386666504
Riso20866 a_58313_15032.t60 a_58313_15032.t85 25301.4711792446
Riso20867 a_58313_15032.t60 a_58313_15032.t86 28611.709050363
Riso20868 a_58313_15032.t60 a_58313_15032.t87 31585.1934504784
Riso20869 a_58313_15032.t60 a_58313_15032.t88 33861.9099081515
Riso20870 a_58313_15032.t60 a_58313_15032.t89 35104.2520885804
Riso20871 a_58313_15032.t60 a_58313_15032.t9 100565832.296558
Riso20872 a_58313_15032.t60 a_58313_15032.t90 45599.1776188327
Riso20873 a_58313_15032.t60 a_58313_15032.t91 43985.4192169787
Riso20874 a_58313_15032.t60 a_58313_15032.t92 41028.0453387604
Riso20875 a_58313_15032.t60 a_58313_15032.t93 37165.5946314915
Riso20876 a_58313_15032.t60 a_58313_15032.t94 32865.7131167157
Riso20877 a_58313_15032.t60 a_58313_15032.t95 28519.7253223621
Riso20878 a_58313_15032.t60 a_58313_15032.t96 24398.2546165891
Riso20879 a_58313_15032.t60 a_58313_15032.t97 20655.4271388493
Riso20880 a_58313_15032.t60 a_58313_15032.t98 17356.106641506
Riso20881 a_58313_15032.t60 a_58313_15032.t99 14506.6820364666
Riso20882 a_58313_15032.t61 a_58313_15032.t62 2944.16465327316
Riso20883 a_58313_15032.t61 a_58313_15032.t63 3477.65642224923
Riso20884 a_58313_15032.t61 a_58313_15032.t64 4065.11889832726
Riso20885 a_58313_15032.t61 a_58313_15032.t65 4684.58338878202
Riso20886 a_58313_15032.t61 a_58313_15032.t66 5297.47602392173
Riso20887 a_58313_15032.t61 a_58313_15032.t67 5848.01854095169
Riso20888 a_58313_15032.t61 a_58313_15032.t68 6269.55403282189
Riso20889 a_58313_15032.t61 a_58313_15032.t69 6499.57447315085
Riso20890 a_58313_15032.t61 a_58313_15032.t7 79194216.2408429
Riso20891 a_58313_15032.t61 a_58313_15032.t70 41999.4828099309
Riso20892 a_58313_15032.t61 a_58313_15032.t71 40513.1178841289
Riso20893 a_58313_15032.t61 a_58313_15032.t72 37789.2053083575
Riso20894 a_58313_15032.t61 a_58313_15032.t73 34231.6645684748
Riso20895 a_58313_15032.t61 a_58313_15032.t74 30271.224727341
Riso20896 a_58313_15032.t61 a_58313_15032.t75 26268.3183331313
Riso20897 a_58313_15032.t61 a_58313_15032.t76 22472.2051771946
Riso20898 a_58313_15032.t61 a_58313_15032.t77 19024.8443579734
Riso20899 a_58313_15032.t61 a_58313_15032.t78 15985.9791470493
Riso20900 a_58313_15032.t61 a_58313_15032.t79 13361.4941022111
Riso20901 a_58313_15032.t61 a_58313_15032.t8 79194216.2408429
Riso20902 a_58313_15032.t61 a_58313_15032.t80 13361.4941022111
Riso20903 a_58313_15032.t61 a_58313_15032.t81 15985.9791470493
Riso20904 a_58313_15032.t61 a_58313_15032.t82 19024.8443579734
Riso20905 a_58313_15032.t61 a_58313_15032.t83 22472.2051771946
Riso20906 a_58313_15032.t61 a_58313_15032.t84 26268.3183331313
Riso20907 a_58313_15032.t61 a_58313_15032.t85 30271.224727341
Riso20908 a_58313_15032.t61 a_58313_15032.t86 34231.6645684748
Riso20909 a_58313_15032.t61 a_58313_15032.t87 37789.2053083575
Riso20910 a_58313_15032.t61 a_58313_15032.t88 40513.1178841289
Riso20911 a_58313_15032.t61 a_58313_15032.t89 41999.4828099309
Riso20912 a_58313_15032.t61 a_58313_15032.t9 120319126.416587
Riso20913 a_58313_15032.t61 a_58313_15032.t90 54555.8376152429
Riso20914 a_58313_15032.t61 a_58313_15032.t91 52625.1023274772
Riso20915 a_58313_15032.t61 a_58313_15032.t92 49086.8365627673
Riso20916 a_58313_15032.t61 a_58313_15032.t93 44465.7173982055
Riso20917 a_58313_15032.t61 a_58313_15032.t94 39321.2465999426
Riso20918 a_58313_15032.t61 a_58313_15032.t95 34121.6132563652
Riso20919 a_58313_15032.t61 a_58313_15032.t96 29190.5969902459
Riso20920 a_58313_15032.t61 a_58313_15032.t97 24712.5976323559
Riso20921 a_58313_15032.t61 a_58313_15032.t98 20765.2195722007
Riso20922 a_58313_15032.t61 a_58313_15032.t99 17356.106641506
Riso20923 a_58313_15032.t62 a_58313_15032.t63 2275.49353696054
Riso20924 a_58313_15032.t62 a_58313_15032.t64 2659.88086716661
Riso20925 a_58313_15032.t62 a_58313_15032.t65 3065.2076945634
Riso20926 a_58313_15032.t62 a_58313_15032.t66 3466.23443808773
Riso20927 a_58313_15032.t62 a_58313_15032.t67 3826.46437089789
Riso20928 a_58313_15032.t62 a_58313_15032.t68 4102.28267233026
Riso20929 a_58313_15032.t62 a_58313_15032.t69 4252.78920943056
Riso20930 a_58313_15032.t62 a_58313_15032.t7 94248692.8185336
Riso20931 a_58313_15032.t62 a_58313_15032.t70 49983.4020940657
Riso20932 a_58313_15032.t62 a_58313_15032.t71 48214.4856509492
Riso20933 a_58313_15032.t62 a_58313_15032.t72 44972.7691241051
Riso20934 a_58313_15032.t62 a_58313_15032.t73 40738.9553394854
Riso20935 a_58313_15032.t62 a_58313_15032.t74 36025.6530842028
Riso20936 a_58313_15032.t62 a_58313_15032.t75 31261.8115685311
Riso20937 a_58313_15032.t62 a_58313_15032.t76 26744.0737876532
Riso20938 a_58313_15032.t62 a_58313_15032.t77 22641.3846481166
Riso20939 a_58313_15032.t62 a_58313_15032.t78 19024.8443579734
Riso20940 a_58313_15032.t62 a_58313_15032.t79 15901.4561038926
Riso20941 a_58313_15032.t62 a_58313_15032.t8 94248692.8185336
Riso20942 a_58313_15032.t62 a_58313_15032.t80 15901.4561038926
Riso20943 a_58313_15032.t62 a_58313_15032.t81 19024.8443579734
Riso20944 a_58313_15032.t62 a_58313_15032.t82 22641.3846481166
Riso20945 a_58313_15032.t62 a_58313_15032.t83 26744.0737876532
Riso20946 a_58313_15032.t62 a_58313_15032.t84 31261.8115685311
Riso20947 a_58313_15032.t62 a_58313_15032.t85 36025.6530842028
Riso20948 a_58313_15032.t62 a_58313_15032.t86 40738.9553394854
Riso20949 a_58313_15032.t62 a_58313_15032.t87 44972.7691241051
Riso20950 a_58313_15032.t62 a_58313_15032.t88 48214.4856509492
Riso20951 a_58313_15032.t62 a_58313_15032.t89 49983.4020940657
Riso20952 a_58313_15032.t62 a_58313_15032.t9 143191269.818804
Riso20953 a_58313_15032.t62 a_58313_15032.t90 64926.6654173291
Riso20954 a_58313_15032.t62 a_58313_15032.t91 62628.9057362794
Riso20955 a_58313_15032.t62 a_58313_15032.t92 58418.0310159044
Riso20956 a_58313_15032.t62 a_58313_15032.t93 52918.4571670505
Riso20957 a_58313_15032.t62 a_58313_15032.t94 46796.0448117737
Riso20958 a_58313_15032.t62 a_58313_15032.t95 40607.9837508817
Riso20959 a_58313_15032.t62 a_58313_15032.t96 34739.602707305
Riso20960 a_58313_15032.t62 a_58313_15032.t97 29410.3551188214
Riso20961 a_58313_15032.t62 a_58313_15032.t98 24712.5976323559
Riso20962 a_58313_15032.t62 a_58313_15032.t99 20655.4271388493
Riso20963 a_58313_15032.t63 a_58313_15032.t64 1924.14258624939
Riso20964 a_58313_15032.t63 a_58313_15032.t65 2217.35369189348
Riso20965 a_58313_15032.t63 a_58313_15032.t66 2507.45414149071
Riso20966 a_58313_15032.t63 a_58313_15032.t67 2768.04241185944
Riso20967 a_58313_15032.t63 a_58313_15032.t68 2967.56779151235
Riso20968 a_58313_15032.t63 a_58313_15032.t69 3076.44335850424
Riso20969 a_58313_15032.t63 a_58313_15032.t7 111326848.348844
Riso20970 a_58313_15032.t63 a_58313_15032.t70 59040.5496190724
Riso20971 a_58313_15032.t63 a_58313_15032.t71 56951.1000286811
Riso20972 a_58313_15032.t63 a_58313_15032.t72 53121.9744102624
Riso20973 a_58313_15032.t63 a_58313_15032.t73 48120.9804331352
Riso20974 a_58313_15032.t63 a_58313_15032.t74 42553.6131869242
Riso20975 a_58313_15032.t63 a_58313_15032.t75 36926.5488095514
Riso20976 a_58313_15032.t63 a_58313_15032.t76 31590.1829272149
Riso20977 a_58313_15032.t63 a_58313_15032.t77 26744.0737876532
Riso20978 a_58313_15032.t63 a_58313_15032.t78 22472.2051771946
Riso20979 a_58313_15032.t63 a_58313_15032.t79 18782.8492816586
Riso20980 a_58313_15032.t63 a_58313_15032.t8 111326848.348844
Riso20981 a_58313_15032.t63 a_58313_15032.t80 18782.8492816586
Riso20982 a_58313_15032.t63 a_58313_15032.t81 22472.2051771946
Riso20983 a_58313_15032.t63 a_58313_15032.t82 26744.0737876532
Riso20984 a_58313_15032.t63 a_58313_15032.t83 31590.1829272149
Riso20985 a_58313_15032.t63 a_58313_15032.t84 36926.5488095514
Riso20986 a_58313_15032.t63 a_58313_15032.t85 42553.6131869242
Riso20987 a_58313_15032.t63 a_58313_15032.t86 48120.9804331352
Riso20988 a_58313_15032.t63 a_58313_15032.t87 53121.9744102624
Riso20989 a_58313_15032.t63 a_58313_15032.t88 56951.1000286811
Riso20990 a_58313_15032.t63 a_58313_15032.t89 59040.5496190724
Riso20991 a_58313_15032.t63 a_58313_15032.t9 169137972.138131
Riso20992 a_58313_15032.t63 a_58313_15032.t90 76691.578615611
Riso20993 a_58313_15032.t63 a_58313_15032.t91 73977.4577519209
Riso20994 a_58313_15032.t63 a_58313_15032.t92 69003.5594686442
Riso20995 a_58313_15032.t63 a_58313_15032.t93 62507.4457768241
Riso20996 a_58313_15032.t63 a_58313_15032.t94 55275.6333089597
Riso20997 a_58313_15032.t63 a_58313_15032.t95 47966.276386358
Riso20998 a_58313_15032.t63 a_58313_15032.t96 41034.5264919655
Riso20999 a_58313_15032.t63 a_58313_15032.t97 34739.602707305
Riso21000 a_58313_15032.t63 a_58313_15032.t98 29190.5969902459
Riso21001 a_58313_15032.t63 a_58313_15032.t99 24398.2546165891
Riso21002 a_58313_15032.t64 a_58313_15032.t65 1688.38857255739
Riso21003 a_58313_15032.t64 a_58313_15032.t66 1909.28354559864
Riso21004 a_58313_15032.t64 a_58313_15032.t67 2107.70667468335
Riso21005 a_58313_15032.t64 a_58313_15032.t68 2259.63388962103
Riso21006 a_58313_15032.t64 a_58313_15032.t69 2342.53643413247
Riso21007 a_58313_15032.t64 a_58313_15032.t7 130132715.876918
Riso21008 a_58313_15032.t64 a_58313_15032.t70 69013.9636821544
Riso21009 a_58313_15032.t64 a_58313_15032.t71 66571.554201258
Riso21010 a_58313_15032.t64 a_58313_15032.t72 62095.5942369796
Riso21011 a_58313_15032.t64 a_58313_15032.t73 56249.8082654914
Riso21012 a_58313_15032.t64 a_58313_15032.t74 49741.974523864
Riso21013 a_58313_15032.t64 a_58313_15032.t75 43164.3593240947
Riso21014 a_58313_15032.t64 a_58313_15032.t76 36926.5488095514
Riso21015 a_58313_15032.t64 a_58313_15032.t77 31261.8115685311
Riso21016 a_58313_15032.t64 a_58313_15032.t78 26268.3183331313
Riso21017 a_58313_15032.t64 a_58313_15032.t79 21955.7386666504
Riso21018 a_58313_15032.t64 a_58313_15032.t8 130132715.876918
Riso21019 a_58313_15032.t64 a_58313_15032.t80 21955.7386666504
Riso21020 a_58313_15032.t64 a_58313_15032.t81 26268.3183331313
Riso21021 a_58313_15032.t64 a_58313_15032.t82 31261.8115685311
Riso21022 a_58313_15032.t64 a_58313_15032.t83 36926.5488095514
Riso21023 a_58313_15032.t64 a_58313_15032.t84 43164.3593240947
Riso21024 a_58313_15032.t64 a_58313_15032.t85 49741.974523864
Riso21025 a_58313_15032.t64 a_58313_15032.t86 56249.8082654914
Riso21026 a_58313_15032.t64 a_58313_15032.t87 62095.5942369796
Riso21027 a_58313_15032.t64 a_58313_15032.t88 66571.554201258
Riso21028 a_58313_15032.t64 a_58313_15032.t89 69013.9636821544
Riso21029 a_58313_15032.t64 a_58313_15032.t9 197709573.195494
Riso21030 a_58313_15032.t64 a_58313_15032.t90 89646.6895287012
Riso21031 a_58313_15032.t64 a_58313_15032.t91 86474.0862937344
Riso21032 a_58313_15032.t64 a_58313_15032.t92 80659.9731512325
Riso21033 a_58313_15032.t64 a_58313_15032.t93 73066.5046402687
Riso21034 a_58313_15032.t64 a_58313_15032.t94 64613.0595718625
Riso21035 a_58313_15032.t64 a_58313_15032.t95 56068.9708658626
Riso21036 a_58313_15032.t64 a_58313_15032.t96 47966.276386358
Riso21037 a_58313_15032.t64 a_58313_15032.t97 40607.9837508817
Riso21038 a_58313_15032.t64 a_58313_15032.t98 34121.6132563652
Riso21039 a_58313_15032.t64 a_58313_15032.t99 28519.725322362
Riso21040 a_58313_15032.t65 a_58313_15032.t66 1497.18717873619
Riso21041 a_58313_15032.t65 a_58313_15032.t67 1652.78301232266
Riso21042 a_58313_15032.t65 a_58313_15032.t68 1771.91852722831
Riso21043 a_58313_15032.t65 a_58313_15032.t69 1836.92753388595
Riso21044 a_58313_15032.t65 a_58313_15032.t7 149963032.910291
Riso21045 a_58313_15032.t65 a_58313_15032.t70 79530.679408285
Riso21046 a_58313_15032.t65 a_58313_15032.t71 76716.082549256
Riso21047 a_58313_15032.t65 a_58313_15032.t72 71558.0519425401
Riso21048 a_58313_15032.t65 a_58313_15032.t73 64821.4539385611
Riso21049 a_58313_15032.t65 a_58313_15032.t74 57321.9217955953
Riso21050 a_58313_15032.t65 a_58313_15032.t75 49741.974523864
Riso21051 a_58313_15032.t65 a_58313_15032.t76 42553.6131869242
Riso21052 a_58313_15032.t65 a_58313_15032.t77 36025.6530842027
Riso21053 a_58313_15032.t65 a_58313_15032.t78 30271.2247273409
Riso21054 a_58313_15032.t65 a_58313_15032.t79 25301.4711792446
Riso21055 a_58313_15032.t65 a_58313_15032.t8 149963032.910291
Riso21056 a_58313_15032.t65 a_58313_15032.t80 25301.4711792446
Riso21057 a_58313_15032.t65 a_58313_15032.t81 30271.2247273409
Riso21058 a_58313_15032.t65 a_58313_15032.t82 36025.6530842027
Riso21059 a_58313_15032.t65 a_58313_15032.t83 42553.6131869241
Riso21060 a_58313_15032.t65 a_58313_15032.t84 49741.9745238639
Riso21061 a_58313_15032.t65 a_58313_15032.t85 57321.9217955953
Riso21062 a_58313_15032.t65 a_58313_15032.t86 64821.4539385611
Riso21063 a_58313_15032.t65 a_58313_15032.t87 71558.0519425401
Riso21064 a_58313_15032.t65 a_58313_15032.t88 76716.082549256
Riso21065 a_58313_15032.t65 a_58313_15032.t89 79530.679408285
Riso21066 a_58313_15032.t65 a_58313_15032.t9 227837612.025545
Riso21067 a_58313_15032.t65 a_58313_15032.t90 103307.530020403
Riso21068 a_58313_15032.t65 a_58313_15032.t91 99651.4685901123
Riso21069 a_58313_15032.t65 a_58313_15032.t92 92951.3698896608
Riso21070 a_58313_15032.t65 a_58313_15032.t93 84200.7681632665
Riso21071 a_58313_15032.t65 a_58313_15032.t94 74459.1420667377
Riso21072 a_58313_15032.t65 a_58313_15032.t95 64613.0595718624
Riso21073 a_58313_15032.t65 a_58313_15032.t96 55275.6333089596
Riso21074 a_58313_15032.t65 a_58313_15032.t97 46796.0448117736
Riso21075 a_58313_15032.t65 a_58313_15032.t98 39321.2465999425
Riso21076 a_58313_15032.t65 a_58313_15032.t99 32865.7131167156
Riso21077 a_58313_15032.t66 a_58313_15032.t67 1319.55738070574
Riso21078 a_58313_15032.t66 a_58313_15032.t68 1414.673404301
Riso21079 a_58313_15032.t66 a_58313_15032.t69 1466.57562855419
Riso21080 a_58313_15032.t66 a_58313_15032.t7 169582971.501635
Riso21081 a_58313_15032.t66 a_58313_15032.t70 89935.8240351732
Riso21082 a_58313_15032.t66 a_58313_15032.t71 86752.9883077921
Riso21083 a_58313_15032.t66 a_58313_15032.t72 80920.1230982272
Riso21084 a_58313_15032.t66 a_58313_15032.t73 73302.1636241071
Riso21085 a_58313_15032.t66 a_58313_15032.t74 64821.4539385611
Riso21086 a_58313_15032.t66 a_58313_15032.t75 56249.8082654914
Riso21087 a_58313_15032.t66 a_58313_15032.t76 48120.9804331352
Riso21088 a_58313_15032.t66 a_58313_15032.t77 40738.9553394854
Riso21089 a_58313_15032.t66 a_58313_15032.t78 34231.6645684748
Riso21090 a_58313_15032.t66 a_58313_15032.t79 28611.709050363
Riso21091 a_58313_15032.t66 a_58313_15032.t8 169582971.501635
Riso21092 a_58313_15032.t66 a_58313_15032.t80 28611.709050363
Riso21093 a_58313_15032.t66 a_58313_15032.t81 34231.6645684748
Riso21094 a_58313_15032.t66 a_58313_15032.t82 40738.9553394854
Riso21095 a_58313_15032.t66 a_58313_15032.t83 48120.9804331352
Riso21096 a_58313_15032.t66 a_58313_15032.t84 56249.8082654914
Riso21097 a_58313_15032.t66 a_58313_15032.t85 64821.4539385611
Riso21098 a_58313_15032.t66 a_58313_15032.t86 73302.1636241071
Riso21099 a_58313_15032.t66 a_58313_15032.t87 80920.1230982272
Riso21100 a_58313_15032.t66 a_58313_15032.t88 86752.9883077921
Riso21101 a_58313_15032.t66 a_58313_15032.t89 89935.8240351732
Riso21102 a_58313_15032.t66 a_58313_15032.t9 257646024.605554
Riso21103 a_58313_15032.t66 a_58313_15032.t90 116823.44361383
Riso21104 a_58313_15032.t66 a_58313_15032.t91 112689.052962287
Riso21105 a_58313_15032.t66 a_58313_15032.t92 105112.368062506
Riso21106 a_58313_15032.t66 a_58313_15032.t93 95216.9090657747
Riso21107 a_58313_15032.t66 a_58313_15032.t94 84200.7681632666
Riso21108 a_58313_15032.t66 a_58313_15032.t95 73066.5046402687
Riso21109 a_58313_15032.t66 a_58313_15032.t96 62507.4457768241
Riso21110 a_58313_15032.t66 a_58313_15032.t97 52918.4571670505
Riso21111 a_58313_15032.t66 a_58313_15032.t98 44465.7173982055
Riso21112 a_58313_15032.t66 a_58313_15032.t99 37165.5946314914
Riso21113 a_58313_15032.t67 a_58313_15032.t68 1142.42728719483
Riso21114 a_58313_15032.t67 a_58313_15032.t69 1184.34121381046
Riso21115 a_58313_15032.t67 a_58313_15032.t7 187206956.122676
Riso21116 a_58313_15032.t67 a_58313_15032.t70 99282.4439560377
Riso21117 a_58313_15032.t67 a_58313_15032.t71 95768.830631036
Riso21118 a_58313_15032.t67 a_58313_15032.t72 89329.7823487268
Riso21119 a_58313_15032.t67 a_58313_15032.t73 80920.1230982272
Riso21120 a_58313_15032.t67 a_58313_15032.t74 71558.0519425401
Riso21121 a_58313_15032.t67 a_58313_15032.t75 62095.5942369796
Riso21122 a_58313_15032.t67 a_58313_15032.t76 53121.9744102624
Riso21123 a_58313_15032.t67 a_58313_15032.t77 44972.769124105
Riso21124 a_58313_15032.t67 a_58313_15032.t78 37789.2053083575
Riso21125 a_58313_15032.t67 a_58313_15032.t79 31585.1934504783
Riso21126 a_58313_15032.t67 a_58313_15032.t8 187206956.122676
Riso21127 a_58313_15032.t67 a_58313_15032.t80 31585.1934504783
Riso21128 a_58313_15032.t67 a_58313_15032.t81 37789.2053083575
Riso21129 a_58313_15032.t67 a_58313_15032.t82 44972.769124105
Riso21130 a_58313_15032.t67 a_58313_15032.t83 53121.9744102624
Riso21131 a_58313_15032.t67 a_58313_15032.t84 62095.5942369796
Riso21132 a_58313_15032.t67 a_58313_15032.t85 71558.0519425401
Riso21133 a_58313_15032.t67 a_58313_15032.t86 80920.1230982272
Riso21134 a_58313_15032.t67 a_58313_15032.t87 89329.7823487268
Riso21135 a_58313_15032.t67 a_58313_15032.t88 95768.830631036
Riso21136 a_58313_15032.t67 a_58313_15032.t89 99282.4439560377
Riso21137 a_58313_15032.t67 a_58313_15032.t9 284422000.60782
Riso21138 a_58313_15032.t67 a_58313_15032.t90 128964.371181002
Riso21139 a_58313_15032.t67 a_58313_15032.t91 124400.312169395
Riso21140 a_58313_15032.t67 a_58313_15032.t92 116036.216971457
Riso21141 a_58313_15032.t67 a_58313_15032.t93 105112.368062506
Riso21142 a_58313_15032.t67 a_58313_15032.t94 92951.3698896609
Riso21143 a_58313_15032.t67 a_58313_15032.t95 80659.9731512326
Riso21144 a_58313_15032.t67 a_58313_15032.t96 69003.5594686443
Riso21145 a_58313_15032.t67 a_58313_15032.t97 58418.0310159044
Riso21146 a_58313_15032.t67 a_58313_15032.t98 49086.8365627672
Riso21147 a_58313_15032.t67 a_58313_15032.t99 41028.0453387604
Riso21148 a_58313_15032.t68 a_58313_15032.t69 963.556960007447
Riso21149 a_58313_15032.t68 a_58313_15032.t7 200701163.738142
Riso21150 a_58313_15032.t68 a_58313_15032.t70 106438.897642704
Riso21151 a_58313_15032.t68 a_58313_15032.t71 102672.016871502
Riso21152 a_58313_15032.t68 a_58313_15032.t72 95768.8306310361
Riso21153 a_58313_15032.t68 a_58313_15032.t73 86752.9883077921
Riso21154 a_58313_15032.t68 a_58313_15032.t74 76716.082549256
Riso21155 a_58313_15032.t68 a_58313_15032.t75 66571.554201258
Riso21156 a_58313_15032.t68 a_58313_15032.t76 56951.1000286811
Riso21157 a_58313_15032.t68 a_58313_15032.t77 48214.4856509492
Riso21158 a_58313_15032.t68 a_58313_15032.t78 40513.1178841288
Riso21159 a_58313_15032.t68 a_58313_15032.t79 33861.9099081515
Riso21160 a_58313_15032.t68 a_58313_15032.t8 200701163.738142
Riso21161 a_58313_15032.t68 a_58313_15032.t80 33861.9099081515
Riso21162 a_58313_15032.t68 a_58313_15032.t81 40513.1178841288
Riso21163 a_58313_15032.t68 a_58313_15032.t82 48214.4856509492
Riso21164 a_58313_15032.t68 a_58313_15032.t83 56951.1000286811
Riso21165 a_58313_15032.t68 a_58313_15032.t84 66571.554201258
Riso21166 a_58313_15032.t68 a_58313_15032.t85 76716.082549256
Riso21167 a_58313_15032.t68 a_58313_15032.t86 86752.9883077921
Riso21168 a_58313_15032.t68 a_58313_15032.t87 95768.8306310361
Riso21169 a_58313_15032.t68 a_58313_15032.t88 102672.016871502
Riso21170 a_58313_15032.t68 a_58313_15032.t89 106438.897642704
Riso21171 a_58313_15032.t68 a_58313_15032.t9 304923640.109361
Riso21172 a_58313_15032.t68 a_58313_15032.t90 138260.350538597
Riso21173 a_58313_15032.t68 a_58313_15032.t91 133367.306102796
Riso21174 a_58313_15032.t68 a_58313_15032.t92 124400.312169395
Riso21175 a_58313_15032.t68 a_58313_15032.t93 112689.052962287
Riso21176 a_58313_15032.t68 a_58313_15032.t94 99651.4685901123
Riso21177 a_58313_15032.t68 a_58313_15032.t95 86474.0862937344
Riso21178 a_58313_15032.t68 a_58313_15032.t96 73977.4577519208
Riso21179 a_58313_15032.t68 a_58313_15032.t97 62628.9057362794
Riso21180 a_58313_15032.t68 a_58313_15032.t98 52625.1023274772
Riso21181 a_58313_15032.t68 a_58313_15032.t99 43985.4192169787
Riso21182 a_58313_15032.t69 a_58313_15032.t7 208064585.413097
Riso21183 a_58313_15032.t69 a_58313_15032.t70 110343.979563321
Riso21184 a_58313_15032.t69 a_58313_15032.t71 106438.897642704
Riso21185 a_58313_15032.t69 a_58313_15032.t72 99282.4439560378
Riso21186 a_58313_15032.t69 a_58313_15032.t73 89935.8240351733
Riso21187 a_58313_15032.t69 a_58313_15032.t74 79530.6794082851
Riso21188 a_58313_15032.t69 a_58313_15032.t75 69013.9636821545
Riso21189 a_58313_15032.t69 a_58313_15032.t76 59040.5496190725
Riso21190 a_58313_15032.t69 a_58313_15032.t77 49983.4020940657
Riso21191 a_58313_15032.t69 a_58313_15032.t78 41999.4828099309
Riso21192 a_58313_15032.t69 a_58313_15032.t79 35104.2520885805
Riso21193 a_58313_15032.t69 a_58313_15032.t8 208064585.413097
Riso21194 a_58313_15032.t69 a_58313_15032.t80 35104.2520885805
Riso21195 a_58313_15032.t69 a_58313_15032.t81 41999.4828099309
Riso21196 a_58313_15032.t69 a_58313_15032.t82 49983.4020940657
Riso21197 a_58313_15032.t69 a_58313_15032.t83 59040.5496190725
Riso21198 a_58313_15032.t69 a_58313_15032.t84 69013.9636821545
Riso21199 a_58313_15032.t69 a_58313_15032.t85 79530.6794082851
Riso21200 a_58313_15032.t69 a_58313_15032.t86 89935.8240351733
Riso21201 a_58313_15032.t69 a_58313_15032.t87 99282.4439560378
Riso21202 a_58313_15032.t69 a_58313_15032.t88 106438.897642704
Riso21203 a_58313_15032.t69 a_58313_15032.t89 110343.979563321
Riso21204 a_58313_15032.t69 a_58313_15032.t9 316110826.565923
Riso21205 a_58313_15032.t69 a_58313_15032.t90 143332.913362752
Riso21206 a_58313_15032.t69 a_58313_15032.t91 138260.350538597
Riso21207 a_58313_15032.t69 a_58313_15032.t92 128964.371181002
Riso21208 a_58313_15032.t69 a_58313_15032.t93 116823.44361383
Riso21209 a_58313_15032.t69 a_58313_15032.t94 103307.530020403
Riso21210 a_58313_15032.t69 a_58313_15032.t95 89646.6895287012
Riso21211 a_58313_15032.t69 a_58313_15032.t96 76691.5786156109
Riso21212 a_58313_15032.t69 a_58313_15032.t97 64926.665417329
Riso21213 a_58313_15032.t69 a_58313_15032.t98 54555.8376152429
Riso21214 a_58313_15032.t69 a_58313_15032.t99 45599.1776188327
Riso21215 a_58313_15032.t7 a_58313_15032.t70 183881851.666551
Riso21216 a_58313_15032.t7 a_58313_15032.t71 177374258.798192
Riso21217 a_58313_15032.t7 a_58313_15032.t72 165448443.17619
Riso21218 a_58313_15032.t7 a_58313_15032.t73 149872842.362503
Riso21219 a_58313_15032.t7 a_58313_15032.t74 132533271.427846
Riso21220 a_58313_15032.t7 a_58313_15032.t75 115007773.717644
Riso21221 a_58313_15032.t7 a_58313_15032.t76 98387656.7650518
Riso21222 a_58313_15032.t7 a_58313_15032.t77 83294444.9350434
Riso21223 a_58313_15032.t7 a_58313_15032.t78 69989705.8153114
Riso21224 a_58313_15032.t7 a_58313_15032.t79 58499203.1369809
Riso21225 a_58313_15032.t7 a_58313_15032.t8 0.810181438795599
Riso21226 a_58313_15032.t7 a_58313_15032.t80 58499203.1369809
Riso21227 a_58313_15032.t7 a_58313_15032.t81 69989705.8153114
Riso21228 a_58313_15032.t7 a_58313_15032.t82 83294444.9350434
Riso21229 a_58313_15032.t7 a_58313_15032.t83 98387656.7650518
Riso21230 a_58313_15032.t7 a_58313_15032.t84 115007773.717644
Riso21231 a_58313_15032.t7 a_58313_15032.t85 132533271.427846
Riso21232 a_58313_15032.t7 a_58313_15032.t86 149872842.362503
Riso21233 a_58313_15032.t7 a_58313_15032.t87 165448443.17619
Riso21234 a_58313_15032.t7 a_58313_15032.t88 177374258.798192
Riso21235 a_58313_15032.t7 a_58313_15032.t89 183881851.666551
Riso21236 a_58313_15032.t7 a_58313_15032.t9 17.808514393306
Riso21237 a_58313_15032.t7 a_58313_15032.t90 155417969.939196
Riso21238 a_58313_15032.t7 a_58313_15032.t91 149917716.033633
Riso21239 a_58313_15032.t7 a_58313_15032.t92 139837949.939034
Riso21240 a_58313_15032.t7 a_58313_15032.t93 126673364.978054
Riso21241 a_58313_15032.t7 a_58313_15032.t94 112017862.600538
Riso21242 a_58313_15032.t7 a_58313_15032.t95 97205213.8719787
Riso21243 a_58313_15032.t7 a_58313_15032.t96 83157798.0258092
Riso21244 a_58313_15032.t7 a_58313_15032.t97 70400930.9330414
Riso21245 a_58313_15032.t7 a_58313_15032.t98 59155690.9823961
Riso21246 a_58313_15032.t7 a_58313_15032.t99 49443853.8235803
Riso21247 a_58313_15032.t70 a_58313_15032.t71 965.003270898412
Riso21248 a_58313_15032.t70 a_58313_15032.t72 1186.68487937122
Riso21249 a_58313_15032.t70 a_58313_15032.t73 1470.54577145056
Riso21250 a_58313_15032.t70 a_58313_15032.t74 1843.97883253606
Riso21251 a_58313_15032.t70 a_58313_15032.t75 2355.77494168798
Riso21252 a_58313_15032.t70 a_58313_15032.t76 3103.21445551542
Riso21253 a_58313_15032.t70 a_58313_15032.t77 4313.55217282585
Riso21254 a_58313_15032.t70 a_58313_15032.t78 6670.47911440152
Riso21255 a_58313_15032.t70 a_58313_15032.t79 13605.1805397892
Riso21256 a_58313_15032.t70 a_58313_15032.t8 183881851.666551
Riso21257 a_58313_15032.t70 a_58313_15032.t80 30030.897663416
Riso21258 a_58313_15032.t70 a_58313_15032.t81 35929.6123728478
Riso21259 a_58313_15032.t70 a_58313_15032.t82 42759.6756475138
Riso21260 a_58313_15032.t70 a_58313_15032.t83 50507.861529942
Riso21261 a_58313_15032.t70 a_58313_15032.t84 59039.8928157109
Riso21262 a_58313_15032.t70 a_58313_15032.t85 68036.7064475673
Riso21263 a_58313_15032.t70 a_58313_15032.t86 76938.073514857
Riso21264 a_58313_15032.t70 a_58313_15032.t87 84933.8965175534
Riso21265 a_58313_15032.t70 a_58313_15032.t88 91056.0815951595
Riso21266 a_58313_15032.t70 a_58313_15032.t89 94396.7912969184
Riso21267 a_58313_15032.t70 a_58313_15032.t9 279370196.544399
Riso21268 a_58313_15032.t70 a_58313_15032.t90 126673.676589969
Riso21269 a_58313_15032.t70 a_58313_15032.t91 122190.685436058
Riso21270 a_58313_15032.t70 a_58313_15032.t92 113975.155205743
Riso21271 a_58313_15032.t70 a_58313_15032.t93 103245.338193973
Riso21272 a_58313_15032.t70 a_58313_15032.t94 91300.3464458556
Riso21273 a_58313_15032.t70 a_58313_15032.t95 79227.2723012347
Riso21274 a_58313_15032.t70 a_58313_15032.t96 67777.9024985106
Riso21275 a_58313_15032.t70 a_58313_15032.t97 57380.3966178026
Riso21276 a_58313_15032.t70 a_58313_15032.t98 48214.944969953
Riso21277 a_58313_15032.t70 a_58313_15032.t99 40299.2958347111
Riso21278 a_58313_15032.t71 a_58313_15032.t72 1144.68801025121
Riso21279 a_58313_15032.t71 a_58313_15032.t73 1418.50304353501
Riso21280 a_58313_15032.t71 a_58313_15032.t74 1778.72027987705
Riso21281 a_58313_15032.t71 a_58313_15032.t75 2272.4038853763
Riso21282 a_58313_15032.t71 a_58313_15032.t76 2993.39145734199
Riso21283 a_58313_15032.t71 a_58313_15032.t77 4160.89522977918
Riso21284 a_58313_15032.t71 a_58313_15032.t78 6434.41034567857
Riso21285 a_58313_15032.t71 a_58313_15032.t79 13123.6921544426
Riso21286 a_58313_15032.t71 a_58313_15032.t8 177374258.798192
Riso21287 a_58313_15032.t71 a_58313_15032.t80 28968.1018861619
Riso21288 a_58313_15032.t71 a_58313_15032.t81 34658.0606285003
Riso21289 a_58313_15032.t71 a_58313_15032.t82 41246.4074387418
Riso21290 a_58313_15032.t71 a_58313_15032.t83 48720.3844270664
Riso21291 a_58313_15032.t71 a_58313_15032.t84 56950.4664696411
Riso21292 a_58313_15032.t71 a_58313_15032.t85 65628.88217534
Riso21293 a_58313_15032.t71 a_58313_15032.t86 74215.2291777306
Riso21294 a_58313_15032.t71 a_58313_15032.t87 81928.0793895974
Riso21295 a_58313_15032.t71 a_58313_15032.t88 87833.5998665987
Riso21296 a_58313_15032.t71 a_58313_15032.t89 91056.0815951596
Riso21297 a_58313_15032.t71 a_58313_15032.t9 269483263.809127
Riso21298 a_58313_15032.t71 a_58313_15032.t90 122190.685436058
Riso21299 a_58313_15032.t71 a_58313_15032.t91 117866.347683763
Riso21300 a_58313_15032.t71 a_58313_15032.t92 109941.565699955
Riso21301 a_58313_15032.t71 a_58313_15032.t93 99591.4777372008
Riso21302 a_58313_15032.t71 a_58313_15032.t94 88069.2201654481
Riso21303 a_58313_15032.t71 a_58313_15032.t95 76423.4130430517
Riso21304 a_58313_15032.t71 a_58313_15032.t96 65379.2373179385
Riso21305 a_58313_15032.t71 a_58313_15032.t97 55349.6999697681
Riso21306 a_58313_15032.t71 a_58313_15032.t98 46508.6143604278
Riso21307 a_58313_15032.t71 a_58313_15032.t99 38873.1006566821
Riso21308 a_58313_15032.t72 a_58313_15032.t73 1323.12953290801
Riso21309 a_58313_15032.t72 a_58313_15032.t74 1659.12744693356
Riso21310 a_58313_15032.t72 a_58313_15032.t75 2119.61807564643
Riso21311 a_58313_15032.t72 a_58313_15032.t76 2792.12981517017
Riso21312 a_58313_15032.t72 a_58313_15032.t77 3881.13609410174
Riso21313 a_58313_15032.t72 a_58313_15032.t78 6001.79068632786
Riso21314 a_58313_15032.t72 a_58313_15032.t79 12241.3164705399
Riso21315 a_58313_15032.t72 a_58313_15032.t8 165448443.17619
Riso21316 a_58313_15032.t72 a_58313_15032.t80 27020.4221926458
Riso21317 a_58313_15032.t72 a_58313_15032.t81 32327.8147198091
Riso21318 a_58313_15032.t72 a_58313_15032.t82 38473.1919027489
Riso21319 a_58313_15032.t72 a_58313_15032.t83 45444.6536324911
Riso21320 a_58313_15032.t72 a_58313_15032.t84 53121.3834487692
Riso21321 a_58313_15032.t72 a_58313_15032.t85 61216.303069419
Riso21322 a_58313_15032.t72 a_58313_15032.t86 69225.3442557862
Riso21323 a_58313_15032.t72 a_58313_15032.t87 76419.618490676
Riso21324 a_58313_15032.t72 a_58313_15032.t88 81928.0793895974
Riso21325 a_58313_15032.t72 a_58313_15032.t89 84933.8965175534
Riso21326 a_58313_15032.t72 a_58313_15032.t9 251364469.463329
Riso21327 a_58313_15032.t72 a_58313_15032.t90 113975.155205743
Riso21328 a_58313_15032.t72 a_58313_15032.t91 109941.565699955
Riso21329 a_58313_15032.t72 a_58313_15032.t92 102549.608994312
Riso21330 a_58313_15032.t72 a_58313_15032.t93 92895.4125411353
Riso21331 a_58313_15032.t72 a_58313_15032.t94 82147.8576814954
Riso21332 a_58313_15032.t72 a_58313_15032.t95 71285.0601651834
Riso21333 a_58313_15032.t72 a_58313_15032.t96 60983.4431646963
Riso21334 a_58313_15032.t72 a_58313_15032.t97 51628.2450019222
Riso21335 a_58313_15032.t72 a_58313_15032.t98 43381.5926411813
Riso21336 a_58313_15032.t72 a_58313_15032.t99 36259.455169292
Riso21337 a_58313_15032.t73 a_58313_15032.t74 1502.934337368
Riso21338 a_58313_15032.t73 a_58313_15032.t75 1920.07358680171
Riso21339 a_58313_15032.t73 a_58313_15032.t76 2529.27391525231
Riso21340 a_58313_15032.t73 a_58313_15032.t77 3515.75927129931
Riso21341 a_58313_15032.t73 a_58313_15032.t78 5436.77179522834
Riso21342 a_58313_15032.t73 a_58313_15032.t79 11088.8978976065
Riso21343 a_58313_15032.t73 a_58313_15032.t8 149872842.362503
Riso21344 a_58313_15032.t73 a_58313_15032.t80 24476.6732046798
Riso21345 a_58313_15032.t73 a_58313_15032.t81 29284.4186769802
Riso21346 a_58313_15032.t73 a_58313_15032.t82 34851.2594892328
Riso21347 a_58313_15032.t73 a_58313_15032.t83 41166.415829176
Riso21348 a_58313_15032.t73 a_58313_15032.t84 48120.4451057727
Riso21349 a_58313_15032.t73 a_58313_15032.t85 55453.2950797722
Riso21350 a_58313_15032.t73 a_58313_15032.t86 62708.3513629004
Riso21351 a_58313_15032.t73 a_58313_15032.t87 69225.3442557862
Riso21352 a_58313_15032.t73 a_58313_15032.t88 74215.2291777306
Riso21353 a_58313_15032.t73 a_58313_15032.t89 76938.073514857
Riso21354 a_58313_15032.t73 a_58313_15032.t9 227700586.26235
Riso21355 a_58313_15032.t73 a_58313_15032.t90 103245.338193973
Riso21356 a_58313_15032.t73 a_58313_15032.t91 99591.4777372008
Riso21357 a_58313_15032.t73 a_58313_15032.t92 92895.4125411353
Riso21358 a_58313_15032.t73 a_58313_15032.t93 84150.0787357109
Riso21359 a_58313_15032.t73 a_58313_15032.t94 74414.317163474
Riso21360 a_58313_15032.t73 a_58313_15032.t95 64574.1620763435
Riso21361 a_58313_15032.t73 a_58313_15032.t96 55242.3570067201
Riso21362 a_58313_15032.t73 a_58313_15032.t97 46767.8732787209
Riso21363 a_58313_15032.t73 a_58313_15032.t98 39297.5749455811
Riso21364 a_58313_15032.t73 a_58313_15032.t99 32845.9277368381
Riso21365 a_58313_15032.t74 a_58313_15032.t75 1697.93025760815
Riso21366 a_58313_15032.t74 a_58313_15032.t76 2236.6490222072
Riso21367 a_58313_15032.t74 a_58313_15032.t77 3109.00274147771
Riso21368 a_58313_15032.t74 a_58313_15032.t78 4807.76330567902
Riso21369 a_58313_15032.t74 a_58313_15032.t79 9805.9654553323
Riso21370 a_58313_15032.t74 a_58313_15032.t8 132533271.427846
Riso21371 a_58313_15032.t74 a_58313_15032.t80 21644.8392006887
Riso21372 a_58313_15032.t74 a_58313_15032.t81 25896.3515200133
Riso21373 a_58313_15032.t74 a_58313_15032.t82 30819.1354796406
Riso21374 a_58313_15032.t74 a_58313_15032.t83 36403.6584400218
Riso21375 a_58313_15032.t74 a_58313_15032.t84 42553.1397943767
Riso21376 a_58313_15032.t74 a_58313_15032.t85 49037.6141035587
Riso21377 a_58313_15032.t74 a_58313_15032.t86 55453.2950797722
Riso21378 a_58313_15032.t74 a_58313_15032.t87 61216.303069419
Riso21379 a_58313_15032.t74 a_58313_15032.t88 65628.88217534
Riso21380 a_58313_15032.t74 a_58313_15032.t89 68036.7064475674
Riso21381 a_58313_15032.t74 a_58313_15032.t9 201356717.652658
Riso21382 a_58313_15032.t74 a_58313_15032.t90 91300.3464458556
Riso21383 a_58313_15032.t74 a_58313_15032.t91 88069.2201654481
Riso21384 a_58313_15032.t74 a_58313_15032.t92 82147.8576814954
Riso21385 a_58313_15032.t74 a_58313_15032.t93 74414.317163474
Riso21386 a_58313_15032.t74 a_58313_15032.t94 65804.9366334834
Riso21387 a_58313_15032.t74 a_58313_15032.t95 57103.2404188992
Riso21388 a_58313_15032.t74 a_58313_15032.t96 48851.0805565226
Riso21389 a_58313_15032.t74 a_58313_15032.t97 41357.0540575977
Riso21390 a_58313_15032.t74 a_58313_15032.t98 34751.0335069345
Riso21391 a_58313_15032.t74 a_58313_15032.t99 29045.8110183605
Riso21392 a_58313_15032.t75 a_58313_15032.t76 1940.88640430065
Riso21393 a_58313_15032.t75 a_58313_15032.t77 2697.88468908401
Riso21394 a_58313_15032.t75 a_58313_15032.t78 4172.01015556723
Riso21395 a_58313_15032.t75 a_58313_15032.t79 8509.27653124342
Riso21396 a_58313_15032.t75 a_58313_15032.t8 115007773.717644
Riso21397 a_58313_15032.t75 a_58313_15032.t80 18782.6403296988
Riso21398 a_58313_15032.t75 a_58313_15032.t81 22471.9551825723
Riso21399 a_58313_15032.t75 a_58313_15032.t82 26743.7762701389
Riso21400 a_58313_15032.t75 a_58313_15032.t83 31589.8314986041
Riso21401 a_58313_15032.t75 a_58313_15032.t84 36926.1380159266
Riso21402 a_58313_15032.t75 a_58313_15032.t85 42553.1397943767
Riso21403 a_58313_15032.t75 a_58313_15032.t86 48120.4451057727
Riso21404 a_58313_15032.t75 a_58313_15032.t87 53121.3834487692
Riso21405 a_58313_15032.t75 a_58313_15032.t88 56950.4664696411
Riso21406 a_58313_15032.t75 a_58313_15032.t89 59039.8928157109
Riso21407 a_58313_15032.t75 a_58313_15032.t9 174730372.01026
Riso21408 a_58313_15032.t75 a_58313_15032.t90 79227.2723012347
Riso21409 a_58313_15032.t75 a_58313_15032.t91 76423.4130430518
Riso21410 a_58313_15032.t75 a_58313_15032.t92 71285.0601651834
Riso21411 a_58313_15032.t75 a_58313_15032.t93 64574.1620763435
Riso21412 a_58313_15032.t75 a_58313_15032.t94 57103.2404188992
Riso21413 a_58313_15032.t75 a_58313_15032.t95 49552.2104139438
Riso21414 a_58313_15032.t75 a_58313_15032.t96 42391.2724554272
Riso21415 a_58313_15032.t75 a_58313_15032.t97 35888.2163206393
Riso21416 a_58313_15032.t75 a_58313_15032.t98 30155.7409317826
Riso21417 a_58313_15032.t75 a_58313_15032.t99 25204.9468413196
Riso21418 a_58313_15032.t76 a_58313_15032.t77 2308.00531304056
Riso21419 a_58313_15032.t76 a_58313_15032.t78 3569.10050457997
Riso21420 a_58313_15032.t76 a_58313_15032.t79 7279.57555921678
Riso21421 a_58313_15032.t76 a_58313_15032.t8 98387656.7650518
Riso21422 a_58313_15032.t76 a_58313_15032.t80 16068.3048646505
Riso21423 a_58313_15032.t76 a_58313_15032.t81 19224.4658067263
Riso21424 a_58313_15032.t76 a_58313_15032.t82 22878.9532673487
Riso21425 a_58313_15032.t76 a_58313_15032.t83 27024.690577709
Riso21426 a_58313_15032.t76 a_58313_15032.t84 31589.8314986041
Riso21427 a_58313_15032.t76 a_58313_15032.t85 36403.6584400218
Riso21428 a_58313_15032.t76 a_58313_15032.t86 41166.415829176
Riso21429 a_58313_15032.t76 a_58313_15032.t87 45444.6536324911
Riso21430 a_58313_15032.t76 a_58313_15032.t88 48720.3844270664
Riso21431 a_58313_15032.t76 a_58313_15032.t89 50507.861529942
Riso21432 a_58313_15032.t76 a_58313_15032.t9 149479563.963927
Riso21433 a_58313_15032.t76 a_58313_15032.t90 67777.9024985106
Riso21434 a_58313_15032.t76 a_58313_15032.t91 65379.2373179385
Riso21435 a_58313_15032.t76 a_58313_15032.t92 60983.4431646963
Riso21436 a_58313_15032.t76 a_58313_15032.t93 55242.3570067201
Riso21437 a_58313_15032.t76 a_58313_15032.t94 48851.0805565226
Riso21438 a_58313_15032.t76 a_58313_15032.t95 42391.2724554272
Riso21439 a_58313_15032.t76 a_58313_15032.t96 36265.1830337843
Riso21440 a_58313_15032.t76 a_58313_15032.t97 30701.9029681757
Riso21441 a_58313_15032.t76 a_58313_15032.t98 25797.8447228816
Riso21442 a_58313_15032.t76 a_58313_15032.t99 21562.5046763661
Riso21443 a_58313_15032.t77 a_58313_15032.t78 3021.58070657467
Riso21444 a_58313_15032.t77 a_58313_15032.t79 6162.84832370403
Riso21445 a_58313_15032.t77 a_58313_15032.t8 83294444.9350434
Riso21446 a_58313_15032.t77 a_58313_15032.t80 13603.3378449513
Riso21447 a_58313_15032.t77 a_58313_15032.t81 16275.3262064961
Riso21448 a_58313_15032.t77 a_58313_15032.t82 19369.1950368262
Riso21449 a_58313_15032.t77 a_58313_15032.t83 22878.9532673487
Riso21450 a_58313_15032.t77 a_58313_15032.t84 26743.7762701389
Riso21451 a_58313_15032.t77 a_58313_15032.t85 30819.1354796406
Riso21452 a_58313_15032.t77 a_58313_15032.t86 34851.2594892328
Riso21453 a_58313_15032.t77 a_58313_15032.t87 38473.1919027489
Riso21454 a_58313_15032.t77 a_58313_15032.t88 41246.4074387418
Riso21455 a_58313_15032.t77 a_58313_15032.t89 42759.6756475138
Riso21456 a_58313_15032.t77 a_58313_15032.t9 126548570.408988
Riso21457 a_58313_15032.t77 a_58313_15032.t90 57380.3966178026
Riso21458 a_58313_15032.t77 a_58313_15032.t91 55349.6999697681
Riso21459 a_58313_15032.t77 a_58313_15032.t92 51628.2450019222
Riso21460 a_58313_15032.t77 a_58313_15032.t93 46767.8732787209
Riso21461 a_58313_15032.t77 a_58313_15032.t94 41357.0540575977
Riso21462 a_58313_15032.t77 a_58313_15032.t95 35888.2163206393
Riso21463 a_58313_15032.t77 a_58313_15032.t96 30701.9029681757
Riso21464 a_58313_15032.t77 a_58313_15032.t97 25992.0608973394
Riso21465 a_58313_15032.t77 a_58313_15032.t98 21840.3123660541
Riso21466 a_58313_15032.t77 a_58313_15032.t99 18254.6969556973
Riso21467 a_58313_15032.t78 a_58313_15032.t79 5178.44787244581
Riso21468 a_58313_15032.t78 a_58313_15032.t8 69989705.8153114
Riso21469 a_58313_15032.t78 a_58313_15032.t80 11430.457512706
Riso21470 a_58313_15032.t78 a_58313_15032.t81 13675.6454062358
Riso21471 a_58313_15032.t78 a_58313_15032.t82 16275.3262064961
Riso21472 a_58313_15032.t78 a_58313_15032.t83 19224.4658067263
Riso21473 a_58313_15032.t78 a_58313_15032.t84 22471.9551825723
Riso21474 a_58313_15032.t78 a_58313_15032.t85 25896.3515200133
Riso21475 a_58313_15032.t78 a_58313_15032.t86 29284.4186769802
Riso21476 a_58313_15032.t78 a_58313_15032.t87 32327.8147198091
Riso21477 a_58313_15032.t78 a_58313_15032.t88 34658.0606285003
Riso21478 a_58313_15032.t78 a_58313_15032.t89 35929.6123728478
Riso21479 a_58313_15032.t78 a_58313_15032.t9 106334788.846729
Riso21480 a_58313_15032.t78 a_58313_15032.t90 48214.944969953
Riso21481 a_58313_15032.t78 a_58313_15032.t91 46508.6143604278
Riso21482 a_58313_15032.t78 a_58313_15032.t92 43381.5926411813
Riso21483 a_58313_15032.t78 a_58313_15032.t93 39297.5749455811
Riso21484 a_58313_15032.t78 a_58313_15032.t94 34751.0335069345
Riso21485 a_58313_15032.t78 a_58313_15032.t95 30155.7409317826
Riso21486 a_58313_15032.t78 a_58313_15032.t96 25797.8447228816
Riso21487 a_58313_15032.t78 a_58313_15032.t97 21840.3123660541
Riso21488 a_58313_15032.t78 a_58313_15032.t98 18351.7284808934
Riso21489 a_58313_15032.t78 a_58313_15032.t99 15338.8484751087
Riso21490 a_58313_15032.t79 a_58313_15032.t8 58499203.1369809
Riso21491 a_58313_15032.t79 a_58313_15032.t80 9553.87150431672
Riso21492 a_58313_15032.t79 a_58313_15032.t81 11430.457512706
Riso21493 a_58313_15032.t79 a_58313_15032.t82 13603.3378449513
Riso21494 a_58313_15032.t79 a_58313_15032.t83 16068.3048646505
Riso21495 a_58313_15032.t79 a_58313_15032.t84 18782.6403296988
Riso21496 a_58313_15032.t79 a_58313_15032.t85 21644.8392006887
Riso21497 a_58313_15032.t79 a_58313_15032.t86 24476.6732046798
Riso21498 a_58313_15032.t79 a_58313_15032.t87 27020.4221926458
Riso21499 a_58313_15032.t79 a_58313_15032.t88 28968.1018861619
Riso21500 a_58313_15032.t79 a_58313_15032.t89 30030.897663416
Riso21501 a_58313_15032.t79 a_58313_15032.t9 88877361.9035834
Riso21502 a_58313_15032.t79 a_58313_15032.t90 40299.2958347111
Riso21503 a_58313_15032.t79 a_58313_15032.t91 38873.1006566821
Riso21504 a_58313_15032.t79 a_58313_15032.t92 36259.455169292
Riso21505 a_58313_15032.t79 a_58313_15032.t93 32845.9277368381
Riso21506 a_58313_15032.t79 a_58313_15032.t94 29045.8110183605
Riso21507 a_58313_15032.t79 a_58313_15032.t95 25204.9468413196
Riso21508 a_58313_15032.t79 a_58313_15032.t96 21562.5046763661
Riso21509 a_58313_15032.t79 a_58313_15032.t97 18254.6969556973
Riso21510 a_58313_15032.t79 a_58313_15032.t98 15338.8484751087
Riso21511 a_58313_15032.t79 a_58313_15032.t99 12820.6055787772
Riso21512 a_58313_15032.t8 a_58313_15032.t80 58499203.1369809
Riso21513 a_58313_15032.t8 a_58313_15032.t81 69989705.8153114
Riso21514 a_58313_15032.t8 a_58313_15032.t82 83294444.9350434
Riso21515 a_58313_15032.t8 a_58313_15032.t83 98387656.7650518
Riso21516 a_58313_15032.t8 a_58313_15032.t84 115007773.717644
Riso21517 a_58313_15032.t8 a_58313_15032.t85 132533271.427846
Riso21518 a_58313_15032.t8 a_58313_15032.t86 149872842.362503
Riso21519 a_58313_15032.t8 a_58313_15032.t87 165448443.17619
Riso21520 a_58313_15032.t8 a_58313_15032.t88 177374258.798192
Riso21521 a_58313_15032.t8 a_58313_15032.t89 183881851.666551
Riso21522 a_58313_15032.t8 a_58313_15032.t9 17.808514393306
Riso21523 a_58313_15032.t8 a_58313_15032.t90 155417969.939196
Riso21524 a_58313_15032.t8 a_58313_15032.t91 149917716.033633
Riso21525 a_58313_15032.t8 a_58313_15032.t92 139837949.939034
Riso21526 a_58313_15032.t8 a_58313_15032.t93 126673364.978054
Riso21527 a_58313_15032.t8 a_58313_15032.t94 112017862.600538
Riso21528 a_58313_15032.t8 a_58313_15032.t95 97205213.8719787
Riso21529 a_58313_15032.t8 a_58313_15032.t96 83157798.0258092
Riso21530 a_58313_15032.t8 a_58313_15032.t97 70400930.9330414
Riso21531 a_58313_15032.t8 a_58313_15032.t98 59155690.9823961
Riso21532 a_58313_15032.t8 a_58313_15032.t99 49443853.8235803
Riso21533 a_58313_15032.t80 a_58313_15032.t81 5178.44787244581
Riso21534 a_58313_15032.t80 a_58313_15032.t82 6162.84832370403
Riso21535 a_58313_15032.t80 a_58313_15032.t83 7279.57555921678
Riso21536 a_58313_15032.t80 a_58313_15032.t84 8509.27653124342
Riso21537 a_58313_15032.t80 a_58313_15032.t85 9805.9654553323
Riso21538 a_58313_15032.t80 a_58313_15032.t86 11088.8978976065
Riso21539 a_58313_15032.t80 a_58313_15032.t87 12241.3164705399
Riso21540 a_58313_15032.t80 a_58313_15032.t88 13123.6921544426
Riso21541 a_58313_15032.t80 a_58313_15032.t89 13605.1805397892
Riso21542 a_58313_15032.t80 a_58313_15032.t9 88877361.9035834
Riso21543 a_58313_15032.t80 a_58313_15032.t90 40299.2958347111
Riso21544 a_58313_15032.t80 a_58313_15032.t91 38873.1006566821
Riso21545 a_58313_15032.t80 a_58313_15032.t92 36259.455169292
Riso21546 a_58313_15032.t80 a_58313_15032.t93 32845.9277368381
Riso21547 a_58313_15032.t80 a_58313_15032.t94 29045.8110183605
Riso21548 a_58313_15032.t80 a_58313_15032.t95 25204.9468413196
Riso21549 a_58313_15032.t80 a_58313_15032.t96 21562.5046763661
Riso21550 a_58313_15032.t80 a_58313_15032.t97 18254.6969556973
Riso21551 a_58313_15032.t80 a_58313_15032.t98 15338.8484751087
Riso21552 a_58313_15032.t80 a_58313_15032.t99 12820.6055787772
Riso21553 a_58313_15032.t81 a_58313_15032.t82 3021.58070657467
Riso21554 a_58313_15032.t81 a_58313_15032.t83 3569.10050457997
Riso21555 a_58313_15032.t81 a_58313_15032.t84 4172.01015556723
Riso21556 a_58313_15032.t81 a_58313_15032.t85 4807.76330567902
Riso21557 a_58313_15032.t81 a_58313_15032.t86 5436.77179522834
Riso21558 a_58313_15032.t81 a_58313_15032.t87 6001.79068632786
Riso21559 a_58313_15032.t81 a_58313_15032.t88 6434.41034567857
Riso21560 a_58313_15032.t81 a_58313_15032.t89 6670.47911440152
Riso21561 a_58313_15032.t81 a_58313_15032.t9 106334788.846729
Riso21562 a_58313_15032.t81 a_58313_15032.t90 48214.944969953
Riso21563 a_58313_15032.t81 a_58313_15032.t91 46508.6143604278
Riso21564 a_58313_15032.t81 a_58313_15032.t92 43381.5926411813
Riso21565 a_58313_15032.t81 a_58313_15032.t93 39297.5749455811
Riso21566 a_58313_15032.t81 a_58313_15032.t94 34751.0335069345
Riso21567 a_58313_15032.t81 a_58313_15032.t95 30155.7409317826
Riso21568 a_58313_15032.t81 a_58313_15032.t96 25797.8447228816
Riso21569 a_58313_15032.t81 a_58313_15032.t97 21840.3123660541
Riso21570 a_58313_15032.t81 a_58313_15032.t98 18351.7284808934
Riso21571 a_58313_15032.t81 a_58313_15032.t99 15338.8484751087
Riso21572 a_58313_15032.t82 a_58313_15032.t83 2308.00531304056
Riso21573 a_58313_15032.t82 a_58313_15032.t84 2697.88468908401
Riso21574 a_58313_15032.t82 a_58313_15032.t85 3109.00274147771
Riso21575 a_58313_15032.t82 a_58313_15032.t86 3515.75927129931
Riso21576 a_58313_15032.t82 a_58313_15032.t87 3881.13609410174
Riso21577 a_58313_15032.t82 a_58313_15032.t88 4160.89522977918
Riso21578 a_58313_15032.t82 a_58313_15032.t89 4313.55217282585
Riso21579 a_58313_15032.t82 a_58313_15032.t9 126548570.408988
Riso21580 a_58313_15032.t82 a_58313_15032.t90 57380.3966178026
Riso21581 a_58313_15032.t82 a_58313_15032.t91 55349.6999697681
Riso21582 a_58313_15032.t82 a_58313_15032.t92 51628.2450019222
Riso21583 a_58313_15032.t82 a_58313_15032.t93 46767.8732787209
Riso21584 a_58313_15032.t82 a_58313_15032.t94 41357.0540575977
Riso21585 a_58313_15032.t82 a_58313_15032.t95 35888.2163206393
Riso21586 a_58313_15032.t82 a_58313_15032.t96 30701.9029681757
Riso21587 a_58313_15032.t82 a_58313_15032.t97 25992.0608973394
Riso21588 a_58313_15032.t82 a_58313_15032.t98 21840.3123660541
Riso21589 a_58313_15032.t82 a_58313_15032.t99 18254.6969556973
Riso21590 a_58313_15032.t83 a_58313_15032.t84 1940.88640430065
Riso21591 a_58313_15032.t83 a_58313_15032.t85 2236.6490222072
Riso21592 a_58313_15032.t83 a_58313_15032.t86 2529.27391525231
Riso21593 a_58313_15032.t83 a_58313_15032.t87 2792.12981517017
Riso21594 a_58313_15032.t83 a_58313_15032.t88 2993.39145734199
Riso21595 a_58313_15032.t83 a_58313_15032.t89 3103.21445551542
Riso21596 a_58313_15032.t83 a_58313_15032.t9 149479563.963927
Riso21597 a_58313_15032.t83 a_58313_15032.t90 67777.9024985106
Riso21598 a_58313_15032.t83 a_58313_15032.t91 65379.2373179385
Riso21599 a_58313_15032.t83 a_58313_15032.t92 60983.4431646963
Riso21600 a_58313_15032.t83 a_58313_15032.t93 55242.3570067201
Riso21601 a_58313_15032.t83 a_58313_15032.t94 48851.0805565226
Riso21602 a_58313_15032.t83 a_58313_15032.t95 42391.2724554272
Riso21603 a_58313_15032.t83 a_58313_15032.t96 36265.1830337843
Riso21604 a_58313_15032.t83 a_58313_15032.t97 30701.9029681757
Riso21605 a_58313_15032.t83 a_58313_15032.t98 25797.8447228816
Riso21606 a_58313_15032.t83 a_58313_15032.t99 21562.5046763661
Riso21607 a_58313_15032.t84 a_58313_15032.t85 1697.93025760815
Riso21608 a_58313_15032.t84 a_58313_15032.t86 1920.07358680171
Riso21609 a_58313_15032.t84 a_58313_15032.t87 2119.61807564643
Riso21610 a_58313_15032.t84 a_58313_15032.t88 2272.4038853763
Riso21611 a_58313_15032.t84 a_58313_15032.t89 2355.77494168798
Riso21612 a_58313_15032.t84 a_58313_15032.t9 174730372.01026
Riso21613 a_58313_15032.t84 a_58313_15032.t90 79227.2723012347
Riso21614 a_58313_15032.t84 a_58313_15032.t91 76423.4130430518
Riso21615 a_58313_15032.t84 a_58313_15032.t92 71285.0601651834
Riso21616 a_58313_15032.t84 a_58313_15032.t93 64574.1620763435
Riso21617 a_58313_15032.t84 a_58313_15032.t94 57103.2404188992
Riso21618 a_58313_15032.t84 a_58313_15032.t95 49552.2104139438
Riso21619 a_58313_15032.t84 a_58313_15032.t96 42391.2724554272
Riso21620 a_58313_15032.t84 a_58313_15032.t97 35888.2163206393
Riso21621 a_58313_15032.t84 a_58313_15032.t98 30155.7409317826
Riso21622 a_58313_15032.t84 a_58313_15032.t99 25204.9468413196
Riso21623 a_58313_15032.t85 a_58313_15032.t86 1502.934337368
Riso21624 a_58313_15032.t85 a_58313_15032.t87 1659.12744693356
Riso21625 a_58313_15032.t85 a_58313_15032.t88 1778.72027987705
Riso21626 a_58313_15032.t85 a_58313_15032.t89 1843.97883253606
Riso21627 a_58313_15032.t85 a_58313_15032.t9 201356717.652658
Riso21628 a_58313_15032.t85 a_58313_15032.t90 91300.3464458556
Riso21629 a_58313_15032.t85 a_58313_15032.t91 88069.2201654481
Riso21630 a_58313_15032.t85 a_58313_15032.t92 82147.8576814954
Riso21631 a_58313_15032.t85 a_58313_15032.t93 74414.317163474
Riso21632 a_58313_15032.t85 a_58313_15032.t94 65804.9366334834
Riso21633 a_58313_15032.t85 a_58313_15032.t95 57103.2404188992
Riso21634 a_58313_15032.t85 a_58313_15032.t96 48851.0805565226
Riso21635 a_58313_15032.t85 a_58313_15032.t97 41357.0540575977
Riso21636 a_58313_15032.t85 a_58313_15032.t98 34751.0335069345
Riso21637 a_58313_15032.t85 a_58313_15032.t99 29045.8110183605
Riso21638 a_58313_15032.t86 a_58313_15032.t87 1323.12953290801
Riso21639 a_58313_15032.t86 a_58313_15032.t88 1418.50304353501
Riso21640 a_58313_15032.t86 a_58313_15032.t89 1470.54577145056
Riso21641 a_58313_15032.t86 a_58313_15032.t9 227700586.26235
Riso21642 a_58313_15032.t86 a_58313_15032.t90 103245.338193973
Riso21643 a_58313_15032.t86 a_58313_15032.t91 99591.4777372008
Riso21644 a_58313_15032.t86 a_58313_15032.t92 92895.4125411353
Riso21645 a_58313_15032.t86 a_58313_15032.t93 84150.0787357109
Riso21646 a_58313_15032.t86 a_58313_15032.t94 74414.317163474
Riso21647 a_58313_15032.t86 a_58313_15032.t95 64574.1620763435
Riso21648 a_58313_15032.t86 a_58313_15032.t96 55242.3570067201
Riso21649 a_58313_15032.t86 a_58313_15032.t97 46767.8732787209
Riso21650 a_58313_15032.t86 a_58313_15032.t98 39297.5749455811
Riso21651 a_58313_15032.t86 a_58313_15032.t99 32845.9277368381
Riso21652 a_58313_15032.t87 a_58313_15032.t88 1144.68801025121
Riso21653 a_58313_15032.t87 a_58313_15032.t89 1186.68487937122
Riso21654 a_58313_15032.t87 a_58313_15032.t9 251364469.463329
Riso21655 a_58313_15032.t87 a_58313_15032.t90 113975.155205743
Riso21656 a_58313_15032.t87 a_58313_15032.t91 109941.565699955
Riso21657 a_58313_15032.t87 a_58313_15032.t92 102549.608994312
Riso21658 a_58313_15032.t87 a_58313_15032.t93 92895.4125411353
Riso21659 a_58313_15032.t87 a_58313_15032.t94 82147.8576814954
Riso21660 a_58313_15032.t87 a_58313_15032.t95 71285.0601651834
Riso21661 a_58313_15032.t87 a_58313_15032.t96 60983.4431646963
Riso21662 a_58313_15032.t87 a_58313_15032.t97 51628.2450019222
Riso21663 a_58313_15032.t87 a_58313_15032.t98 43381.5926411813
Riso21664 a_58313_15032.t87 a_58313_15032.t99 36259.455169292
Riso21665 a_58313_15032.t88 a_58313_15032.t89 965.003270898412
Riso21666 a_58313_15032.t88 a_58313_15032.t9 269483263.809127
Riso21667 a_58313_15032.t88 a_58313_15032.t90 122190.685436058
Riso21668 a_58313_15032.t88 a_58313_15032.t91 117866.347683763
Riso21669 a_58313_15032.t88 a_58313_15032.t92 109941.565699955
Riso21670 a_58313_15032.t88 a_58313_15032.t93 99591.4777372008
Riso21671 a_58313_15032.t88 a_58313_15032.t94 88069.2201654481
Riso21672 a_58313_15032.t88 a_58313_15032.t95 76423.4130430517
Riso21673 a_58313_15032.t88 a_58313_15032.t96 65379.2373179385
Riso21674 a_58313_15032.t88 a_58313_15032.t97 55349.6999697681
Riso21675 a_58313_15032.t88 a_58313_15032.t98 46508.6143604278
Riso21676 a_58313_15032.t88 a_58313_15032.t99 38873.1006566821
Riso21677 a_58313_15032.t89 a_58313_15032.t9 279370196.544399
Riso21678 a_58313_15032.t89 a_58313_15032.t90 126673.676589969
Riso21679 a_58313_15032.t89 a_58313_15032.t91 122190.685436058
Riso21680 a_58313_15032.t89 a_58313_15032.t92 113975.155205743
Riso21681 a_58313_15032.t89 a_58313_15032.t93 103245.338193973
Riso21682 a_58313_15032.t89 a_58313_15032.t94 91300.3464458556
Riso21683 a_58313_15032.t89 a_58313_15032.t95 79227.2723012347
Riso21684 a_58313_15032.t89 a_58313_15032.t96 67777.9024985106
Riso21685 a_58313_15032.t89 a_58313_15032.t97 57380.3966178026
Riso21686 a_58313_15032.t89 a_58313_15032.t98 48214.944969953
Riso21687 a_58313_15032.t89 a_58313_15032.t99 40299.2958347111
Riso21688 a_58313_15032.t9 a_58313_15032.t90 236125253.334845
Riso21689 a_58313_15032.t9 a_58313_15032.t91 227768762.464676
Riso21690 a_58313_15032.t9 a_58313_15032.t92 212454656.099921
Riso21691 a_58313_15032.t9 a_58313_15032.t93 192453809.60723
Riso21692 a_58313_15032.t9 a_58313_15032.t94 170187824.45124
Riso21693 a_58313_15032.t9 a_58313_15032.t95 147683088.126608
Riso21694 a_58313_15032.t9 a_58313_15032.t96 126340963.874989
Riso21695 a_58313_15032.t9 a_58313_15032.t97 106959559.812015
Riso21696 a_58313_15032.t9 a_58313_15032.t98 89874758.5294083
Riso21697 a_58313_15032.t9 a_58313_15032.t99 75119643.5940551
Riso21698 a_58313_15032.t90 a_58313_15032.t91 965.886756736616
Riso21699 a_58313_15032.t90 a_58313_15032.t92 1188.11761925013
Riso21700 a_58313_15032.t90 a_58313_15032.t93 1472.97566004467
Riso21701 a_58313_15032.t90 a_58313_15032.t94 1848.3023699625
Riso21702 a_58313_15032.t90 a_58313_15032.t95 2363.91586767323
Riso21703 a_58313_15032.t90 a_58313_15032.t96 3119.75795040294
Riso21704 a_58313_15032.t90 a_58313_15032.t97 4351.43890045715
Riso21705 a_58313_15032.t90 a_58313_15032.t98 6779.10425783193
Riso21706 a_58313_15032.t90 a_58313_15032.t99 14158.8061658556
Riso21707 a_58313_15032.t91 a_58313_15032.t92 1146.07004535564
Riso21708 a_58313_15032.t91 a_58313_15032.t93 1420.84693818497
Riso21709 a_58313_15032.t91 a_58313_15032.t94 1782.89080698154
Riso21710 a_58313_15032.t91 a_58313_15032.t95 2280.25670336501
Riso21711 a_58313_15032.t91 a_58313_15032.t96 3009.34947667349
Riso21712 a_58313_15032.t91 a_58313_15032.t97 4197.44114320665
Riso21713 a_58313_15032.t91 a_58313_15032.t98 6539.19123693125
Riso21714 a_58313_15032.t91 a_58313_15032.t99 13657.7249270367
Riso21715 a_58313_15032.t92 a_58313_15032.t93 1325.31583504357
Riso21716 a_58313_15032.t92 a_58313_15032.t94 1663.01756730017
Riso21717 a_58313_15032.t92 a_58313_15032.t95 2126.94290687945
Riso21718 a_58313_15032.t92 a_58313_15032.t96 2807.01489191389
Riso21719 a_58313_15032.t92 a_58313_15032.t97 3915.22483122737
Riso21720 a_58313_15032.t92 a_58313_15032.t98 6099.52660048942
Riso21721 a_58313_15032.t92 a_58313_15032.t99 12739.4433770562
Riso21722 a_58313_15032.t93 a_58313_15032.t94 1506.45823511695
Riso21723 a_58313_15032.t93 a_58313_15032.t95 1926.70884583254
Riso21724 a_58313_15032.t93 a_58313_15032.t96 2542.75768528687
Riso21725 a_58313_15032.t93 a_58313_15032.t97 3546.63883612016
Riso21726 a_58313_15032.t93 a_58313_15032.t98 5525.30668244206
Riso21727 a_58313_15032.t93 a_58313_15032.t99 11540.1302809619
Riso21728 a_58313_15032.t94 a_58313_15032.t95 1703.79784890931
Riso21729 a_58313_15032.t94 a_58313_15032.t96 2248.57278454928
Riso21730 a_58313_15032.t94 a_58313_15032.t97 3136.30968836324
Riso21731 a_58313_15032.t94 a_58313_15032.t98 4886.05512995462
Riso21732 a_58313_15032.t94 a_58313_15032.t99 10204.9924104335
Riso21733 a_58313_15032.t95 a_58313_15032.t96 1951.2334314775
Riso21734 a_58313_15032.t95 a_58313_15032.t97 2721.58070997368
Riso21735 a_58313_15032.t95 a_58313_15032.t98 4239.94908375654
Riso21736 a_58313_15032.t95 a_58313_15032.t99 8855.53827567267
Riso21737 a_58313_15032.t96 a_58313_15032.t97 2328.27695116229
Riso21738 a_58313_15032.t96 a_58313_15032.t98 3627.22137529682
Riso21739 a_58313_15032.t96 a_58313_15032.t99 7575.79798454094
Riso21740 a_58313_15032.t97 a_58313_15032.t98 3070.78551360712
Riso21741 a_58313_15032.t97 a_58313_15032.t99 6413.62858726502
Riso21742 a_58313_15032.t98 a_58313_15032.t99 5389.17065095294
Riso21743 a_60857_41340.t0 a_60857_41340.t1 106.090046943421
Riso21744 a_60857_41340.t0 a_60857_41340.t10 1893.32989575219
Riso21745 a_60857_41340.t0 a_60857_41340.t11 1324.63227559121
Riso21746 a_60857_41340.t0 a_60857_41340.t12 1324.63227559121
Riso21747 a_60857_41340.t0 a_60857_41340.t13 1893.32989575219
Riso21748 a_60857_41340.t0 a_60857_41340.t14 2342.88774735587
Riso21749 a_60857_41340.t0 a_60857_41340.t15 126436.934115757
Riso21750 a_60857_41340.t0 a_60857_41340.t16 102175.969616461
Riso21751 a_60857_41340.t0 a_60857_41340.t17 71485.475113158
Riso21752 a_60857_41340.t0 a_60857_41340.t18 46485.1859244028
Riso21753 a_60857_41340.t0 a_60857_41340.t19 29288.1246831497
Riso21754 a_60857_41340.t0 a_60857_41340.t2 282.064278875974
Riso21755 a_60857_41340.t0 a_60857_41340.t20 18220.9190213156
Riso21756 a_60857_41340.t0 a_60857_41340.t21 11280.0925957879
Riso21757 a_60857_41340.t0 a_60857_41340.t22 6970.03657155024
Riso21758 a_60857_41340.t0 a_60857_41340.t23 4303.7217594606
Riso21759 a_60857_41340.t0 a_60857_41340.t24 2656.64701737329
Riso21760 a_60857_41340.t0 a_60857_41340.t25 1639.75135744704
Riso21761 a_60857_41340.t0 a_60857_41340.t26 1012.05659651437
Riso21762 a_60857_41340.t0 a_60857_41340.t27 1012.05659651437
Riso21763 a_60857_41340.t0 a_60857_41340.t28 1639.75135744704
Riso21764 a_60857_41340.t0 a_60857_41340.t29 2656.64701737329
Riso21765 a_60857_41340.t0 a_60857_41340.t3 0.781168572090774
Riso21766 a_60857_41340.t0 a_60857_41340.t30 4303.7217594606
Riso21767 a_60857_41340.t0 a_60857_41340.t31 6970.03657155024
Riso21768 a_60857_41340.t0 a_60857_41340.t32 11280.0925957879
Riso21769 a_60857_41340.t0 a_60857_41340.t33 18220.9190213156
Riso21770 a_60857_41340.t0 a_60857_41340.t34 29288.1246831497
Riso21771 a_60857_41340.t0 a_60857_41340.t35 46485.1859244028
Riso21772 a_60857_41340.t0 a_60857_41340.t36 71485.475113158
Riso21773 a_60857_41340.t0 a_60857_41340.t37 102175.969616461
Riso21774 a_60857_41340.t0 a_60857_41340.t38 126436.934115757
Riso21775 a_60857_41340.t0 a_60857_41340.t4 190.964995298425
Riso21776 a_60857_41340.t0 a_60857_41340.t5 106.090046943421
Riso21777 a_60857_41340.t0 a_60857_41340.t6 7.04283207588158
Riso21778 a_60857_41340.t0 a_60857_41340.t7 282.064278875974
Riso21779 a_60857_41340.t0 a_60857_41340.t8 190.964995298425
Riso21780 a_60857_41340.t0 a_60857_41340.t9 2342.88774735587
Riso21781 a_60857_41340.t1 a_60857_41340.t10 442.016844613638
Riso21782 a_60857_41340.t1 a_60857_41340.t11 309.248684048057
Riso21783 a_60857_41340.t1 a_60857_41340.t12 309.248684048057
Riso21784 a_60857_41340.t1 a_60857_41340.t13 442.016844613638
Riso21785 a_60857_41340.t1 a_60857_41340.t14 546.970631844784
Riso21786 a_60857_41340.t1 a_60857_41340.t15 43852.4296517573
Riso21787 a_60857_41340.t1 a_60857_41340.t16 35437.9402746651
Riso21788 a_60857_41340.t1 a_60857_41340.t17 24793.4813545241
Riso21789 a_60857_41340.t1 a_60857_41340.t18 16122.5701956079
Riso21790 a_60857_41340.t1 a_60857_41340.t19 10158.0715815511
Riso21791 a_60857_41340.t1 a_60857_41340.t2 30.2327321514312
Riso21792 a_60857_41340.t1 a_60857_41340.t20 6319.60570034918
Riso21793 a_60857_41340.t1 a_60857_41340.t21 3912.30197474753
Riso21794 a_60857_41340.t1 a_60857_41340.t22 2417.43475165452
Riso21795 a_60857_41340.t1 a_60857_41340.t23 1492.67029462053
Riso21796 a_60857_41340.t1 a_60857_41340.t24 921.411352257667
Riso21797 a_60857_41340.t1 a_60857_41340.t25 568.718955040358
Riso21798 a_60857_41340.t1 a_60857_41340.t26 351.01405307417
Riso21799 a_60857_41340.t1 a_60857_41340.t27 351.01405307417
Riso21800 a_60857_41340.t1 a_60857_41340.t28 568.718955040358
Riso21801 a_60857_41340.t1 a_60857_41340.t29 921.411352257667
Riso21802 a_60857_41340.t1 a_60857_41340.t3 106.090046943421
Riso21803 a_60857_41340.t1 a_60857_41340.t30 1492.67029462053
Riso21804 a_60857_41340.t1 a_60857_41340.t31 2417.43475165452
Riso21805 a_60857_41340.t1 a_60857_41340.t32 3912.30197474753
Riso21806 a_60857_41340.t1 a_60857_41340.t33 6319.60570034918
Riso21807 a_60857_41340.t1 a_60857_41340.t34 10158.0715815511
Riso21808 a_60857_41340.t1 a_60857_41340.t35 16122.5701956079
Riso21809 a_60857_41340.t1 a_60857_41340.t36 24793.4813545241
Riso21810 a_60857_41340.t1 a_60857_41340.t37 35437.9402746651
Riso21811 a_60857_41340.t1 a_60857_41340.t38 43852.4296517573
Riso21812 a_60857_41340.t1 a_60857_41340.t4 20.4683612407908
Riso21813 a_60857_41340.t1 a_60857_41340.t5 0.710318598693643
Riso21814 a_60857_41340.t1 a_60857_41340.t6 40.6241896450359
Riso21815 a_60857_41340.t1 a_60857_41340.t7 30.2327321514312
Riso21816 a_60857_41340.t1 a_60857_41340.t8 20.4683612407908
Riso21817 a_60857_41340.t1 a_60857_41340.t9 546.970631844784
Riso21818 a_60857_41340.t10 a_60857_41340.t11 441.287125549109
Riso21819 a_60857_41340.t10 a_60857_41340.t12 1830.14497431683
Riso21820 a_60857_41340.t10 a_60857_41340.t13 2615.87178365267
Riso21821 a_60857_41340.t10 a_60857_41340.t14 3236.9921186603
Riso21822 a_60857_41340.t10 a_60857_41340.t15 782609.853168611
Riso21823 a_60857_41340.t10 a_60857_41340.t16 632441.154462744
Riso21824 a_60857_41340.t10 a_60857_41340.t17 442475.433094396
Riso21825 a_60857_41340.t10 a_60857_41340.t18 287730.517868345
Riso21826 a_60857_41340.t10 a_60857_41340.t19 181285.437820556
Riso21827 a_60857_41340.t10 a_60857_41340.t2 1175.20131359232
Riso21828 a_60857_41340.t10 a_60857_41340.t20 112782.47815479
Riso21829 a_60857_41340.t10 a_60857_41340.t21 69820.671244968
Riso21830 a_60857_41340.t10 a_60857_41340.t22 43142.609681177
Riso21831 a_60857_41340.t10 a_60857_41340.t23 26638.8542066861
Riso21832 a_60857_41340.t10 a_60857_41340.t24 16443.9144837524
Riso21833 a_60857_41340.t10 a_60857_41340.t25 10149.6099858746
Riso21834 a_60857_41340.t10 a_60857_41340.t26 6264.3520260567
Riso21835 a_60857_41340.t10 a_60857_41340.t27 6264.3520260567
Riso21836 a_60857_41340.t10 a_60857_41340.t28 10149.6099858746
Riso21837 a_60857_41340.t10 a_60857_41340.t29 16443.9144837524
Riso21838 a_60857_41340.t10 a_60857_41340.t3 1893.32989575219
Riso21839 a_60857_41340.t10 a_60857_41340.t30 26638.8542066861
Riso21840 a_60857_41340.t10 a_60857_41340.t31 43142.609681177
Riso21841 a_60857_41340.t10 a_60857_41340.t32 69820.671244968
Riso21842 a_60857_41340.t10 a_60857_41340.t33 112782.47815479
Riso21843 a_60857_41340.t10 a_60857_41340.t34 181285.437820556
Riso21844 a_60857_41340.t10 a_60857_41340.t35 287730.517868345
Riso21845 a_60857_41340.t10 a_60857_41340.t36 442475.433094396
Riso21846 a_60857_41340.t10 a_60857_41340.t37 632441.154462744
Riso21847 a_60857_41340.t10 a_60857_41340.t38 782609.853168611
Riso21848 a_60857_41340.t10 a_60857_41340.t4 795.642447952583
Riso21849 a_60857_41340.t10 a_60857_41340.t5 442.016844613638
Riso21850 a_60857_41340.t10 a_60857_41340.t6 724.997254329357
Riso21851 a_60857_41340.t10 a_60857_41340.t7 1175.20131359232
Riso21852 a_60857_41340.t10 a_60857_41340.t8 795.642447952583
Riso21853 a_60857_41340.t10 a_60857_41340.t9 207.984396943464
Riso21854 a_60857_41340.t11 a_60857_41340.t12 1280.42614624642
Riso21855 a_60857_41340.t11 a_60857_41340.t13 1830.14497431683
Riso21856 a_60857_41340.t11 a_60857_41340.t14 2264.70001125098
Riso21857 a_60857_41340.t11 a_60857_41340.t15 547538.108931084
Riso21858 a_60857_41340.t11 a_60857_41340.t16 442475.433094396
Riso21859 a_60857_41340.t11 a_60857_41340.t17 309569.526762361
Riso21860 a_60857_41340.t11 a_60857_41340.t18 201305.188016145
Riso21861 a_60857_41340.t11 a_60857_41340.t19 126832.910931452
Riso21862 a_60857_41340.t11 a_60857_41340.t2 822.207262344588
Riso21863 a_60857_41340.t11 a_60857_41340.t20 78906.1172171706
Riso21864 a_60857_41340.t11 a_60857_41340.t21 48848.7055753083
Riso21865 a_60857_41340.t11 a_60857_41340.t22 30183.906864375
Riso21866 a_60857_41340.t11 a_60857_41340.t23 18637.3680287377
Riso21867 a_60857_41340.t11 a_60857_41340.t24 11504.6722238474
Riso21868 a_60857_41340.t11 a_60857_41340.t25 7100.981715926
Riso21869 a_60857_41340.t11 a_60857_41340.t26 4382.73483030978
Riso21870 a_60857_41340.t11 a_60857_41340.t27 4382.73483030978
Riso21871 a_60857_41340.t11 a_60857_41340.t28 7100.981715926
Riso21872 a_60857_41340.t11 a_60857_41340.t29 11504.6722238474
Riso21873 a_60857_41340.t11 a_60857_41340.t3 1324.63227559121
Riso21874 a_60857_41340.t11 a_60857_41340.t30 18637.3680287377
Riso21875 a_60857_41340.t11 a_60857_41340.t31 30183.906864375
Riso21876 a_60857_41340.t11 a_60857_41340.t32 48848.7055753083
Riso21877 a_60857_41340.t11 a_60857_41340.t33 78906.1172171706
Riso21878 a_60857_41340.t11 a_60857_41340.t34 126832.910931452
Riso21879 a_60857_41340.t11 a_60857_41340.t35 201305.188016145
Riso21880 a_60857_41340.t11 a_60857_41340.t36 309569.526762361
Riso21881 a_60857_41340.t11 a_60857_41340.t37 442475.433094396
Riso21882 a_60857_41340.t11 a_60857_41340.t38 547538.108931084
Riso21883 a_60857_41340.t11 a_60857_41340.t4 556.656116164944
Riso21884 a_60857_41340.t11 a_60857_41340.t5 309.248684048057
Riso21885 a_60857_41340.t11 a_60857_41340.t6 507.230549179145
Riso21886 a_60857_41340.t11 a_60857_41340.t7 822.207262344588
Riso21887 a_60857_41340.t11 a_60857_41340.t8 556.656116164944
Riso21888 a_60857_41340.t11 a_60857_41340.t9 546.0676461268
Riso21889 a_60857_41340.t12 a_60857_41340.t13 441.287125549109
Riso21890 a_60857_41340.t12 a_60857_41340.t14 546.0676461268
Riso21891 a_60857_41340.t12 a_60857_41340.t15 547538.108931084
Riso21892 a_60857_41340.t12 a_60857_41340.t16 442475.433094396
Riso21893 a_60857_41340.t12 a_60857_41340.t17 309569.526762361
Riso21894 a_60857_41340.t12 a_60857_41340.t18 201305.188016145
Riso21895 a_60857_41340.t12 a_60857_41340.t19 126832.910931452
Riso21896 a_60857_41340.t12 a_60857_41340.t2 822.207262344588
Riso21897 a_60857_41340.t12 a_60857_41340.t20 78906.1172171706
Riso21898 a_60857_41340.t12 a_60857_41340.t21 48848.7055753083
Riso21899 a_60857_41340.t12 a_60857_41340.t22 30183.906864375
Riso21900 a_60857_41340.t12 a_60857_41340.t23 18637.3680287377
Riso21901 a_60857_41340.t12 a_60857_41340.t24 11504.6722238474
Riso21902 a_60857_41340.t12 a_60857_41340.t25 7100.981715926
Riso21903 a_60857_41340.t12 a_60857_41340.t26 4382.73483030978
Riso21904 a_60857_41340.t12 a_60857_41340.t27 4382.73483030978
Riso21905 a_60857_41340.t12 a_60857_41340.t28 7100.981715926
Riso21906 a_60857_41340.t12 a_60857_41340.t29 11504.6722238474
Riso21907 a_60857_41340.t12 a_60857_41340.t3 1324.63227559121
Riso21908 a_60857_41340.t12 a_60857_41340.t30 18637.3680287377
Riso21909 a_60857_41340.t12 a_60857_41340.t31 30183.906864375
Riso21910 a_60857_41340.t12 a_60857_41340.t32 48848.7055753083
Riso21911 a_60857_41340.t12 a_60857_41340.t33 78906.1172171706
Riso21912 a_60857_41340.t12 a_60857_41340.t34 126832.910931452
Riso21913 a_60857_41340.t12 a_60857_41340.t35 201305.188016145
Riso21914 a_60857_41340.t12 a_60857_41340.t36 309569.526762361
Riso21915 a_60857_41340.t12 a_60857_41340.t37 442475.433094396
Riso21916 a_60857_41340.t12 a_60857_41340.t38 547538.108931084
Riso21917 a_60857_41340.t12 a_60857_41340.t4 556.656116164944
Riso21918 a_60857_41340.t12 a_60857_41340.t5 309.248684048057
Riso21919 a_60857_41340.t12 a_60857_41340.t6 507.230549179145
Riso21920 a_60857_41340.t12 a_60857_41340.t7 822.207262344588
Riso21921 a_60857_41340.t12 a_60857_41340.t8 556.656116164944
Riso21922 a_60857_41340.t12 a_60857_41340.t9 2264.70001125098
Riso21923 a_60857_41340.t13 a_60857_41340.t14 207.984396943464
Riso21924 a_60857_41340.t13 a_60857_41340.t15 782609.853168611
Riso21925 a_60857_41340.t13 a_60857_41340.t16 632441.154462744
Riso21926 a_60857_41340.t13 a_60857_41340.t17 442475.433094396
Riso21927 a_60857_41340.t13 a_60857_41340.t18 287730.517868345
Riso21928 a_60857_41340.t13 a_60857_41340.t19 181285.437820556
Riso21929 a_60857_41340.t13 a_60857_41340.t2 1175.20131359232
Riso21930 a_60857_41340.t13 a_60857_41340.t20 112782.47815479
Riso21931 a_60857_41340.t13 a_60857_41340.t21 69820.671244968
Riso21932 a_60857_41340.t13 a_60857_41340.t22 43142.609681177
Riso21933 a_60857_41340.t13 a_60857_41340.t23 26638.8542066861
Riso21934 a_60857_41340.t13 a_60857_41340.t24 16443.9144837524
Riso21935 a_60857_41340.t13 a_60857_41340.t25 10149.6099858746
Riso21936 a_60857_41340.t13 a_60857_41340.t26 6264.3520260567
Riso21937 a_60857_41340.t13 a_60857_41340.t27 6264.3520260567
Riso21938 a_60857_41340.t13 a_60857_41340.t28 10149.6099858746
Riso21939 a_60857_41340.t13 a_60857_41340.t29 16443.9144837524
Riso21940 a_60857_41340.t13 a_60857_41340.t3 1893.32989575219
Riso21941 a_60857_41340.t13 a_60857_41340.t30 26638.8542066861
Riso21942 a_60857_41340.t13 a_60857_41340.t31 43142.609681177
Riso21943 a_60857_41340.t13 a_60857_41340.t32 69820.671244968
Riso21944 a_60857_41340.t13 a_60857_41340.t33 112782.47815479
Riso21945 a_60857_41340.t13 a_60857_41340.t34 181285.437820556
Riso21946 a_60857_41340.t13 a_60857_41340.t35 287730.517868345
Riso21947 a_60857_41340.t13 a_60857_41340.t36 442475.433094396
Riso21948 a_60857_41340.t13 a_60857_41340.t37 632441.154462744
Riso21949 a_60857_41340.t13 a_60857_41340.t38 782609.853168611
Riso21950 a_60857_41340.t13 a_60857_41340.t4 795.642447952583
Riso21951 a_60857_41340.t13 a_60857_41340.t5 442.016844613638
Riso21952 a_60857_41340.t13 a_60857_41340.t6 724.997254329357
Riso21953 a_60857_41340.t13 a_60857_41340.t7 1175.20131359232
Riso21954 a_60857_41340.t13 a_60857_41340.t8 795.642447952583
Riso21955 a_60857_41340.t13 a_60857_41340.t9 3236.9921186603
Riso21956 a_60857_41340.t14 a_60857_41340.t15 968435.051948655
Riso21957 a_60857_41340.t14 a_60857_41340.t16 782609.853168611
Riso21958 a_60857_41340.t14 a_60857_41340.t17 547538.108931084
Riso21959 a_60857_41340.t14 a_60857_41340.t18 356050.103242196
Riso21960 a_60857_41340.t14 a_60857_41340.t19 224330.388484721
Riso21961 a_60857_41340.t14 a_60857_41340.t2 1454.24459016324
Riso21962 a_60857_41340.t14 a_60857_41340.t20 139561.883419324
Riso21963 a_60857_41340.t14 a_60857_41340.t21 86399.097980233
Riso21964 a_60857_41340.t14 a_60857_41340.t22 53386.5185553569
Riso21965 a_60857_41340.t14 a_60857_41340.t23 32964.0625569105
Riso21966 a_60857_41340.t14 a_60857_41340.t24 20348.4061858355
Riso21967 a_60857_41340.t14 a_60857_41340.t25 12559.5634071469
Riso21968 a_60857_41340.t14 a_60857_41340.t26 7751.7783033481
Riso21969 a_60857_41340.t14 a_60857_41340.t27 7751.7783033481
Riso21970 a_60857_41340.t14 a_60857_41340.t28 12559.5634071469
Riso21971 a_60857_41340.t14 a_60857_41340.t29 20348.4061858355
Riso21972 a_60857_41340.t14 a_60857_41340.t3 2342.88774735587
Riso21973 a_60857_41340.t14 a_60857_41340.t30 32964.0625569105
Riso21974 a_60857_41340.t14 a_60857_41340.t31 53386.5185553569
Riso21975 a_60857_41340.t14 a_60857_41340.t32 86399.097980233
Riso21976 a_60857_41340.t14 a_60857_41340.t33 139561.883419324
Riso21977 a_60857_41340.t14 a_60857_41340.t34 224330.388484721
Riso21978 a_60857_41340.t14 a_60857_41340.t35 356050.103242196
Riso21979 a_60857_41340.t14 a_60857_41340.t36 547538.108931084
Riso21980 a_60857_41340.t14 a_60857_41340.t37 782609.853168611
Riso21981 a_60857_41340.t14 a_60857_41340.t38 968435.051948655
Riso21982 a_60857_41340.t14 a_60857_41340.t4 984.562144593274
Riso21983 a_60857_41340.t14 a_60857_41340.t5 546.970631844784
Riso21984 a_60857_41340.t14 a_60857_41340.t6 897.142747202054
Riso21985 a_60857_41340.t14 a_60857_41340.t7 1454.24459016324
Riso21986 a_60857_41340.t14 a_60857_41340.t8 984.562144593274
Riso21987 a_60857_41340.t14 a_60857_41340.t9 4005.59310351129
Riso21988 a_60857_41340.t15 a_60857_41340.t16 161.113387905556
Riso21989 a_60857_41340.t15 a_60857_41340.t17 261.059013092136
Riso21990 a_60857_41340.t15 a_60857_41340.t18 423.041963352564
Riso21991 a_60857_41340.t15 a_60857_41340.t19 685.689028068245
Riso21992 a_60857_41340.t15 a_60857_41340.t2 116591.558803616
Riso21993 a_60857_41340.t15 a_60857_41340.t20 1112.06730692766
Riso21994 a_60857_41340.t15 a_60857_41340.t21 1806.42312134865
Riso21995 a_60857_41340.t15 a_60857_41340.t22 2946.56797188293
Riso21996 a_60857_41340.t15 a_60857_41340.t23 4860.06666352197
Riso21997 a_60857_41340.t15 a_60857_41340.t24 8264.80352139626
Riso21998 a_60857_41340.t15 a_60857_41340.t25 15393.8652672812
Riso21999 a_60857_41340.t15 a_60857_41340.t26 41065.4142011835
Riso22000 a_60857_41340.t15 a_60857_41340.t27 188842.166892923
Riso22001 a_60857_41340.t15 a_60857_41340.t28 305965.299344317
Riso22002 a_60857_41340.t15 a_60857_41340.t29 495710.399159745
Riso22003 a_60857_41340.t15 a_60857_41340.t3 126436.934115757
Riso22004 a_60857_41340.t15 a_60857_41340.t30 803042.187126559
Riso22005 a_60857_41340.t15 a_60857_41340.t31 1300556.5242376
Riso22006 a_60857_41340.t15 a_60857_41340.t32 2104780.6376421
Riso22007 a_60857_41340.t15 a_60857_41340.t33 3399886.76781166
Riso22008 a_60857_41340.t15 a_60857_41340.t34 5464944.3009856
Riso22009 a_60857_41340.t15 a_60857_41340.t35 8673786.88960502
Riso22010 a_60857_41340.t15 a_60857_41340.t36 13338653.261322
Riso22011 a_60857_41340.t15 a_60857_41340.t37 19065269.247997
Riso22012 a_60857_41340.t15 a_60857_41340.t38 23592183.1802202
Riso22013 a_60857_41340.t15 a_60857_41340.t4 78935.5765554372
Riso22014 a_60857_41340.t15 a_60857_41340.t5 43852.4296517573
Riso22015 a_60857_41340.t15 a_60857_41340.t6 48415.4559041217
Riso22016 a_60857_41340.t15 a_60857_41340.t7 116591.558803616
Riso22017 a_60857_41340.t15 a_60857_41340.t8 78935.5765554372
Riso22018 a_60857_41340.t15 a_60857_41340.t9 968435.051948655
Riso22019 a_60857_41340.t16 a_60857_41340.t17 210.966502599506
Riso22020 a_60857_41340.t16 a_60857_41340.t18 341.867849741012
Riso22021 a_60857_41340.t16 a_60857_41340.t19 554.11768553403
Riso22022 a_60857_41340.t16 a_60857_41340.t2 94219.7440420974
Riso22023 a_60857_41340.t16 a_60857_41340.t20 898.681672082238
Riso22024 a_60857_41340.t16 a_60857_41340.t21 1459.80314416997
Riso22025 a_60857_41340.t16 a_60857_41340.t22 2381.17478625597
Riso22026 a_60857_41340.t16 a_60857_41340.t23 3927.50763231384
Riso22027 a_60857_41340.t16 a_60857_41340.t24 6678.93696880591
Riso22028 a_60857_41340.t16 a_60857_41340.t25 12440.0604999612
Riso22029 a_60857_41340.t16 a_60857_41340.t26 33185.7027620272
Riso22030 a_60857_41340.t16 a_60857_41340.t27 152606.765117325
Riso22031 a_60857_41340.t16 a_60857_41340.t28 247256.083423178
Riso22032 a_60857_41340.t16 a_60857_41340.t29 400592.524940052
Riso22033 a_60857_41340.t16 a_60857_41340.t3 102175.969616461
Riso22034 a_60857_41340.t16 a_60857_41340.t30 648952.892494682
Riso22035 a_60857_41340.t16 a_60857_41340.t31 1051003.21226811
Riso22036 a_60857_41340.t16 a_60857_41340.t32 1700911.24073084
Riso22037 a_60857_41340.t16 a_60857_41340.t33 2747509.8911311
Riso22038 a_60857_41340.t16 a_60857_41340.t34 4416320.17383416
Riso22039 a_60857_41340.t16 a_60857_41340.t35 7009443.81394562
Riso22040 a_60857_41340.t16 a_60857_41340.t36 10779206.5655877
Riso22041 a_60857_41340.t16 a_60857_41340.t37 15406988.3538107
Riso22042 a_60857_41340.t16 a_60857_41340.t38 19065269.247997
Riso22043 a_60857_41340.t16 a_60857_41340.t4 63789.2648077195
Riso22044 a_60857_41340.t16 a_60857_41340.t5 35437.9402746651
Riso22045 a_60857_41340.t16 a_60857_41340.t6 39125.4041868622
Riso22046 a_60857_41340.t16 a_60857_41340.t7 94219.7440420974
Riso22047 a_60857_41340.t16 a_60857_41340.t8 63789.2648077195
Riso22048 a_60857_41340.t16 a_60857_41340.t9 782609.853168611
Riso22049 a_60857_41340.t17 a_60857_41340.t18 239.181343288302
Riso22050 a_60857_41340.t17 a_60857_41340.t19 387.677906729862
Riso22051 a_60857_41340.t17 a_60857_41340.t2 65919.0531117248
Riso22052 a_60857_41340.t17 a_60857_41340.t20 628.74555089063
Riso22053 a_60857_41340.t17 a_60857_41340.t21 1021.32352376385
Riso22054 a_60857_41340.t17 a_60857_41340.t22 1665.94368090594
Riso22055 a_60857_41340.t17 a_60857_41340.t23 2747.80606595073
Riso22056 a_60857_41340.t17 a_60857_41340.t24 4672.79130560859
Riso22057 a_60857_41340.t17 a_60857_41340.t25 8703.45188417852
Riso22058 a_60857_41340.t17 a_60857_41340.t26 23217.7461864317
Riso22059 a_60857_41340.t17 a_60857_41340.t27 106768.422661845
Riso22060 a_60857_41340.t17 a_60857_41340.t28 172988.019242412
Riso22061 a_60857_41340.t17 a_60857_41340.t29 280266.946128454
Riso22062 a_60857_41340.t17 a_60857_41340.t3 71485.475113158
Riso22063 a_60857_41340.t17 a_60857_41340.t30 454027.556774628
Riso22064 a_60857_41340.t17 a_60857_41340.t31 735314.42135037
Riso22065 a_60857_41340.t17 a_60857_41340.t32 1190010.22085105
Riso22066 a_60857_41340.t17 a_60857_41340.t33 1922243.07420681
Riso22067 a_60857_41340.t17 a_60857_41340.t34 3089794.46990732
Riso22068 a_60857_41340.t17 a_60857_41340.t35 4904024.1379629
Riso22069 a_60857_41340.t17 a_60857_41340.t36 7541466.99636283
Riso22070 a_60857_41340.t17 a_60857_41340.t37 10779206.5655877
Riso22071 a_60857_41340.t17 a_60857_41340.t38 13338653.261322
Riso22072 a_60857_41340.t17 a_60857_41340.t4 44628.9466986789
Riso22073 a_60857_41340.t17 a_60857_41340.t5 24793.4813545241
Riso22074 a_60857_41340.t17 a_60857_41340.t6 27373.3453941365
Riso22075 a_60857_41340.t17 a_60857_41340.t7 65919.0531117248
Riso22076 a_60857_41340.t17 a_60857_41340.t8 44628.9466986789
Riso22077 a_60857_41340.t17 a_60857_41340.t9 547538.108931084
Riso22078 a_60857_41340.t18 a_60857_41340.t19 252.097080485149
Riso22079 a_60857_41340.t18 a_60857_41340.t2 42865.4833028463
Riso22080 a_60857_41340.t18 a_60857_41340.t20 408.857236886606
Riso22081 a_60857_41340.t18 a_60857_41340.t21 664.140705730444
Riso22082 a_60857_41340.t18 a_60857_41340.t22 1083.32079522323
Riso22083 a_60857_41340.t18 a_60857_41340.t23 1786.82838237736
Riso22084 a_60857_41340.t18 a_60857_41340.t24 3038.59731341655
Riso22085 a_60857_41340.t18 a_60857_41340.t25 5659.63335040719
Riso22086 a_60857_41340.t18 a_60857_41340.t26 15097.9097014243
Riso22087 a_60857_41340.t18 a_60857_41340.t27 69428.7891412157
Riso22088 a_60857_41340.t18 a_60857_41340.t28 112489.70821623
Riso22089 a_60857_41340.t18 a_60857_41340.t29 182250.465267562
Riso22090 a_60857_41340.t18 a_60857_41340.t3 46485.1859244028
Riso22091 a_60857_41340.t18 a_60857_41340.t30 295242.57001946
Riso22092 a_60857_41340.t18 a_60857_41340.t31 478156.262307264
Riso22093 a_60857_41340.t18 a_60857_41340.t32 773833.373571836
Riso22094 a_60857_41340.t18 a_60857_41340.t33 1249985.77060519
Riso22095 a_60857_41340.t18 a_60857_41340.t34 2009214.74151881
Riso22096 a_60857_41340.t18 a_60857_41340.t35 3188962.14189117
Riso22097 a_60857_41340.t18 a_60857_41340.t36 4904024.1379629
Riso22098 a_60857_41340.t18 a_60857_41340.t37 7009443.81394562
Riso22099 a_60857_41340.t18 a_60857_41340.t38 8673786.88960502
Riso22100 a_60857_41340.t18 a_60857_41340.t4 29021.068708215
Riso22101 a_60857_41340.t18 a_60857_41340.t5 16122.5701956079
Riso22102 a_60857_41340.t18 a_60857_41340.t6 17800.1901505879
Riso22103 a_60857_41340.t18 a_60857_41340.t7 42865.4833028463
Riso22104 a_60857_41340.t18 a_60857_41340.t8 29021.068708215
Riso22105 a_60857_41340.t18 a_60857_41340.t9 356050.103242196
Riso22106 a_60857_41340.t19 a_60857_41340.t2 27007.5206673138
Riso22107 a_60857_41340.t19 a_60857_41340.t20 257.601674456395
Riso22108 a_60857_41340.t19 a_60857_41340.t21 418.443756000492
Riso22109 a_60857_41340.t19 a_60857_41340.t22 682.549373341125
Riso22110 a_60857_41340.t19 a_60857_41340.t23 1125.79634586309
Riso22111 a_60857_41340.t19 a_60857_41340.t24 1914.47695018273
Riso22112 a_60857_41340.t19 a_60857_41340.t25 3565.86822083939
Riso22113 a_60857_41340.t19 a_60857_41340.t26 9512.48129908241
Riso22114 a_60857_41340.t19 a_60857_41340.t27 43743.8076783203
Riso22115 a_60857_41340.t19 a_60857_41340.t28 70874.4632142805
Riso22116 a_60857_41340.t19 a_60857_41340.t29 114827.428226253
Riso22117 a_60857_41340.t19 a_60857_41340.t3 29288.1246831497
Riso22118 a_60857_41340.t19 a_60857_41340.t30 186018.427818402
Riso22119 a_60857_41340.t19 a_60857_41340.t31 301263.724130494
Riso22120 a_60857_41340.t19 a_60857_41340.t32 487555.935906381
Riso22121 a_60857_41340.t19 a_60857_41340.t33 787557.118975172
Riso22122 a_60857_41340.t19 a_60857_41340.t34 1265911.50911013
Riso22123 a_60857_41340.t19 a_60857_41340.t35 2009214.74151881
Riso22124 a_60857_41340.t19 a_60857_41340.t36 3089794.46990732
Riso22125 a_60857_41340.t19 a_60857_41340.t37 4416320.17383416
Riso22126 a_60857_41340.t19 a_60857_41340.t38 5464944.3009856
Riso22127 a_60857_41340.t19 a_60857_41340.t4 18284.8075545344
Riso22128 a_60857_41340.t19 a_60857_41340.t5 10158.0715815511
Riso22129 a_60857_41340.t19 a_60857_41340.t6 11215.0608445886
Riso22130 a_60857_41340.t19 a_60857_41340.t7 27007.5206673138
Riso22131 a_60857_41340.t19 a_60857_41340.t8 18284.8075545344
Riso22132 a_60857_41340.t19 a_60857_41340.t9 224330.388484721
Riso22133 a_60857_41340.t2 a_60857_41340.t20 16802.0947865178
Riso22134 a_60857_41340.t2 a_60857_41340.t21 10401.7357617037
Riso22135 a_60857_41340.t2 a_60857_41340.t22 6427.29463885334
Riso22136 a_60857_41340.t2 a_60857_41340.t23 3968.60009380773
Riso22137 a_60857_41340.t2 a_60857_41340.t24 2449.77956095448
Riso22138 a_60857_41340.t2 a_60857_41340.t25 1512.06740460872
Riso22139 a_60857_41340.t2 a_60857_41340.t26 933.249900516121
Riso22140 a_60857_41340.t2 a_60857_41340.t27 933.249900516121
Riso22141 a_60857_41340.t2 a_60857_41340.t28 1512.06740460872
Riso22142 a_60857_41340.t2 a_60857_41340.t29 2449.77956095448
Riso22143 a_60857_41340.t2 a_60857_41340.t3 282.064278875974
Riso22144 a_60857_41340.t2 a_60857_41340.t30 3968.60009380773
Riso22145 a_60857_41340.t2 a_60857_41340.t31 6427.29463885334
Riso22146 a_60857_41340.t2 a_60857_41340.t32 10401.7357617037
Riso22147 a_60857_41340.t2 a_60857_41340.t33 16802.0947865178
Riso22148 a_60857_41340.t2 a_60857_41340.t34 27007.5206673138
Riso22149 a_60857_41340.t2 a_60857_41340.t35 42865.4833028463
Riso22150 a_60857_41340.t2 a_60857_41340.t36 65919.0531117248
Riso22151 a_60857_41340.t2 a_60857_41340.t37 94219.7440420974
Riso22152 a_60857_41340.t2 a_60857_41340.t38 116591.558803616
Riso22153 a_60857_41340.t2 a_60857_41340.t4 18.048861959645
Riso22154 a_60857_41340.t2 a_60857_41340.t5 30.2327321514312
Riso22155 a_60857_41340.t2 a_60857_41340.t6 108.008555819179
Riso22156 a_60857_41340.t2 a_60857_41340.t7 0.702226834185146
Riso22157 a_60857_41340.t2 a_60857_41340.t8 18.048861959645
Riso22158 a_60857_41340.t2 a_60857_41340.t9 1454.24459016324
Riso22159 a_60857_41340.t20 a_60857_41340.t21 260.324956805673
Riso22160 a_60857_41340.t20 a_60857_41340.t22 424.632064846867
Riso22161 a_60857_41340.t20 a_60857_41340.t23 700.387760376686
Riso22162 a_60857_41340.t20 a_60857_41340.t24 1191.04687837949
Riso22163 a_60857_41340.t20 a_60857_41340.t25 2218.42117907871
Riso22164 a_60857_41340.t20 a_60857_41340.t26 5917.96686600693
Riso22165 a_60857_41340.t20 a_60857_41340.t27 27214.182745174
Riso22166 a_60857_41340.t20 a_60857_41340.t28 44092.8829987395
Riso22167 a_60857_41340.t20 a_60857_41340.t29 71437.188067566
Riso22168 a_60857_41340.t20 a_60857_41340.t3 18220.9190213156
Riso22169 a_60857_41340.t20 a_60857_41340.t30 115726.996740818
Riso22170 a_60857_41340.t20 a_60857_41340.t31 187424.151625517
Riso22171 a_60857_41340.t20 a_60857_41340.t32 303321.476626428
Riso22172 a_60857_41340.t20 a_60857_41340.t33 489960.167977678
Riso22173 a_60857_41340.t20 a_60857_41340.t34 787557.118975172
Riso22174 a_60857_41340.t20 a_60857_41340.t35 1249985.77060519
Riso22175 a_60857_41340.t20 a_60857_41340.t36 1922243.07420681
Riso22176 a_60857_41340.t20 a_60857_41340.t37 2747509.8911311
Riso22177 a_60857_41340.t20 a_60857_41340.t38 3399886.76781166
Riso22178 a_60857_41340.t20 a_60857_41340.t4 11375.4636521058
Riso22179 a_60857_41340.t20 a_60857_41340.t5 6319.60570034918
Riso22180 a_60857_41340.t20 a_60857_41340.t6 6977.18674988926
Riso22181 a_60857_41340.t20 a_60857_41340.t7 16802.0947865178
Riso22182 a_60857_41340.t20 a_60857_41340.t8 11375.4636521058
Riso22183 a_60857_41340.t20 a_60857_41340.t9 139561.883419324
Riso22184 a_60857_41340.t21 a_60857_41340.t22 262.878563096069
Riso22185 a_60857_41340.t21 a_60857_41340.t23 433.591674534269
Riso22186 a_60857_41340.t21 a_60857_41340.t24 737.345852771084
Riso22187 a_60857_41340.t21 a_60857_41340.t25 1373.3663097449
Riso22188 a_60857_41340.t21 a_60857_41340.t26 3663.65791699474
Riso22189 a_60857_41340.t21 a_60857_41340.t27 16847.5860589216
Riso22190 a_60857_41340.t21 a_60857_41340.t28 27296.7462540818
Riso22191 a_60857_41340.t21 a_60857_41340.t29 44224.8876273573
Riso22192 a_60857_41340.t21 a_60857_41340.t3 11280.0925957879
Riso22193 a_60857_41340.t21 a_60857_41340.t30 71643.5453964617
Riso22194 a_60857_41340.t21 a_60857_41340.t31 116029.371655161
Riso22195 a_60857_41340.t21 a_60857_41340.t32 187778.362805664
Riso22196 a_60857_41340.t21 a_60857_41340.t33 303321.476626428
Riso22197 a_60857_41340.t21 a_60857_41340.t34 487555.935906381
Riso22198 a_60857_41340.t21 a_60857_41340.t35 773833.373571836
Riso22199 a_60857_41340.t21 a_60857_41340.t36 1190010.22085105
Riso22200 a_60857_41340.t21 a_60857_41340.t37 1700911.24073084
Riso22201 a_60857_41340.t21 a_60857_41340.t38 2104780.6376421
Riso22202 a_60857_41340.t21 a_60857_41340.t4 7042.25089665691
Riso22203 a_60857_41340.t21 a_60857_41340.t5 3912.30197474753
Riso22204 a_60857_41340.t21 a_60857_41340.t6 4319.39313844625
Riso22205 a_60857_41340.t21 a_60857_41340.t7 10401.7357617037
Riso22206 a_60857_41340.t21 a_60857_41340.t8 7042.25089665691
Riso22207 a_60857_41340.t21 a_60857_41340.t9 86399.097980233
Riso22208 a_60857_41340.t22 a_60857_41340.t23 267.918884792848
Riso22209 a_60857_41340.t22 a_60857_41340.t24 455.610405327206
Riso22210 a_60857_41340.t22 a_60857_41340.t25 848.611243548776
Riso22211 a_60857_41340.t22 a_60857_41340.t26 2263.7961036453
Riso22212 a_60857_41340.t22 a_60857_41340.t27 10410.2240274936
Riso22213 a_60857_41340.t22 a_60857_41340.t28 16866.8225069643
Riso22214 a_60857_41340.t22 a_60857_41340.t29 27326.8221442156
Riso22215 a_60857_41340.t22 a_60857_41340.t3 6970.03657155024
Riso22216 a_60857_41340.t22 a_60857_41340.t30 44268.9745042804
Riso22217 a_60857_41340.t22 a_60857_41340.t31 71695.2415898123
Riso22218 a_60857_41340.t22 a_60857_41340.t32 116029.371655161
Riso22219 a_60857_41340.t22 a_60857_41340.t33 187424.151625517
Riso22220 a_60857_41340.t22 a_60857_41340.t34 301263.724130494
Riso22221 a_60857_41340.t22 a_60857_41340.t35 478156.262307264
Riso22222 a_60857_41340.t22 a_60857_41340.t36 735314.42135037
Riso22223 a_60857_41340.t22 a_60857_41340.t37 1051003.21226811
Riso22224 a_60857_41340.t22 a_60857_41340.t38 1300556.5242376
Riso22225 a_60857_41340.t22 a_60857_41340.t4 4351.44888030971
Riso22226 a_60857_41340.t22 a_60857_41340.t5 2417.43475165452
Riso22227 a_60857_41340.t22 a_60857_41340.t6 2668.97881256006
Riso22228 a_60857_41340.t22 a_60857_41340.t7 6427.29463885334
Riso22229 a_60857_41340.t22 a_60857_41340.t8 4351.44888030971
Riso22230 a_60857_41340.t22 a_60857_41340.t9 53386.5185553569
Riso22231 a_60857_41340.t23 a_60857_41340.t24 281.321395535697
Riso22232 a_60857_41340.t23 a_60857_41340.t25 523.983861016024
Riso22233 a_60857_41340.t23 a_60857_41340.t26 1397.8045093777
Riso22234 a_60857_41340.t23 a_60857_41340.t27 6427.9013758487
Riso22235 a_60857_41340.t23 a_60857_41340.t28 10414.5954316043
Riso22236 a_60857_41340.t23 a_60857_41340.t29 16873.231276721
Riso22237 a_60857_41340.t23 a_60857_41340.t3 4303.7217594606
Riso22238 a_60857_41340.t23 a_60857_41340.t30 27334.3399116058
Riso22239 a_60857_41340.t23 a_60857_41340.t31 44268.9745042804
Riso22240 a_60857_41340.t23 a_60857_41340.t32 71643.5453964617
Riso22241 a_60857_41340.t23 a_60857_41340.t33 115726.996740818
Riso22242 a_60857_41340.t23 a_60857_41340.t34 186018.427818402
Riso22243 a_60857_41340.t23 a_60857_41340.t35 295242.57001946
Riso22244 a_60857_41340.t23 a_60857_41340.t36 454027.556774628
Riso22245 a_60857_41340.t23 a_60857_41340.t37 648952.892494682
Riso22246 a_60857_41340.t23 a_60857_41340.t38 803042.187126559
Riso22247 a_60857_41340.t23 a_60857_41340.t4 2686.84748481945
Riso22248 a_60857_41340.t23 a_60857_41340.t5 1492.67029462053
Riso22249 a_60857_41340.t23 a_60857_41340.t6 1647.98879794102
Riso22250 a_60857_41340.t23 a_60857_41340.t7 3968.60009380773
Riso22251 a_60857_41340.t23 a_60857_41340.t8 2686.84748481945
Riso22252 a_60857_41340.t23 a_60857_41340.t9 32964.0625569105
Riso22253 a_60857_41340.t24 a_60857_41340.t25 323.450315638999
Riso22254 a_60857_41340.t24 a_60857_41340.t26 862.851594099015
Riso22255 a_60857_41340.t24 a_60857_41340.t27 3967.88314220815
Riso22256 a_60857_41340.t24 a_60857_41340.t28 6428.83193591696
Riso22257 a_60857_41340.t24 a_60857_41340.t29 10415.6871773162
Riso22258 a_60857_41340.t24 a_60857_41340.t3 2656.64701737329
Riso22259 a_60857_41340.t24 a_60857_41340.t30 16873.231276721
Riso22260 a_60857_41340.t24 a_60857_41340.t31 27326.8221442156
Riso22261 a_60857_41340.t24 a_60857_41340.t32 44224.8876273573
Riso22262 a_60857_41340.t24 a_60857_41340.t33 71437.188067566
Riso22263 a_60857_41340.t24 a_60857_41340.t34 114827.428226253
Riso22264 a_60857_41340.t24 a_60857_41340.t35 182250.465267562
Riso22265 a_60857_41340.t24 a_60857_41340.t36 280266.946128454
Riso22266 a_60857_41340.t24 a_60857_41340.t37 400592.524940052
Riso22267 a_60857_41340.t24 a_60857_41340.t38 495710.399159745
Riso22268 a_60857_41340.t24 a_60857_41340.t4 1658.56571489351
Riso22269 a_60857_41340.t24 a_60857_41340.t5 921.411352257667
Riso22270 a_60857_41340.t24 a_60857_41340.t6 1017.28800545492
Riso22271 a_60857_41340.t24 a_60857_41340.t7 2449.77956095448
Riso22272 a_60857_41340.t24 a_60857_41340.t8 1658.56571489351
Riso22273 a_60857_41340.t24 a_60857_41340.t9 20348.4061858355
Riso22274 a_60857_41340.t25 a_60857_41340.t26 532.574355360962
Riso22275 a_60857_41340.t25 a_60857_41340.t27 2449.08026022217
Riso22276 a_60857_41340.t25 a_60857_41340.t28 3968.04160461694
Riso22277 a_60857_41340.t25 a_60857_41340.t29 6428.83193591696
Riso22278 a_60857_41340.t25 a_60857_41340.t3 1639.75135744704
Riso22279 a_60857_41340.t25 a_60857_41340.t30 10414.5954316043
Riso22280 a_60857_41340.t25 a_60857_41340.t31 16866.8225069643
Riso22281 a_60857_41340.t25 a_60857_41340.t32 27296.7462540818
Riso22282 a_60857_41340.t25 a_60857_41340.t33 44092.8829987395
Riso22283 a_60857_41340.t25 a_60857_41340.t34 70874.4632142805
Riso22284 a_60857_41340.t25 a_60857_41340.t35 112489.70821623
Riso22285 a_60857_41340.t25 a_60857_41340.t36 172988.019242412
Riso22286 a_60857_41340.t25 a_60857_41340.t37 247256.083423178
Riso22287 a_60857_41340.t25 a_60857_41340.t38 305965.299344317
Riso22288 a_60857_41340.t25 a_60857_41340.t4 1023.70972305562
Riso22289 a_60857_41340.t25 a_60857_41340.t5 568.718955040358
Riso22290 a_60857_41340.t25 a_60857_41340.t6 627.89650900201
Riso22291 a_60857_41340.t25 a_60857_41340.t7 1512.06740460872
Riso22292 a_60857_41340.t25 a_60857_41340.t8 1023.70972305562
Riso22293 a_60857_41340.t25 a_60857_41340.t9 12559.5634071469
Riso22294 a_60857_41340.t26 a_60857_41340.t27 1511.5754114148
Riso22295 a_60857_41340.t26 a_60857_41340.t28 2449.08026022217
Riso22296 a_60857_41340.t26 a_60857_41340.t29 3967.88314220815
Riso22297 a_60857_41340.t26 a_60857_41340.t3 1012.05659651437
Riso22298 a_60857_41340.t26 a_60857_41340.t30 6427.9013758487
Riso22299 a_60857_41340.t26 a_60857_41340.t31 10410.2240274936
Riso22300 a_60857_41340.t26 a_60857_41340.t32 16847.5860589216
Riso22301 a_60857_41340.t26 a_60857_41340.t33 27214.182745174
Riso22302 a_60857_41340.t26 a_60857_41340.t34 43743.8076783203
Riso22303 a_60857_41340.t26 a_60857_41340.t35 69428.7891412157
Riso22304 a_60857_41340.t26 a_60857_41340.t36 106768.422661845
Riso22305 a_60857_41340.t26 a_60857_41340.t37 152606.765117325
Riso22306 a_60857_41340.t26 a_60857_41340.t38 188842.166892923
Riso22307 a_60857_41340.t26 a_60857_41340.t4 631.834926331387
Riso22308 a_60857_41340.t26 a_60857_41340.t5 351.01405307417
Riso22309 a_60857_41340.t26 a_60857_41340.t6 387.538513676367
Riso22310 a_60857_41340.t26 a_60857_41340.t7 933.249900516121
Riso22311 a_60857_41340.t26 a_60857_41340.t8 631.834926331387
Riso22312 a_60857_41340.t26 a_60857_41340.t9 7751.7783033481
Riso22313 a_60857_41340.t27 a_60857_41340.t28 532.574355360962
Riso22314 a_60857_41340.t27 a_60857_41340.t29 862.851594099015
Riso22315 a_60857_41340.t27 a_60857_41340.t3 1012.05659651437
Riso22316 a_60857_41340.t27 a_60857_41340.t30 1397.8045093777
Riso22317 a_60857_41340.t27 a_60857_41340.t31 2263.7961036453
Riso22318 a_60857_41340.t27 a_60857_41340.t32 3663.65791699474
Riso22319 a_60857_41340.t27 a_60857_41340.t33 5917.96686600693
Riso22320 a_60857_41340.t27 a_60857_41340.t34 9512.48129908241
Riso22321 a_60857_41340.t27 a_60857_41340.t35 15097.9097014243
Riso22322 a_60857_41340.t27 a_60857_41340.t36 23217.7461864317
Riso22323 a_60857_41340.t27 a_60857_41340.t37 33185.7027620272
Riso22324 a_60857_41340.t27 a_60857_41340.t38 41065.4142011835
Riso22325 a_60857_41340.t27 a_60857_41340.t4 631.834926331387
Riso22326 a_60857_41340.t27 a_60857_41340.t5 351.01405307417
Riso22327 a_60857_41340.t27 a_60857_41340.t6 387.538513676367
Riso22328 a_60857_41340.t27 a_60857_41340.t7 933.249900516121
Riso22329 a_60857_41340.t27 a_60857_41340.t8 631.834926331387
Riso22330 a_60857_41340.t27 a_60857_41340.t9 7751.7783033481
Riso22331 a_60857_41340.t28 a_60857_41340.t29 323.450315638999
Riso22332 a_60857_41340.t28 a_60857_41340.t3 1639.75135744704
Riso22333 a_60857_41340.t28 a_60857_41340.t30 523.983861016024
Riso22334 a_60857_41340.t28 a_60857_41340.t31 848.611243548776
Riso22335 a_60857_41340.t28 a_60857_41340.t32 1373.3663097449
Riso22336 a_60857_41340.t28 a_60857_41340.t33 2218.42117907871
Riso22337 a_60857_41340.t28 a_60857_41340.t34 3565.86822083939
Riso22338 a_60857_41340.t28 a_60857_41340.t35 5659.63335040719
Riso22339 a_60857_41340.t28 a_60857_41340.t36 8703.45188417852
Riso22340 a_60857_41340.t28 a_60857_41340.t37 12440.0604999612
Riso22341 a_60857_41340.t28 a_60857_41340.t38 15393.8652672812
Riso22342 a_60857_41340.t28 a_60857_41340.t4 1023.70972305562
Riso22343 a_60857_41340.t28 a_60857_41340.t5 568.718955040358
Riso22344 a_60857_41340.t28 a_60857_41340.t6 627.89650900201
Riso22345 a_60857_41340.t28 a_60857_41340.t7 1512.06740460872
Riso22346 a_60857_41340.t28 a_60857_41340.t8 1023.70972305562
Riso22347 a_60857_41340.t28 a_60857_41340.t9 12559.5634071469
Riso22348 a_60857_41340.t29 a_60857_41340.t3 2656.64701737329
Riso22349 a_60857_41340.t29 a_60857_41340.t30 281.321395535697
Riso22350 a_60857_41340.t29 a_60857_41340.t31 455.610405327206
Riso22351 a_60857_41340.t29 a_60857_41340.t32 737.345852771084
Riso22352 a_60857_41340.t29 a_60857_41340.t33 1191.04687837949
Riso22353 a_60857_41340.t29 a_60857_41340.t34 1914.47695018273
Riso22354 a_60857_41340.t29 a_60857_41340.t35 3038.59731341655
Riso22355 a_60857_41340.t29 a_60857_41340.t36 4672.79130560859
Riso22356 a_60857_41340.t29 a_60857_41340.t37 6678.93696880591
Riso22357 a_60857_41340.t29 a_60857_41340.t38 8264.80352139626
Riso22358 a_60857_41340.t29 a_60857_41340.t4 1658.56571489351
Riso22359 a_60857_41340.t29 a_60857_41340.t5 921.411352257667
Riso22360 a_60857_41340.t29 a_60857_41340.t6 1017.28800545492
Riso22361 a_60857_41340.t29 a_60857_41340.t7 2449.77956095448
Riso22362 a_60857_41340.t29 a_60857_41340.t8 1658.56571489351
Riso22363 a_60857_41340.t29 a_60857_41340.t9 20348.4061858355
Riso22364 a_60857_41340.t3 a_60857_41340.t30 4303.7217594606
Riso22365 a_60857_41340.t3 a_60857_41340.t31 6970.03657155024
Riso22366 a_60857_41340.t3 a_60857_41340.t32 11280.0925957879
Riso22367 a_60857_41340.t3 a_60857_41340.t33 18220.9190213156
Riso22368 a_60857_41340.t3 a_60857_41340.t34 29288.1246831497
Riso22369 a_60857_41340.t3 a_60857_41340.t35 46485.1859244028
Riso22370 a_60857_41340.t3 a_60857_41340.t36 71485.475113158
Riso22371 a_60857_41340.t3 a_60857_41340.t37 102175.969616461
Riso22372 a_60857_41340.t3 a_60857_41340.t38 126436.934115757
Riso22373 a_60857_41340.t3 a_60857_41340.t4 190.964995298425
Riso22374 a_60857_41340.t3 a_60857_41340.t5 106.090046943421
Riso22375 a_60857_41340.t3 a_60857_41340.t6 7.04283207588158
Riso22376 a_60857_41340.t3 a_60857_41340.t7 282.064278875974
Riso22377 a_60857_41340.t3 a_60857_41340.t8 190.964995298425
Riso22378 a_60857_41340.t3 a_60857_41340.t9 2342.88774735587
Riso22379 a_60857_41340.t30 a_60857_41340.t31 267.918884792848
Riso22380 a_60857_41340.t30 a_60857_41340.t32 433.591674534269
Riso22381 a_60857_41340.t30 a_60857_41340.t33 700.387760376686
Riso22382 a_60857_41340.t30 a_60857_41340.t34 1125.79634586309
Riso22383 a_60857_41340.t30 a_60857_41340.t35 1786.82838237736
Riso22384 a_60857_41340.t30 a_60857_41340.t36 2747.80606595073
Riso22385 a_60857_41340.t30 a_60857_41340.t37 3927.50763231384
Riso22386 a_60857_41340.t30 a_60857_41340.t38 4860.06666352197
Riso22387 a_60857_41340.t30 a_60857_41340.t4 2686.84748481945
Riso22388 a_60857_41340.t30 a_60857_41340.t5 1492.67029462053
Riso22389 a_60857_41340.t30 a_60857_41340.t6 1647.98879794102
Riso22390 a_60857_41340.t30 a_60857_41340.t7 3968.60009380773
Riso22391 a_60857_41340.t30 a_60857_41340.t8 2686.84748481945
Riso22392 a_60857_41340.t30 a_60857_41340.t9 32964.0625569105
Riso22393 a_60857_41340.t31 a_60857_41340.t32 262.878563096069
Riso22394 a_60857_41340.t31 a_60857_41340.t33 424.632064846867
Riso22395 a_60857_41340.t31 a_60857_41340.t34 682.549373341125
Riso22396 a_60857_41340.t31 a_60857_41340.t35 1083.32079522323
Riso22397 a_60857_41340.t31 a_60857_41340.t36 1665.94368090594
Riso22398 a_60857_41340.t31 a_60857_41340.t37 2381.17478625597
Riso22399 a_60857_41340.t31 a_60857_41340.t38 2946.56797188293
Riso22400 a_60857_41340.t31 a_60857_41340.t4 4351.44888030971
Riso22401 a_60857_41340.t31 a_60857_41340.t5 2417.43475165452
Riso22402 a_60857_41340.t31 a_60857_41340.t6 2668.97881256006
Riso22403 a_60857_41340.t31 a_60857_41340.t7 6427.29463885334
Riso22404 a_60857_41340.t31 a_60857_41340.t8 4351.44888030971
Riso22405 a_60857_41340.t31 a_60857_41340.t9 53386.5185553569
Riso22406 a_60857_41340.t32 a_60857_41340.t33 260.324956805673
Riso22407 a_60857_41340.t32 a_60857_41340.t34 418.443756000492
Riso22408 a_60857_41340.t32 a_60857_41340.t35 664.140705730444
Riso22409 a_60857_41340.t32 a_60857_41340.t36 1021.32352376385
Riso22410 a_60857_41340.t32 a_60857_41340.t37 1459.80314416997
Riso22411 a_60857_41340.t32 a_60857_41340.t38 1806.42312134865
Riso22412 a_60857_41340.t32 a_60857_41340.t4 7042.25089665691
Riso22413 a_60857_41340.t32 a_60857_41340.t5 3912.30197474753
Riso22414 a_60857_41340.t32 a_60857_41340.t6 4319.39313844625
Riso22415 a_60857_41340.t32 a_60857_41340.t7 10401.7357617037
Riso22416 a_60857_41340.t32 a_60857_41340.t8 7042.25089665691
Riso22417 a_60857_41340.t32 a_60857_41340.t9 86399.097980233
Riso22418 a_60857_41340.t33 a_60857_41340.t34 257.601674456395
Riso22419 a_60857_41340.t33 a_60857_41340.t35 408.857236886606
Riso22420 a_60857_41340.t33 a_60857_41340.t36 628.74555089063
Riso22421 a_60857_41340.t33 a_60857_41340.t37 898.681672082238
Riso22422 a_60857_41340.t33 a_60857_41340.t38 1112.06730692766
Riso22423 a_60857_41340.t33 a_60857_41340.t4 11375.4636521058
Riso22424 a_60857_41340.t33 a_60857_41340.t5 6319.60570034918
Riso22425 a_60857_41340.t33 a_60857_41340.t6 6977.18674988926
Riso22426 a_60857_41340.t33 a_60857_41340.t7 16802.0947865178
Riso22427 a_60857_41340.t33 a_60857_41340.t8 11375.4636521058
Riso22428 a_60857_41340.t33 a_60857_41340.t9 139561.883419324
Riso22429 a_60857_41340.t34 a_60857_41340.t35 252.097080485149
Riso22430 a_60857_41340.t34 a_60857_41340.t36 387.677906729862
Riso22431 a_60857_41340.t34 a_60857_41340.t37 554.11768553403
Riso22432 a_60857_41340.t34 a_60857_41340.t38 685.689028068245
Riso22433 a_60857_41340.t34 a_60857_41340.t4 18284.8075545344
Riso22434 a_60857_41340.t34 a_60857_41340.t5 10158.0715815511
Riso22435 a_60857_41340.t34 a_60857_41340.t6 11215.0608445886
Riso22436 a_60857_41340.t34 a_60857_41340.t7 27007.5206673138
Riso22437 a_60857_41340.t34 a_60857_41340.t8 18284.8075545344
Riso22438 a_60857_41340.t34 a_60857_41340.t9 224330.388484721
Riso22439 a_60857_41340.t35 a_60857_41340.t36 239.181343288302
Riso22440 a_60857_41340.t35 a_60857_41340.t37 341.867849741012
Riso22441 a_60857_41340.t35 a_60857_41340.t38 423.041963352564
Riso22442 a_60857_41340.t35 a_60857_41340.t4 29021.068708215
Riso22443 a_60857_41340.t35 a_60857_41340.t5 16122.5701956079
Riso22444 a_60857_41340.t35 a_60857_41340.t6 17800.1901505879
Riso22445 a_60857_41340.t35 a_60857_41340.t7 42865.4833028463
Riso22446 a_60857_41340.t35 a_60857_41340.t8 29021.068708215
Riso22447 a_60857_41340.t35 a_60857_41340.t9 356050.103242196
Riso22448 a_60857_41340.t36 a_60857_41340.t37 210.966502599506
Riso22449 a_60857_41340.t36 a_60857_41340.t38 261.059013092136
Riso22450 a_60857_41340.t36 a_60857_41340.t4 44628.9466986789
Riso22451 a_60857_41340.t36 a_60857_41340.t5 24793.4813545241
Riso22452 a_60857_41340.t36 a_60857_41340.t6 27373.3453941365
Riso22453 a_60857_41340.t36 a_60857_41340.t7 65919.0531117248
Riso22454 a_60857_41340.t36 a_60857_41340.t8 44628.9466986789
Riso22455 a_60857_41340.t36 a_60857_41340.t9 547538.108931084
Riso22456 a_60857_41340.t37 a_60857_41340.t38 161.113387905556
Riso22457 a_60857_41340.t37 a_60857_41340.t4 63789.2648077195
Riso22458 a_60857_41340.t37 a_60857_41340.t5 35437.9402746651
Riso22459 a_60857_41340.t37 a_60857_41340.t6 39125.4041868622
Riso22460 a_60857_41340.t37 a_60857_41340.t7 94219.7440420974
Riso22461 a_60857_41340.t37 a_60857_41340.t8 63789.2648077195
Riso22462 a_60857_41340.t37 a_60857_41340.t9 782609.853168611
Riso22463 a_60857_41340.t38 a_60857_41340.t4 78935.5765554372
Riso22464 a_60857_41340.t38 a_60857_41340.t5 43852.4296517573
Riso22465 a_60857_41340.t38 a_60857_41340.t6 48415.4559041217
Riso22466 a_60857_41340.t38 a_60857_41340.t7 116591.558803616
Riso22467 a_60857_41340.t38 a_60857_41340.t8 78935.5765554372
Riso22468 a_60857_41340.t38 a_60857_41340.t9 968435.051948655
Riso22469 a_60857_41340.t4 a_60857_41340.t5 20.4683612407908
Riso22470 a_60857_41340.t4 a_60857_41340.t6 73.1246559698849
Riso22471 a_60857_41340.t4 a_60857_41340.t7 18.048861959645
Riso22472 a_60857_41340.t4 a_60857_41340.t8 0.713412776880669
Riso22473 a_60857_41340.t4 a_60857_41340.t9 984.562144593274
Riso22474 a_60857_41340.t5 a_60857_41340.t6 40.6241896450359
Riso22475 a_60857_41340.t5 a_60857_41340.t7 30.2327321514312
Riso22476 a_60857_41340.t5 a_60857_41340.t8 20.4683612407908
Riso22477 a_60857_41340.t5 a_60857_41340.t9 546.970631844784
Riso22478 a_60857_41340.t6 a_60857_41340.t7 108.008555819179
Riso22479 a_60857_41340.t6 a_60857_41340.t8 73.1246559698849
Riso22480 a_60857_41340.t6 a_60857_41340.t9 897.142747202054
Riso22481 a_60857_41340.t7 a_60857_41340.t8 18.048861959645
Riso22482 a_60857_41340.t7 a_60857_41340.t9 1454.24459016324
Riso22483 a_60857_41340.t8 a_60857_41340.t9 984.562144593274
Riso22484 a_59881_41340.t0 a_59881_41340.t1 20.9161035012316
Riso22485 a_59881_41340.t0 a_59881_41340.t10 192.454014202928
Riso22486 a_59881_41340.t0 a_59881_41340.t11 213.637983211102
Riso22487 a_59881_41340.t0 a_59881_41340.t12 172.644712038927
Riso22488 a_59881_41340.t0 a_59881_41340.t13 213.637983211102
Riso22489 a_59881_41340.t0 a_59881_41340.t2 20.9161035012316
Riso22490 a_59881_41340.t0 a_59881_41340.t3 13.7670083961316
Riso22491 a_59881_41340.t0 a_59881_41340.t4 13.7670083961316
Riso22492 a_59881_41340.t0 a_59881_41340.t5 192.454014202928
Riso22493 a_59881_41340.t0 a_59881_41340.t6 155.525564150118
Riso22494 a_59881_41340.t0 a_59881_41340.t7 108.810504928372
Riso22495 a_59881_41340.t0 a_59881_41340.t8 108.810504928372
Riso22496 a_59881_41340.t0 a_59881_41340.t9 155.525564150118
Riso22497 a_59881_41340.t1 a_59881_41340.t10 1430.0965670794
Riso22498 a_59881_41340.t1 a_59881_41340.t11 390.855302249675
Riso22499 a_59881_41340.t1 a_59881_41340.t12 315.857227687385
Riso22500 a_59881_41340.t1 a_59881_41340.t13 390.855302249675
Riso22501 a_59881_41340.t1 a_59881_41340.t2 0.786033262221265
Riso22502 a_59881_41340.t1 a_59881_41340.t3 14.1707783311242
Riso22503 a_59881_41340.t1 a_59881_41340.t4 14.1707783311242
Riso22504 a_59881_41340.t1 a_59881_41340.t5 1430.0965670794
Riso22505 a_59881_41340.t1 a_59881_41340.t6 1155.68686008103
Riso22506 a_59881_41340.t1 a_59881_41340.t7 808.554345850967
Riso22507 a_59881_41340.t1 a_59881_41340.t8 808.554345850967
Riso22508 a_59881_41340.t1 a_59881_41340.t9 1155.68686008103
Riso22509 a_59881_41340.t10 a_59881_41340.t11 14607.0680119734
Riso22510 a_59881_41340.t10 a_59881_41340.t12 11804.235430215
Riso22511 a_59881_41340.t10 a_59881_41340.t13 14607.0680119734
Riso22512 a_59881_41340.t10 a_59881_41340.t2 1430.0965670794
Riso22513 a_59881_41340.t10 a_59881_41340.t3 941.29154816536
Riso22514 a_59881_41340.t10 a_59881_41340.t4 941.29154816536
Riso22515 a_59881_41340.t10 a_59881_41340.t5 2898.02188506314
Riso22516 a_59881_41340.t10 a_59881_41340.t6 2341.94381686727
Riso22517 a_59881_41340.t10 a_59881_41340.t7 1638.49647882479
Riso22518 a_59881_41340.t10 a_59881_41340.t8 499.992253946355
Riso22519 a_59881_41340.t10 a_59881_41340.t9 202.999523548765
Riso22520 a_59881_41340.t11 a_59881_41340.t12 841.27974874821
Riso22521 a_59881_41340.t11 a_59881_41340.t13 1041.0357011015
Riso22522 a_59881_41340.t11 a_59881_41340.t2 390.855302249675
Riso22523 a_59881_41340.t11 a_59881_41340.t3 257.261503196664
Riso22524 a_59881_41340.t11 a_59881_41340.t4 257.261503196664
Riso22525 a_59881_41340.t11 a_59881_41340.t5 14607.0680119734
Riso22526 a_59881_41340.t11 a_59881_41340.t6 11804.235430215
Riso22527 a_59881_41340.t11 a_59881_41340.t7 8258.60895907314
Riso22528 a_59881_41340.t11 a_59881_41340.t8 8258.60895907314
Riso22529 a_59881_41340.t11 a_59881_41340.t9 11804.235430215
Riso22530 a_59881_41340.t12 a_59881_41340.t13 841.27974874821
Riso22531 a_59881_41340.t12 a_59881_41340.t2 315.857227687385
Riso22532 a_59881_41340.t12 a_59881_41340.t3 207.897666278762
Riso22533 a_59881_41340.t12 a_59881_41340.t4 207.897666278762
Riso22534 a_59881_41340.t12 a_59881_41340.t5 11804.235430215
Riso22535 a_59881_41340.t12 a_59881_41340.t6 9539.21580824611
Riso22536 a_59881_41340.t12 a_59881_41340.t7 6673.93103113319
Riso22537 a_59881_41340.t12 a_59881_41340.t8 6673.93103113319
Riso22538 a_59881_41340.t12 a_59881_41340.t9 9539.21580824611
Riso22539 a_59881_41340.t13 a_59881_41340.t2 390.855302249675
Riso22540 a_59881_41340.t13 a_59881_41340.t3 257.261503196664
Riso22541 a_59881_41340.t13 a_59881_41340.t4 257.261503196664
Riso22542 a_59881_41340.t13 a_59881_41340.t5 14607.0680119734
Riso22543 a_59881_41340.t13 a_59881_41340.t6 11804.235430215
Riso22544 a_59881_41340.t13 a_59881_41340.t7 8258.60895907314
Riso22545 a_59881_41340.t13 a_59881_41340.t8 8258.60895907314
Riso22546 a_59881_41340.t13 a_59881_41340.t9 11804.235430215
Riso22547 a_59881_41340.t2 a_59881_41340.t3 14.1707783311242
Riso22548 a_59881_41340.t2 a_59881_41340.t4 14.1707783311242
Riso22549 a_59881_41340.t2 a_59881_41340.t5 1430.0965670794
Riso22550 a_59881_41340.t2 a_59881_41340.t6 1155.68686008103
Riso22551 a_59881_41340.t2 a_59881_41340.t7 808.554345850967
Riso22552 a_59881_41340.t2 a_59881_41340.t8 808.554345850967
Riso22553 a_59881_41340.t2 a_59881_41340.t9 1155.68686008103
Riso22554 a_59881_41340.t3 a_59881_41340.t4 0.796056800339275
Riso22555 a_59881_41340.t3 a_59881_41340.t5 941.29154816536
Riso22556 a_59881_41340.t3 a_59881_41340.t6 760.674697612663
Riso22557 a_59881_41340.t3 a_59881_41340.t7 532.1915942615
Riso22558 a_59881_41340.t3 a_59881_41340.t8 532.1915942615
Riso22559 a_59881_41340.t3 a_59881_41340.t9 760.674697612663
Riso22560 a_59881_41340.t4 a_59881_41340.t5 941.29154816536
Riso22561 a_59881_41340.t4 a_59881_41340.t6 760.674697612663
Riso22562 a_59881_41340.t4 a_59881_41340.t7 532.1915942615
Riso22563 a_59881_41340.t4 a_59881_41340.t8 532.1915942615
Riso22564 a_59881_41340.t4 a_59881_41340.t9 760.674697612663
Riso22565 a_59881_41340.t5 a_59881_41340.t6 202.999523548765
Riso22566 a_59881_41340.t5 a_59881_41340.t7 499.992253946355
Riso22567 a_59881_41340.t5 a_59881_41340.t8 1638.49647882479
Riso22568 a_59881_41340.t5 a_59881_41340.t9 2341.94381686727
Riso22569 a_59881_41340.t6 a_59881_41340.t7 404.052769113469
Riso22570 a_59881_41340.t6 a_59881_41340.t8 1324.09859198109
Riso22571 a_59881_41340.t6 a_59881_41340.t9 1892.56708847916
Riso22572 a_59881_41340.t7 a_59881_41340.t8 926.380413121941
Riso22573 a_59881_41340.t7 a_59881_41340.t9 1324.09859198109
Riso22574 a_59881_41340.t8 a_59881_41340.t9 404.052769113469
CREF0 DVDD_B VDD_B 332.939f
CREF1 DVDD_B DVSS_B 3005.48f
CREF2 DVDD_B a_15044_58302.n529 215.782f
CREF3 DVDD_B a_39525_61194# 60.7693f
CREF4 DVDD_B a_39525_62256.t8 4.09259f
CREF5 DVDD_B a_39525_63720.t33 12.1654f
CREF6 DVDD_B a_53266_42758# 0.0181209f
CREF7 DVDD_B a_53546_55631# 0.000938405f
CREF8 DVDD_B a_53826_42758# 0.0026028f
CREF9 DVDD_B a_54106_55631# 0.000938405f
CREF10 DVDD_B a_54386_42758# 0.00333437f
CREF11 DVDD_B a_54666_55631# 0.000901369f
CREF12 DVDD_B a_54946_42758# 0.0105044f
CREF13 DVDD_B a_55226_55631# 0.00148728f
CREF14 DVDD_B a_55506_42758# 0.041295f
CREF15 DVDD_B a_55786_55631# 0.00316009f
CREF16 DVDD_B a_55961_69935# 0.423916f
CREF17 DVDD_B a_56066_42758# 0.0675842f
CREF18 DVDD_B a_56241_57062# 0.472757f
CREF19 DVDD_B a_56346_55631# 1.46491f
CREF20 DVDD_B a_56521_69935# 0.397715f
CREF21 DVDD_B a_56801_57062# 0.472829f
CREF22 DVDD_B a_57081_69935# 0.369491f
CREF23 DVDD_B a_57361_57062# 0.490229f
CREF24 DVDD_B a_57641_69935# 0.366597f
CREF25 DVDD_B a_57921_57062# 0.494472f
CREF26 DVDD_B a_58201_69935# 0.368164f
CREF27 DVDD_B a_58313_15032.n376 13.2013f
CREF28 DVDD_B a_58481_57062# 0.536309f
CREF29 DVDD_B a_58761_69935# 0.455833f
CREF30 DVDD_B a_59881_41340.t1 0.0598902f
CREF31 DVDD_B a_60857_41340.t0 0.0596083f
CREF32 VDD_B DVSS_B 1248.42f
CREF33 VDD_B a_39525_61194# 0.595065f
CREF34 VDD_B a_53266_42758# 0.391318f
CREF35 VDD_B a_53546_55631# 0.400296f
CREF36 VDD_B a_53826_42758# 0.366846f
CREF37 VDD_B a_54106_55631# 0.365244f
CREF38 VDD_B a_54386_42758# 0.366597f
CREF39 VDD_B a_54666_55631# 0.365048f
CREF40 VDD_B a_54946_42758# 0.366597f
CREF41 VDD_B a_55226_55631# 0.365919f
CREF42 VDD_B a_55506_42758# 0.367532f
CREF43 VDD_B a_55786_55631# 0.368829f
CREF44 VDD_B a_56066_42758# 0.394209f
CREF45 VDD_B a_56241_57062# 0.0305375f
CREF46 VDD_B a_56346_55631# 60.8446f
CREF47 VDD_B a_56801_57062# 0.0333856f
CREF48 VDD_B a_57361_57062# 0.0262474f
CREF49 VDD_B a_57921_57062# 0.0171109f
CREF50 VDD_B a_58313_15032.n376 202.572f
CREF51 VDD_B a_58481_57062# 0.000129222f
CREF52 VDD_B a_59881_41340.t1 4.03304f
CREF53 VDD_B a_60857_41340.t0 12.1052f
CREF54 DVSS_B a_15044_58302.n529 288.147f
CREF55 DVSS_B a_39525_61194# 127.318f
CREF56 DVSS_B a_39525_62256.t8 5.70176f
CREF57 DVSS_B a_39525_63720.t33 12.1963f
CREF58 DVSS_B a_53266_42758# 0.121372f
CREF59 DVSS_B a_53546_55631# 0.140152f
CREF60 DVSS_B a_53826_42758# 0.139349f
CREF61 DVSS_B a_54106_55631# 0.133181f
CREF62 DVSS_B a_54386_42758# 0.137537f
CREF63 DVSS_B a_54666_55631# 0.138985f
CREF64 DVSS_B a_54946_42758# 0.127512f
CREF65 DVSS_B a_55226_55631# 0.139375f
CREF66 DVSS_B a_55506_42758# 0.0922295f
CREF67 DVSS_B a_55786_55631# 0.134738f
CREF68 DVSS_B a_55961_69935# 0.181306f
CREF69 DVSS_B a_56066_42758# 0.0798544f
CREF70 DVSS_B a_56241_57062# 0.0706575f
CREF71 DVSS_B a_56346_55631# 123.82f
CREF72 DVSS_B a_56521_69935# 0.175737f
CREF73 DVSS_B a_56801_57062# 0.0725794f
CREF74 DVSS_B a_57081_69935# 0.200836f
CREF75 DVSS_B a_57361_57062# 0.0731283f
CREF76 DVSS_B a_57641_69935# 0.207478f
CREF77 DVSS_B a_57921_57062# 0.0731283f
CREF78 DVSS_B a_58201_69935# 0.19789f
CREF79 DVSS_B a_58313_15032.n376 288.119f
CREF80 DVSS_B a_58481_57062# 0.0737389f
CREF81 DVSS_B a_58761_69935# 0.0828275f
CREF82 DVSS_B a_59881_41340.t1 5.70195f
CREF83 DVSS_B a_60857_41340.t0 12.1983f
CREF84 a_15044_58302.n529 a_39525_61194# 0.00285216f
CREF85 a_15044_58302.n529 a_39525_62256.t8 0.00994061f
CREF86 a_15044_58302.n529 a_39525_63720.t33 10.4319f
CREF87 a_39525_61194# a_39525_62256.t8 2.20025f
CREF88 a_39525_61194# a_39525_63720.t33 0.0193219f
CREF89 a_39525_61194# a_53546_55631# 0.000301398f
CREF90 a_39525_61194# a_54106_55631# 0.000301398f
CREF91 a_39525_61194# a_54666_55631# 0.000332824f
CREF92 a_39525_61194# a_55226_55631# 0.000301398f
CREF93 a_39525_61194# a_55786_55631# 0.000671088f
CREF94 a_39525_61194# a_56241_57062# 0.0372538f
CREF95 a_39525_61194# a_56801_57062# 0.000397346f
CREF96 a_39525_61194# a_57361_57062# 0.000119353f
CREF97 a_39525_62256.t8 a_39525_63720.t33 3.36501f
CREF98 a_53266_42758# a_53826_42758# 0.0346044f
CREF99 a_53546_55631# a_54106_55631# 0.0346044f
CREF100 a_53826_42758# a_54386_42758# 0.0346044f
CREF101 a_54106_55631# a_54666_55631# 0.0346044f
CREF102 a_54386_42758# a_54946_42758# 0.0346044f
CREF103 a_54666_55631# a_55226_55631# 0.0346044f
CREF104 a_54946_42758# a_55506_42758# 0.0346044f
CREF105 a_55226_55631# a_55786_55631# 0.0346044f
CREF106 a_55226_55631# a_56346_55631# 6.58034e-05f
CREF107 a_55506_42758# a_56066_42758# 0.0346044f
CREF108 a_55786_55631# a_56346_55631# 0.0348689f
CREF109 a_55961_69935# a_56521_69935# 0.0346044f
CREF110 a_56066_42758# a_56346_55631# 0.000192384f
CREF111 a_56241_57062# a_56346_55631# 0.000568104f
CREF112 a_56241_57062# a_56801_57062# 0.0346044f
CREF113 a_56346_55631# a_56801_57062# 0.000149042f
CREF114 a_56346_55631# a_58313_15032.n376 0.00285216f
CREF115 a_56346_55631# a_59881_41340.t1 2.2002f
CREF116 a_56346_55631# a_60857_41340.t0 0.0309197f
CREF117 a_56521_69935# a_57081_69935# 0.0346044f
CREF118 a_56801_57062# a_57361_57062# 0.0346044f
CREF119 a_57081_69935# a_57641_69935# 0.0346044f
CREF120 a_57361_57062# a_57921_57062# 0.0346044f
CREF121 a_57641_69935# a_58201_69935# 0.0346044f
CREF122 a_57921_57062# a_58481_57062# 0.0346044f
CREF123 a_58201_69935# a_58761_69935# 0.0346044f
CREF124 a_58313_15032.n376 a_59881_41340.t1 0.00994061f
CREF125 a_58313_15032.n376 a_60857_41340.t0 10.4279f
CREF126 a_59881_41340.t1 a_60857_41340.t0 3.36501f

Vsrc drive 0 PWL(0 0 100u 3.3)
Rsource drive feed 2
Vport0 feed VDD_A 0
Vport1 vb VDD_B 0
Vport2 0 VSS_A 0
Vport3 gb VSS_B 0
Vport4 feed DVDD_A 0
Vport5 db DVDD_B 0
Vport6 0 DVSS_A 0
Vport7 dg DVSS_B 0
Rstandby1 vb gb 100k
Rstandby2 db dg 100k
Iload1 vb gb PULSE(0 1m 151u 1n 1n 1u 10u)
Iload2 db dg PULSE(0 1m 151u 1n 1n 1u 10u)

.control
set klu
set num_threads=1
set numdgt=15
set wr_singlescale
set wr_vecnames
tran 50n 153u 0 50n uic
wrdata tran.dat v(vb,gb) v(db,dg) v(a_56346_55631#,DVSS_B.t335) i(Vport0)
quit
.endc
.end
