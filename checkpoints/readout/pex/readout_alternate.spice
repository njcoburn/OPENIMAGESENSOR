* RC from verified GDS; capacitive-only nodes eliminated at zero net charge.
.subckt readout_pex GND BIAS COL0 COL1 COL2 OUT SEL0 SEL1 SEL2
X0 n63 n67 n12 n49 nfet_03v3 ad=0.44p pd=2.88u as=0.44p ps=2.88u w=1u l=0.5u
X1 n64 n71 n21 n59 nfet_03v3 ad=0.44p pd=2.88u as=0.44p ps=2.88u w=1u l=0.5u
X2 n13 n9 n52 n50 nfet_03v3 ad=0.88p pd=4.88u as=0.88p ps=4.88u w=2u l=2u
X3 n20 n7 n58 n57 nfet_03v3 ad=0.88p pd=4.88u as=0.88p ps=4.88u w=2u l=2u
X4 n65 n69 n17 n51 nfet_03v3 ad=0.44p pd=2.88u as=0.44p ps=2.88u w=1u l=0.5u
X5 n6 n5 n54 n53 nfet_03v3 ad=0.88p pd=4.88u as=0.88p ps=4.88u w=2u l=2u
X6 n16 n8 n56 n55 nfet_03v3 ad=0.88p pd=4.88u as=0.88p ps=4.88u w=2u l=2u
R0 SEL2 n71 69.5395
R1 SEL1 n69 64.3645
R2 n61 n64 28.8522
R3 n62 n63 24.3972
R4 n61 n65 24.3972
R5 OUT n62 20.903
R6 n62 n61 4.4555
R7 SEL0 n67 59.1895
R8 n19 n21 35.8273
R9 n19 n20 21.1595
R10 COL2 n19 16.403
R11 n15 n17 35.1522
R12 n15 n16 20.4845
R13 COL1 n15 11.903
R14 n11 n12 34.4772
R15 n11 n13 19.8095
R16 COL0 n11 7.403
R17 n1 n7 27.2195
R18 n4 n5 22.7645
R19 n2 n9 22.7645
R20 n1 n8 22.7645
R21 n3 n6 19.1345
R22 n2 n1 4.4555
R23 n3 n2 3.7805
R24 BIAS n4 2.228
R25 n4 n3 0.6305
R26 n45 n44 675.735
R27 n48 n47 674.514
R28 n24 n42 644.861
R29 n39 n38 616.294
R30 n31 n23 615.207
R31 n30 n29 615.207
R32 n38 n50 87.7742
R33 n23 n50 87.7742
R34 n31 n55 87.7742
R35 n55 n30 87.7742
R36 n29 n57 87.7742
R37 n42 n57 87.7742
R38 n24 n49 58.1209
R39 n49 n48 58.1209
R40 n47 n51 58.1209
R41 n45 n51 58.1209
R42 n39 n53 43.8879
R43 n44 n59 29.0612
R44 n44 n43 23.4095
R45 n40 n39 19.0466
R46 n34 n58 18.4595
R47 n35 n56 18.4595
R48 n22 n52 18.4595
R49 n41 n54 18.4595
R50 n33 n32 17.9321
R51 n37 n36 17.9321
R52 n28 n27 17.9006
R53 n46 n43 17.6807
R54 n26 n25 17.6807
R55 n27 n26 4.4555
R56 n26 n43 4.4555
R57 n47 n46 2.54855
R58 n46 n45 2.54855
R59 n25 n24 2.54855
R60 n25 n48 2.54855
R61 n40 n22 2.4305
R62 n36 n35 2.4305
R63 n33 n34 2.4305
R64 n29 n28 2.22856
R65 n28 n42 2.22856
R66 n32 n31 2.22856
R67 n32 n30 2.22856
R68 n38 n37 2.22856
R69 n37 n23 2.22856
R70 n41 n40 1.9805
R71 n36 n22 1.9805
R72 n35 n33 1.9805
R73 n27 n34 1.9805
R74 GND n41 1.553
Cpex0 BIAS COL0 5.10106273448f
Cpex1 BIAS COL1 1.49412477123f
Cpex2 BIAS COL2 1.18526226857f
Cpex3 BIAS OUT 0.673591400254f
Cpex4 BIAS SEL0 0.229845691949f
Cpex5 BIAS SEL1 0.178077325548f
Cpex6 BIAS SEL2 0.173119970927f
Cpex7 BIAS GND 15.4801210087f
Cpex8 COL0 COL1 4.60970046887f
Cpex9 COL0 COL2 0.970797657239f
Cpex10 COL0 OUT 0.988026926671f
Cpex11 COL0 SEL0 0.793250497052f
Cpex12 COL0 SEL1 0.202294937048f
Cpex13 COL0 SEL2 0.184974460435f
Cpex14 COL0 GND 20.8739501039f
Cpex15 n11 GND 19.2174f
Cpex16 n12 GND 0.96887f
Cpex17 n13 GND 3.78322f
Cpex18 COL1 COL2 4.6653419922f
Cpex19 COL1 OUT 1.37448156158f
Cpex20 COL1 SEL0 0.428081929469f
Cpex21 COL1 SEL1 0.97250794934f
Cpex22 COL1 SEL2 0.217987842181f
Cpex23 COL1 GND 20.815727455f
Cpex24 n15 GND 18.558f
Cpex25 n16 GND 2.61157f
Cpex26 n17 GND 2.83237f
Cpex27 COL2 OUT 5.12181463581f
Cpex28 COL2 SEL0 0.800547643109f
Cpex29 COL2 SEL1 0.418184700066f
Cpex30 COL2 SEL2 1.11855333152f
Cpex31 COL2 GND 21.4728549105f
Cpex32 n19 GND 19.0444f
Cpex33 n20 GND 2.17971f
Cpex34 n21 GND 3.75451f
Cpex35 OUT SEL0 5.3739519775f
Cpex36 OUT SEL1 1.728973119f
Cpex37 OUT SEL2 1.41782966944f
Cpex38 OUT GND 25.4747149532f
Cpex39 n61 GND 9.90346f
Cpex40 n62 GND 13.611f
Cpex41 n63 GND 1.98639f
Cpex42 n64 GND 2.49416f
Cpex43 n65 GND 1.98639f
Cpex44 SEL0 SEL1 4.65826613542f
Cpex45 SEL0 SEL2 0.915572687315f
Cpex46 SEL0 GND 36.3428679064f
Cpex47 n67 GND 5.62808f
Cpex48 SEL1 SEL2 4.80890615113f
Cpex49 SEL1 GND 35.3085956161f
Cpex50 n69 GND 7.07001f
Cpex51 SEL2 GND 38.3337954061f
Cpex52 n71 GND 8.25977f
Cplacement n5 GND 42.58389f
.ends readout_pex
