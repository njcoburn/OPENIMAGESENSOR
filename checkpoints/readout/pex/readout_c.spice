* Same extracted capacitance with ideal wires.
.subckt readout_c GND BIAS COL0 COL1 COL2 OUT SEL0 SEL1 SEL2
X0 OUT SEL0 COL0 GND nfet_03v3 ad=0.44p pd=2.88u as=0.44p ps=2.88u w=1u l=0.5u
X1 OUT SEL2 COL2 GND nfet_03v3 ad=0.44p pd=2.88u as=0.44p ps=2.88u w=1u l=0.5u
X2 COL0 BIAS GND GND nfet_03v3 ad=0.88p pd=4.88u as=0.88p ps=4.88u w=2u l=2u
X3 COL2 BIAS GND GND nfet_03v3 ad=0.88p pd=4.88u as=0.88p ps=4.88u w=2u l=2u
X4 OUT SEL1 COL1 GND nfet_03v3 ad=0.44p pd=2.88u as=0.44p ps=2.88u w=1u l=0.5u
X5 BIAS BIAS GND GND nfet_03v3 ad=0.88p pd=4.88u as=0.88p ps=4.88u w=2u l=2u
X6 COL1 BIAS GND GND nfet_03v3 ad=0.88p pd=4.88u as=0.88p ps=4.88u w=2u l=2u
Cpex0 BIAS COL0 5.10106273448f
Cpex1 BIAS COL1 1.49412477123f
Cpex2 BIAS COL2 1.18526226857f
Cpex3 BIAS OUT 0.673591400254f
Cpex4 BIAS SEL0 0.229845691949f
Cpex5 BIAS SEL1 0.178077325548f
Cpex6 BIAS SEL2 0.173119970927f
Cpex7 BIAS GND 58.0640110087f
Cpex8 COL0 COL1 4.60970046887f
Cpex9 COL0 COL2 0.970797657239f
Cpex10 COL0 OUT 0.988026926671f
Cpex11 COL0 SEL0 0.793250497052f
Cpex12 COL0 SEL1 0.202294937048f
Cpex13 COL0 SEL2 0.184974460435f
Cpex14 COL0 GND 20.8739501039f
Cpex15 COL0 GND 19.2174f
Cpex16 COL0 GND 0.96887f
Cpex17 COL0 GND 3.78322f
Cpex18 COL1 COL2 4.6653419922f
Cpex19 COL1 OUT 1.37448156158f
Cpex20 COL1 SEL0 0.428081929469f
Cpex21 COL1 SEL1 0.97250794934f
Cpex22 COL1 SEL2 0.217987842181f
Cpex23 COL1 GND 20.815727455f
Cpex24 COL1 GND 18.558f
Cpex25 COL1 GND 2.61157f
Cpex26 COL1 GND 2.83237f
Cpex27 COL2 OUT 5.12181463581f
Cpex28 COL2 SEL0 0.800547643109f
Cpex29 COL2 SEL1 0.418184700066f
Cpex30 COL2 SEL2 1.11855333152f
Cpex31 COL2 GND 21.4728549105f
Cpex32 COL2 GND 19.0444f
Cpex33 COL2 GND 2.17971f
Cpex34 COL2 GND 3.75451f
Cpex35 OUT SEL0 5.3739519775f
Cpex36 OUT SEL1 1.728973119f
Cpex37 OUT SEL2 1.41782966944f
Cpex38 OUT GND 25.4747149532f
Cpex39 OUT GND 9.90346f
Cpex40 OUT GND 13.611f
Cpex41 OUT GND 1.98639f
Cpex42 OUT GND 2.49416f
Cpex43 OUT GND 1.98639f
Cpex44 SEL0 SEL1 4.65826613542f
Cpex45 SEL0 SEL2 0.915572687315f
Cpex46 SEL0 GND 36.3428679064f
Cpex47 SEL0 GND 5.62808f
Cpex48 SEL1 SEL2 4.80890615113f
Cpex49 SEL1 GND 35.3085956161f
Cpex50 SEL1 GND 7.07001f
Cpex51 SEL2 GND 38.3337954061f
Cpex52 SEL2 GND 8.25977f
.ends readout_c
