* Same extracted capacitance with ideal wires.
.subckt buffer_c GND VDD PREF IN BUF
X0 BUF PREF VDD VDD pfet_03v3 ad=8.8p pd=40.88u as=8.8p ps=40.88u w=20u l=2u
X1 GND IN BUF VDD pfet_03v3 ad=8.8p pd=40.88u as=8.8p ps=40.88u w=20u l=0.5u
X2 PREF PREF VDD VDD pfet_03v3 ad=8.8p pd=40.88u as=8.8p ps=40.88u w=20u l=2u
Cpex3 BUF GND 0.849086647478f
Cpex4 BUF IN 7.50448425823f
Cpex5 BUF IN 0.407264535508f
Cpex6 BUF PREF 3.5113647018f
Cpex7 BUF PREF 0.342236618981f
Cpex8 BUF PREF 0.498721357179f
Cpex9 BUF PREF 0.962645225409f
Cpex10 BUF PREF 0.265213078025f
Cpex11 BUF PREF 0.951442039199f
Cpex12 BUF VDD 12.5830986475f
Cpex13 BUF VDD 1.59541077901f
Cpex14 BUF VDD 0.166944922701f
Cpex15 BUF VDD 0.979795333305f
Cpex16 BUF VDD 0.13524303186f
Cpex17 BUF VDD 0.966483825226f
Cpex18 BUF VDD 0.104578580782f
Cpex19 BUF VDD 0.966483825226f
Cpex20 BUF VDD 0.104578580782f
Cpex21 BUF VDD 0.883394133346f
Cpex22 BUF GND 4.2821737231f
Cpex25 BUF GND 0.686788146242f
Cpex26 BUF IN 1.81987583646f
Cpex27 BUF IN 0.329418035489f
Cpex28 BUF PREF 0.831510178649f
Cpex29 BUF PREF 0.276819867353f
Cpex30 BUF PREF 0.403393360861f
Cpex31 BUF PREF 0.778640591994f
Cpex32 BUF PREF 0.214518976075f
Cpex33 BUF PREF 0.769578836623f
Cpex34 BUF VDD 3.98453802397f
Cpex35 BUF VDD 1.29045629756f
Cpex36 BUF VDD 0.135034268089f
Cpex37 BUF VDD 0.792512545869f
Cpex38 BUF VDD 0.109392028975f
Cpex39 BUF VDD 0.7817454634f
Cpex40 BUF VDD 0.0845889284032f
Cpex41 BUF VDD 0.7817454634f
Cpex42 BUF VDD 0.0845889284032f
Cpex43 BUF VDD 0.714537934431f
Cpex44 BUF GND 1.72980597424f
Cpex46 BUF GND 0.2271773843f
Cpex47 BUF IN 0.601982772328f
Cpex48 BUF IN 0.108965665836f
Cpex49 BUF PREF 0.275048875607f
Cpex50 BUF PREF 0.0915671211444f
Cpex51 BUF PREF 0.13343539644f
Cpex52 BUF PREF 0.257560550465f
Cpex53 BUF PREF 0.0709590870693f
Cpex54 BUF PREF 0.254563081895f
Cpex55 BUF VDD 1.31801477775f
Cpex56 BUF VDD 0.42686014288f
Cpex57 BUF VDD 0.0446669500385f
Cpex58 BUF VDD 0.262149147711f
Cpex59 BUF VDD 0.0361849503983f
Cpex60 BUF VDD 0.258587587068f
Cpex61 BUF VDD 0.0279805229611f
Cpex62 BUF VDD 0.258587587068f
Cpex63 BUF VDD 0.0279805229611f
Cpex64 BUF VDD 0.236356523937f
Cpex65 BUF GND 0.572189253301f
Cpex66 BUF GND 0.261809893271f
Cpex67 BUF IN 0.693753235428f
Cpex68 BUF IN 0.125577153864f
Cpex69 BUF PREF 0.316979249448f
Cpex70 BUF PREF 0.105526253363f
Cpex71 BUF PREF 0.153777221303f
Cpex72 BUF PREF 0.296824881737f
Cpex73 BUF PREF 0.0817765864743f
Cpex74 BUF PREF 0.293370458099f
Cpex75 BUF VDD 1.51894216651f
Cpex76 BUF VDD 0.491933687824f
Cpex77 BUF VDD 0.0514762922302f
Cpex78 BUF VDD 0.302112996832f
Cpex79 BUF VDD 0.0417012372555f
Cpex80 BUF VDD 0.29800848698f
Cpex81 BUF VDD 0.0322460695315f
Cpex82 BUF VDD 0.29800848698f
Cpex83 BUF VDD 0.0322460695315f
Cpex84 BUF VDD 0.272388365138f
Cpex85 BUF GND 0.659417784033f
Cpex86 GND IN 1.05844797914f
Cpex87 GND IN 0.191591012404f
Cpex88 GND PREF 0.483610063168f
Cpex89 GND PREF 0.160999681031f
Cpex90 GND PREF 0.23461539466f
Cpex91 GND PREF 0.452860873563f
Cpex92 GND PREF 0.1247652022f
Cpex93 GND PREF 0.447590515845f
Cpex94 GND VDD 2.31742525221f
Cpex95 GND VDD 0.750535191996f
Cpex96 GND VDD 0.0785365382132f
Cpex97 GND VDD 0.460928864385f
Cpex98 GND VDD 0.0636228965096f
Cpex99 GND VDD 0.45466668075f
Cpex100 GND VDD 0.049197301559f
Cpex101 GND VDD 0.45466668075f
Cpex102 GND VDD 0.049197301559f
Cpex103 GND VDD 0.415578479349f
Cpex106 IN PREF 5.45226479952f
Cpex107 IN PREF 0.426622723164f
Cpex108 IN PREF 0.621692278673f
Cpex109 IN PREF 1.20000696806f
Cpex110 IN PREF 0.330607302931f
Cpex111 IN PREF 1.18604138535f
Cpex112 IN VDD 7.76458602767f
Cpex113 IN VDD 1.98879504225f
Cpex114 IN VDD 0.208108932799f
Cpex115 IN VDD 1.22138581921f
Cpex116 IN VDD 0.16859023068f
Cpex117 IN VDD 1.20479206065f
Cpex118 IN VDD 0.130364772333f
Cpex119 IN VDD 1.20479206065f
Cpex120 IN VDD 0.130364772333f
Cpex121 IN VDD 1.10121474411f
Cpex122 IN GND 3.7134471376f
Cpex123 IN PREF 0.23196363802f
Cpex124 IN PREF 0.0772235207172f
Cpex125 IN PREF 0.112533308601f
Cpex126 IN PREF 0.217214784698f
Cpex127 IN PREF 0.0598436476093f
Cpex128 IN PREF 0.214686856842f
Cpex129 IN VDD 1.11155336351f
Cpex130 IN VDD 0.359994315372f
Cpex131 IN VDD 0.0376700621201f
Cpex132 IN VDD 0.221084597683f
Cpex133 IN VDD 0.0305167316806f
Cpex134 IN VDD 0.218080940381f
Cpex135 IN VDD 0.0235974929381f
Cpex136 IN VDD 0.218080940381f
Cpex137 IN VDD 0.0235974929381f
Cpex138 IN VDD 0.199332278822f
Cpex139 IN GND 0.482558238199f
Cpex145 PREF VDD 17.4913895877f
Cpex146 PREF VDD 0.908690190699f
Cpex147 PREF VDD 0.0950859901666f
Cpex148 PREF VDD 0.558057159936f
Cpex149 PREF VDD 0.0770297017098f
Cpex150 PREF VDD 0.550475390417f
Cpex151 PREF VDD 0.0595643026633f
Cpex152 PREF VDD 0.550475390417f
Cpex153 PREF VDD 0.0595643026633f
Cpex154 PREF VDD 0.503150407439f
Cpex155 PREF GND 2.42885829206f
Cpex160 PREF VDD 0.934071670321f
Cpex161 PREF VDD 0.302514033518f
Cpex162 PREF VDD 0.0316552843981f
Cpex163 PREF VDD 0.185784026408f
Cpex164 PREF VDD 0.0256441260217f
Cpex165 PREF VDD 0.18325996298f
Cpex166 PREF VDD 0.0198296819277f
Cpex167 PREF VDD 0.18325996298f
Cpex168 PREF VDD 0.0198296819277f
Cpex169 PREF VDD 0.167504899666f
Cpex170 PREF GND 0.405508178356f
Cpex174 PREF VDD 1.36116787418f
Cpex175 PREF VDD 0.44083596259f
Cpex176 PREF VDD 0.0461293897887f
Cpex177 PREF VDD 0.270732167903f
Cpex178 PREF VDD 0.0373696811617f
Cpex179 PREF VDD 0.267053998271f
Cpex180 PREF VDD 0.028896632724f
Cpex181 PREF VDD 0.267053998271f
Cpex182 PREF VDD 0.028896632724f
Cpex183 PREF VDD 0.244095068331f
Cpex184 PREF GND 0.590923290614f
Cpex187 PREF VDD 2.62736242632f
Cpex188 PREF VDD 0.850913297508f
Cpex189 PREF VDD 0.0890401748227f
Cpex190 PREF VDD 0.522574429678f
Cpex191 PREF VDD 0.0721319522967f
Cpex192 PREF VDD 0.515474728847f
Cpex193 PREF VDD 0.0557770488906f
Cpex194 PREF VDD 0.515474728847f
Cpex195 PREF VDD 0.0557770488906f
Cpex196 PREF VDD 0.471158791762f
Cpex197 PREF GND 1.14061584912f
Cpex199 PREF VDD 0.723850134796f
Cpex200 PREF VDD 0.234430430659f
Cpex201 PREF VDD 0.0245309675977f
Cpex202 PREF VDD 0.143971599644f
Cpex203 PREF VDD 0.0198726764415f
Cpex204 PREF VDD 0.142015600216f
Cpex205 PREF VDD 0.0153668271851f
Cpex206 PREF VDD 0.142015600216f
Cpex207 PREF VDD 0.0153668271851f
Cpex208 PREF VDD 0.129806360748f
Cpex209 PREF GND 0.314244783232f
Cpex210 PREF VDD 2.59678539781f
Cpex211 PREF VDD 0.841010438315f
Cpex212 PREF VDD 0.0880039325682f
Cpex213 PREF VDD 0.51649275131f
Cpex214 PREF VDD 0.0712924865497f
Cpex215 PREF VDD 0.509475676214f
Cpex216 PREF VDD 0.0551279201686f
Cpex217 PREF VDD 0.509475676214f
Cpex218 PREF VDD 0.0551279201686f
Cpex219 PREF VDD 0.465675484373f
Cpex220 PREF GND 1.12734145538f
Cpex230 VDD GND 14.372865756f
Cpex239 VDD GND 1.89036497804f
Cpex247 VDD GND 0.197809140622f
Cpex254 VDD GND 1.1609366115f
Cpex260 VDD GND 0.160246310428f
Cpex265 VDD GND 1.14516411641f
Cpex269 VDD GND 0.123912718382f
Cpex272 VDD GND 1.14516411641f
Cpex274 VDD GND 0.123912718382f
Cpex275 VDD GND 1.0467130807f
.ends buffer_c
