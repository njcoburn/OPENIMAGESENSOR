* RC from verified GDS; capacitive-only nodes eliminated at zero net charge.
.subckt buffer_pex GND VDD PREF IN BUF
X0 n2 n12 n21 n20 pfet_03v3 ad=8.8p pd=40.88u as=8.8p ps=40.88u w=20u l=2u
X1 n4 n6 n3 n22 pfet_03v3 ad=8.8p pd=40.88u as=8.8p ps=40.88u w=20u l=0.5u
X2 n11 n10 n19 n18 pfet_03v3 ad=8.8p pd=40.88u as=8.8p ps=40.88u w=20u l=2u
R0 GND n4 42.3016
R1 IN n6 198.228
R2 n1 n3 28.7791
R3 n1 n2 21.4553
R4 BUF n1 14.378
R5 n8 n12 64.5425
R6 n9 n10 56.4875
R7 n8 n11 20.1053
R8 PREF n9 4.478
R9 n9 n8 0.8555
R10 n16 n18 74.0647
R11 n14 n20 74.0647
R12 n14 n22 66.3386
R13 n17 n19 19.4303
R14 n15 n21 19.4303
R15 n16 n15 6.7055
R16 VDD n17 3.578
R17 n15 n14 2.2055
R18 n17 n16 2.2055
Cpex0 BUF n1 1.45990384342f
Cpex1 BUF n2 0.482910397174f
Cpex2 BUF n3 0.556528634808f
Cpex3 BUF n4 0.849086647478f
Cpex4 BUF IN 7.50448425823f
Cpex5 BUF n6 0.407264535508f
Cpex6 BUF PREF 3.5113647018f
Cpex7 BUF n8 0.342236618981f
Cpex8 BUF n9 0.498721357179f
Cpex9 BUF n10 0.962645225409f
Cpex10 BUF n11 0.265213078025f
Cpex11 BUF n12 0.951442039199f
Cpex12 BUF VDD 12.5830986475f
Cpex13 BUF n14 1.59541077901f
Cpex14 BUF n15 0.166944922701f
Cpex15 BUF n16 0.979795333305f
Cpex16 BUF n17 0.13524303186f
Cpex17 BUF n18 0.966483825226f
Cpex18 BUF n19 0.104578580782f
Cpex19 BUF n20 0.966483825226f
Cpex20 BUF n21 0.104578580782f
Cpex21 BUF n22 0.883394133346f
Cpex22 BUF GND 4.2821737231f
Cpex23 n1 n2 0.390604583715f
Cpex24 n1 n3 0.450151077708f
Cpex25 n1 n4 0.686788146242f
Cpex26 n1 IN 1.81987583646f
Cpex27 n1 n6 0.329418035489f
Cpex28 n1 PREF 0.831510178649f
Cpex29 n1 n8 0.276819867353f
Cpex30 n1 n9 0.403393360861f
Cpex31 n1 n10 0.778640591994f
Cpex32 n1 n11 0.214518976075f
Cpex33 n1 n12 0.769578836623f
Cpex34 n1 VDD 3.98453802397f
Cpex35 n1 n14 1.29045629756f
Cpex36 n1 n15 0.135034268089f
Cpex37 n1 n16 0.792512545869f
Cpex38 n1 n17 0.109392028975f
Cpex39 n1 n18 0.7817454634f
Cpex40 n1 n19 0.0845889284032f
Cpex41 n1 n20 0.7817454634f
Cpex42 n1 n21 0.0845889284032f
Cpex43 n1 n22 0.714537934431f
Cpex44 n1 GND 1.72980597424f
Cpex45 n2 n3 0.148902023037f
Cpex46 n2 n4 0.2271773843f
Cpex47 n2 IN 0.601982772328f
Cpex48 n2 n6 0.108965665836f
Cpex49 n2 PREF 0.275048875607f
Cpex50 n2 n8 0.0915671211444f
Cpex51 n2 n9 0.13343539644f
Cpex52 n2 n10 0.257560550465f
Cpex53 n2 n11 0.0709590870693f
Cpex54 n2 n12 0.254563081895f
Cpex55 n2 VDD 1.31801477775f
Cpex56 n2 n14 0.42686014288f
Cpex57 n2 n15 0.0446669500385f
Cpex58 n2 n16 0.262149147711f
Cpex59 n2 n17 0.0361849503983f
Cpex60 n2 n18 0.258587587068f
Cpex61 n2 n19 0.0279805229611f
Cpex62 n2 n20 0.258587587068f
Cpex63 n2 n21 0.0279805229611f
Cpex64 n2 n22 0.236356523937f
Cpex65 n2 GND 0.572189253301f
Cpex66 n3 n4 0.261809893271f
Cpex67 n3 IN 0.693753235428f
Cpex68 n3 n6 0.125577153864f
Cpex69 n3 PREF 0.316979249448f
Cpex70 n3 n8 0.105526253363f
Cpex71 n3 n9 0.153777221303f
Cpex72 n3 n10 0.296824881737f
Cpex73 n3 n11 0.0817765864743f
Cpex74 n3 n12 0.293370458099f
Cpex75 n3 VDD 1.51894216651f
Cpex76 n3 n14 0.491933687824f
Cpex77 n3 n15 0.0514762922302f
Cpex78 n3 n16 0.302112996832f
Cpex79 n3 n17 0.0417012372555f
Cpex80 n3 n18 0.29800848698f
Cpex81 n3 n19 0.0322460695315f
Cpex82 n3 n20 0.29800848698f
Cpex83 n3 n21 0.0322460695315f
Cpex84 n3 n22 0.272388365138f
Cpex85 n3 GND 0.659417784033f
Cpex86 n4 IN 1.05844797914f
Cpex87 n4 n6 0.191591012404f
Cpex88 n4 PREF 0.483610063168f
Cpex89 n4 n8 0.160999681031f
Cpex90 n4 n9 0.23461539466f
Cpex91 n4 n10 0.452860873563f
Cpex92 n4 n11 0.1247652022f
Cpex93 n4 n12 0.447590515845f
Cpex94 n4 VDD 2.31742525221f
Cpex95 n4 n14 0.750535191996f
Cpex96 n4 n15 0.0785365382132f
Cpex97 n4 n16 0.460928864385f
Cpex98 n4 n17 0.0636228965096f
Cpex99 n4 n18 0.45466668075f
Cpex100 n4 n19 0.049197301559f
Cpex101 n4 n20 0.45466668075f
Cpex102 n4 n21 0.049197301559f
Cpex103 n4 n22 0.415578479349f
Cpex104 n4 GND 1.0060629418f
Cpex105 IN n6 0.507684729074f
Cpex106 IN PREF 5.45226479952f
Cpex107 IN n8 0.426622723164f
Cpex108 IN n9 0.621692278673f
Cpex109 IN n10 1.20000696806f
Cpex110 IN n11 0.330607302931f
Cpex111 IN n12 1.18604138535f
Cpex112 IN VDD 7.76458602767f
Cpex113 IN n14 1.98879504225f
Cpex114 IN n15 0.208108932799f
Cpex115 IN n16 1.22138581921f
Cpex116 IN n17 0.16859023068f
Cpex117 IN n18 1.20479206065f
Cpex118 IN n19 0.130364772333f
Cpex119 IN n20 1.20479206065f
Cpex120 IN n21 0.130364772333f
Cpex121 IN n22 1.10121474411f
Cpex122 IN GND 3.7134471376f
Cpex123 n6 PREF 0.23196363802f
Cpex124 n6 n8 0.0772235207172f
Cpex125 n6 n9 0.112533308601f
Cpex126 n6 n10 0.217214784698f
Cpex127 n6 n11 0.0598436476093f
Cpex128 n6 n12 0.214686856842f
Cpex129 n6 VDD 1.11155336351f
Cpex130 n6 n14 0.359994315372f
Cpex131 n6 n15 0.0376700621201f
Cpex132 n6 n16 0.221084597683f
Cpex133 n6 n17 0.0305167316806f
Cpex134 n6 n18 0.218080940381f
Cpex135 n6 n19 0.0235974929381f
Cpex136 n6 n20 0.218080940381f
Cpex137 n6 n21 0.0235974929381f
Cpex138 n6 n22 0.199332278822f
Cpex139 n6 GND 0.482558238199f
Cpex140 PREF n8 0.194926010691f
Cpex141 PREF n9 0.284054245541f
Cpex142 PREF n10 0.54828905819f
Cpex143 PREF n11 0.151056095155f
Cpex144 PREF n12 0.541908115084f
Cpex145 PREF VDD 17.4913895877f
Cpex146 PREF n14 0.908690190699f
Cpex147 PREF n15 0.0950859901666f
Cpex148 PREF n16 0.558057159936f
Cpex149 PREF n17 0.0770297017098f
Cpex150 PREF n18 0.550475390417f
Cpex151 PREF n19 0.0595643026633f
Cpex152 PREF n20 0.550475390417f
Cpex153 PREF n21 0.0595643026633f
Cpex154 PREF n22 0.503150407439f
Cpex155 PREF GND 2.42885829206f
Cpex156 n8 n9 0.0945651184927f
Cpex157 n8 n10 0.182532106349f
Cpex158 n8 n11 0.0502884141379f
Cpex159 n8 n12 0.180407812661f
Cpex160 n8 VDD 0.934071670321f
Cpex161 n8 n14 0.302514033518f
Cpex162 n8 n15 0.0316552843981f
Cpex163 n8 n16 0.185784026408f
Cpex164 n8 n17 0.0256441260217f
Cpex165 n8 n18 0.18325996298f
Cpex166 n8 n19 0.0198296819277f
Cpex167 n8 n20 0.18325996298f
Cpex168 n8 n21 0.0198296819277f
Cpex169 n8 n22 0.167504899666f
Cpex170 n8 GND 0.405508178356f
Cpex171 n9 n10 0.265993335483f
Cpex172 n9 n11 0.0732823571712f
Cpex173 n9 n12 0.262897726852f
Cpex174 n9 VDD 1.36116787418f
Cpex175 n9 n14 0.44083596259f
Cpex176 n9 n15 0.0461293897887f
Cpex177 n9 n16 0.270732167903f
Cpex178 n9 n17 0.0373696811617f
Cpex179 n9 n18 0.267053998271f
Cpex180 n9 n19 0.028896632724f
Cpex181 n9 n20 0.267053998271f
Cpex182 n9 n21 0.028896632724f
Cpex183 n9 n22 0.244095068331f
Cpex184 n9 GND 0.590923290614f
Cpex185 n10 n11 0.141451554504f
Cpex186 n10 n12 0.507452183232f
Cpex187 n10 VDD 2.62736242632f
Cpex188 n10 n14 0.850913297508f
Cpex189 n10 n15 0.0890401748227f
Cpex190 n10 n16 0.522574429678f
Cpex191 n10 n17 0.0721319522967f
Cpex192 n10 n18 0.515474728847f
Cpex193 n10 n19 0.0557770488906f
Cpex194 n10 n20 0.515474728847f
Cpex195 n10 n21 0.0557770488906f
Cpex196 n10 n22 0.471158791762f
Cpex197 n10 GND 1.14061584912f
Cpex198 n11 n12 0.13980535291f
Cpex199 n11 VDD 0.723850134796f
Cpex200 n11 n14 0.234430430659f
Cpex201 n11 n15 0.0245309675977f
Cpex202 n11 n16 0.143971599644f
Cpex203 n11 n17 0.0198726764415f
Cpex204 n11 n18 0.142015600216f
Cpex205 n11 n19 0.0153668271851f
Cpex206 n11 n20 0.142015600216f
Cpex207 n11 n21 0.0153668271851f
Cpex208 n11 n22 0.129806360748f
Cpex209 n11 GND 0.314244783232f
Cpex210 n12 VDD 2.59678539781f
Cpex211 n12 n14 0.841010438315f
Cpex212 n12 n15 0.0880039325682f
Cpex213 n12 n16 0.51649275131f
Cpex214 n12 n17 0.0712924865497f
Cpex215 n12 n18 0.509475676214f
Cpex216 n12 n19 0.0551279201686f
Cpex217 n12 n20 0.509475676214f
Cpex218 n12 n21 0.0551279201686f
Cpex219 n12 n22 0.465675484373f
Cpex220 n12 GND 1.12734145538f
Cpex221 VDD n14 4.3543791884f
Cpex222 VDD n15 0.455645346377f
Cpex223 VDD n16 2.6741704797f
Cpex224 VDD n17 0.369120887897f
Cpex225 VDD n18 2.63783917587f
Cpex226 VDD n19 0.285427929721f
Cpex227 VDD n20 2.63783917587f
Cpex228 VDD n21 0.285427929721f
Cpex229 VDD n22 2.41106120129f
Cpex230 VDD GND 14.372865756f
Cpex231 n14 n15 0.147568024988f
Cpex232 n14 n16 0.866072833417f
Cpex233 n14 n17 0.119545696761f
Cpex234 n14 n18 0.854306360229f
Cpex235 n14 n19 0.0924403951454f
Cpex236 n14 n20 0.854306360229f
Cpex237 n14 n21 0.0924403951454f
Cpex238 n14 n22 0.780860690069f
Cpex239 n14 GND 1.89036497804f
Cpex240 n15 n16 0.0906264794809f
Cpex241 n15 n17 0.0125093470393f
Cpex242 n15 n18 0.0893952273278f
Cpex243 n15 n19 0.00967302893083f
Cpex244 n15 n20 0.0893952273278f
Cpex245 n15 n21 0.00967302893083f
Cpex246 n15 n22 0.0817098199776f
Cpex247 n15 GND 0.197809140622f
Cpex248 n16 n17 0.073417026727f
Cpex249 n16 n18 0.524658223435f
Cpex250 n16 n19 0.0567707508083f
Cpex251 n16 n20 0.524658223435f
Cpex252 n16 n21 0.0567707508083f
Cpex253 n16 n22 0.479552771083f
Cpex254 n16 GND 1.1609366115f
Cpex255 n17 n18 0.0724195823514f
Cpex256 n17 n19 0.00783617578012f
Cpex257 n17 n20 0.0724195823514f
Cpex258 n17 n21 0.00783617578012f
Cpex259 n17 n22 0.0661935901242f
Cpex260 n17 GND 0.160246310428f
Cpex261 n18 n19 0.0559994628849f
Cpex262 n18 n20 0.517530212163f
Cpex263 n18 n21 0.0559994628849f
Cpex264 n18 n22 0.473037562886f
Cpex265 n18 GND 1.14516411641f
Cpex266 n19 n20 0.0559994628849f
Cpex267 n19 n21 0.00605943338127f
Cpex268 n19 n22 0.0511851266331f
Cpex269 n19 GND 0.123912718382f
Cpex270 n20 n21 0.0559994628849f
Cpex271 n20 n22 0.473037562886f
Cpex272 n20 GND 1.14516411641f
Cpex273 n21 n22 0.0511851266331f
Cpex274 n21 GND 0.123912718382f
Cpex275 n22 GND 1.0467130807f
.ends buffer_pex
