* Sensitivity: all extracted wire resistances scaled by 0.1; capacitance unchanged.
* RC from verified GDS; capacitive-only nodes eliminated at zero net charge.
.subckt sensor_pex COL0 COL1 COL2 VRESET RST0 ROW0 RST1 ROW1 RST2 ROW2 BIAS SEL0 SEL1 SEL2 PREF BUF OUT GND VDD
X0 n336 n398 n404 n248 nfet_03v3 ad=0.44p pd=2.88u as=0.44p ps=2.88u w=1u l=0.5u
X1 n261 n306 n18 n232 nfet_03v3 ad=0.44p pd=2.88u as=0.44p ps=2.88u w=1u l=0.5u
X2 n354 n302 n396 n252 nfet_03v3 ad=0.44p pd=2.88u as=0.44p ps=2.88u w=1u l=0.5u
D0 n247 n389 diode_nd2ps_03v3 pj=80u area=0.4n
X3 n260 n310 n39 n241 nfet_03v3 ad=0.44p pd=2.88u as=0.44p ps=2.88u w=1u l=0.5u
X4 n352 n291 n358 n251 nfet_03v3 ad=0.44p pd=2.88u as=0.44p ps=2.88u w=1u l=0.5u
X5 n405 n274 n21 n233 nfet_03v3 ad=0.44p pd=2.88u as=0.44p ps=2.88u w=1u l=0.5u
X6 n240 n262 n13 n325 pfet_03v3 ad=8.8p pd=40.88u as=8.8p ps=40.88u w=20u l=0.5u
D1 n247 n393 diode_nd2ps_03v3 pj=80u area=0.4n
X7 n328 n372 n406 n242 nfet_03v3 ad=0.44p pd=2.88u as=0.44p ps=2.88u w=1u l=0.5u
X8 n20 n9 n254 n253 nfet_03v3 ad=0.88p pd=4.88u as=0.88p ps=4.88u w=2u l=2u
X9 n351 n292 n370 n250 nfet_03v3 ad=0.44p pd=2.88u as=0.44p ps=2.88u w=1u l=0.5u
X10 n349 n297 n362 n251 nfet_03v3 ad=0.44p pd=2.88u as=0.44p ps=2.88u w=1u l=0.5u
X11 n37 n7 n236 n235 nfet_03v3 ad=0.88p pd=4.88u as=0.88p ps=4.88u w=2u l=2u
X12 n407 n280 n19 n233 nfet_03v3 ad=0.44p pd=2.88u as=0.44p ps=2.88u w=1u l=0.5u
D2 n247 n397 diode_nd2ps_03v3 pj=80u area=0.4n
X13 n337 n376 n408 n242 nfet_03v3 ad=0.44p pd=2.88u as=0.44p ps=2.88u w=1u l=0.5u
D3 n243 n371 diode_nd2ps_03v3 pj=80u area=0.4n
X14 n381 n273 n30 n244 nfet_03v3 ad=0.44p pd=2.88u as=0.44p ps=2.88u w=1u l=0.5u
X15 n259 n308 n29 n239 nfet_03v3 ad=0.44p pd=2.88u as=0.44p ps=2.88u w=1u l=0.5u
X16 n348 n298 n374 n250 nfet_03v3 ad=0.44p pd=2.88u as=0.44p ps=2.88u w=1u l=0.5u
X17 n409 n286 n22 n233 nfet_03v3 ad=0.44p pd=2.88u as=0.44p ps=2.88u w=1u l=0.5u
X18 n355 n303 n366 n251 nfet_03v3 ad=0.44p pd=2.88u as=0.44p ps=2.88u w=1u l=0.5u
X19 n329 n360 n382 n246 nfet_03v3 ad=0.44p pd=2.88u as=0.44p ps=2.88u w=1u l=0.5u
D4 n245 n359 diode_nd2ps_03v3 pj=80u area=0.4n
X20 n399 n272 n38 n249 nfet_03v3 ad=0.44p pd=2.88u as=0.44p ps=2.88u w=1u l=0.5u
X21 n330 n390 n400 n248 nfet_03v3 ad=0.44p pd=2.88u as=0.44p ps=2.88u w=1u l=0.5u
X22 n267 n266 n331 n326 pfet_03v3 ad=8.8p pd=40.88u as=8.8p ps=40.88u w=20u l=2u
X23 n334 n380 n410 n242 nfet_03v3 ad=0.44p pd=2.88u as=0.44p ps=2.88u w=1u l=0.5u
X24 n383 n279 n27 n244 nfet_03v3 ad=0.44p pd=2.88u as=0.44p ps=2.88u w=1u l=0.5u
X25 n6 n5 n234 n255 nfet_03v3 ad=0.88p pd=4.88u as=0.88p ps=4.88u w=2u l=2u
D5 n243 n375 diode_nd2ps_03v3 pj=80u area=0.4n
X26 n353 n290 n388 n252 nfet_03v3 ad=0.44p pd=2.88u as=0.44p ps=2.88u w=1u l=0.5u
X27 n356 n304 n378 n250 nfet_03v3 ad=0.44p pd=2.88u as=0.44p ps=2.88u w=1u l=0.5u
X28 n338 n364 n384 n246 nfet_03v3 ad=0.44p pd=2.88u as=0.44p ps=2.88u w=1u l=0.5u
X29 n401 n278 n36 n249 nfet_03v3 ad=0.44p pd=2.88u as=0.44p ps=2.88u w=1u l=0.5u
D6 n245 n363 diode_nd2ps_03v3 pj=80u area=0.4n
X30 n12 n268 n333 n332 pfet_03v3 ad=8.8p pd=40.88u as=8.8p ps=40.88u w=20u l=2u
X31 n327 n394 n402 n248 nfet_03v3 ad=0.44p pd=2.88u as=0.44p ps=2.88u w=1u l=0.5u
X32 n385 n285 n31 n244 nfet_03v3 ad=0.44p pd=2.88u as=0.44p ps=2.88u w=1u l=0.5u
D7 n243 n379 diode_nd2ps_03v3 pj=80u area=0.4n
X33 n350 n296 n392 n252 nfet_03v3 ad=0.44p pd=2.88u as=0.44p ps=2.88u w=1u l=0.5u
X34 n335 n368 n386 n246 nfet_03v3 ad=0.44p pd=2.88u as=0.44p ps=2.88u w=1u l=0.5u
X35 n403 n284 n40 n249 nfet_03v3 ad=0.44p pd=2.88u as=0.44p ps=2.88u w=1u l=0.5u
D8 n245 n367 diode_nd2ps_03v3 pj=80u area=0.4n
X36 n28 n8 n238 n237 nfet_03v3 ad=0.88p pd=4.88u as=0.88p ps=4.88u w=2u l=2u
R0 n11 n12 2.86103
R1 n11 n13 2.16241
R2 BUF n11 0.5378
R3 n264 n266 5.73425
R4 n265 n268 5.64875
R5 n264 n267 2.01053
R6 PREF n265 1.3478
R7 n265 n264 0.80555
R8 SEL2 n310 6.95395
R9 SEL1 n308 6.43645
R10 OUT n262 20.9995
R11 n257 n261 2.88522
R12 n258 n260 2.43972
R13 n257 n259 2.43972
R14 OUT n258 1.5458
R15 n258 n257 0.44555
R16 SEL0 n306 5.91895
R17 n1 n7 2.72195
R18 n4 n5 2.27645
R19 n2 n9 2.27645
R20 n1 n8 2.27645
R21 n3 n6 1.91345
R22 n2 n1 0.44555
R23 n3 n2 0.37805
R24 BIAS n4 0.2228
R25 n4 n3 0.06305
R26 n270 n272 5.5567
R27 n271 n274 3.7612
R28 n270 n273 3.7612
R29 n271 n270 1.79555
R30 ROW0 n271 0.8978
R31 n288 n290 5.4892
R32 n289 n292 3.6937
R33 n288 n291 3.6937
R34 n289 n288 1.79555
R35 RST0 n289 0.2228
R36 n276 n278 5.5567
R37 n277 n280 3.7612
R38 n276 n279 3.7612
R39 n277 n276 1.79555
R40 ROW1 n277 0.8978
R41 n294 n296 5.4892
R42 n295 n298 3.6937
R43 n294 n297 3.6937
R44 n295 n294 1.79555
R45 RST1 n295 0.2228
R46 COL2 n35 6.93455
R47 n33 n40 4.99572
R48 n34 n38 3.87523
R49 n33 n36 3.87523
R50 n35 n39 3.58273
R51 n35 n37 2.11595
R52 n34 n33 1.12055
R53 COL2 n34 0.9158
R54 COL1 n26 5.5283
R55 n24 n31 4.99572
R56 n25 n30 3.87523
R57 n24 n27 3.87523
R58 n26 n29 3.51522
R59 n26 n28 2.04845
R60 n25 n24 1.12055
R61 COL1 n25 0.9158
R62 n15 n22 4.99572
R63 COL0 n17 4.12205
R64 n16 n21 3.87523
R65 n15 n19 3.87523
R66 n17 n18 3.44772
R67 n17 n20 1.98095
R68 n16 n15 1.12055
R69 COL0 n16 0.9158
R70 n282 n284 5.5567
R71 n283 n286 3.7612
R72 n282 n285 3.7612
R73 n283 n282 1.79555
R74 ROW2 n283 0.8978
R75 n340 n354 4.23522
R76 n342 n350 4.23522
R77 n345 n353 4.23522
R78 n340 n355 2.43972
R79 n341 n356 2.43972
R80 n342 n349 2.43972
R81 n343 n348 2.43972
R82 n345 n352 2.43972
R83 n346 n351 2.43972
R84 n344 n341 2.01605
R85 n341 n340 1.79555
R86 n343 n342 1.79555
R87 n346 n345 1.79555
R88 n347 n344 1.12055
R89 n344 n343 0.89555
R90 n347 n346 0.89555
R91 VRESET n347 0.7853
R92 n300 n302 5.4892
R93 n301 n304 3.6937
R94 n300 n303 3.6937
R95 n301 n300 1.79555
R96 RST2 n301 0.2228
R97 n312 n326 7.40647
R98 n317 n332 7.40647
R99 n318 n325 5.73836
R100 n319 n336 4.30272
R101 n321 n327 4.30272
R102 n324 n330 4.30272
R103 n316 n318 3.07805
R104 n319 n335 2.50723
R105 n320 n334 2.50723
R106 n321 n338 2.50723
R107 n322 n337 2.50723
R108 n324 n329 2.50723
R109 n314 n328 2.50723
R110 n323 n320 2.28605
R111 n312 n331 2.16353
R112 n313 n333 1.94303
R113 n320 n319 1.79555
R114 n322 n321 1.79555
R115 n314 n324 1.79555
R116 n316 n315 1.40405
R117 n323 n322 1.16555
R118 n315 n314 1.16555
R119 n315 n323 1.12055
R120 n318 n317 0.89555
R121 n313 n312 0.67055
R122 n317 n313 0.22055
R123 VDD n316 0.14405
R124 n116 n115 1205.89
R125 n115 n188 859.673
R126 n115 n249 223.205
R127 n123 n122 218.804
R128 n119 n118 218.804
R129 n124 n166 209.185
R130 n139 n138 199.676
R131 n132 n144 199.566
R132 n130 n129 199.566
R133 n173 n170 38.2974
R134 n173 n171 38.2974
R135 n178 n171 38.2974
R136 n178 n170 38.2974
R137 n151 n142 38.2974
R138 n152 n142 38.2974
R139 n158 n152 38.2974
R140 n158 n151 38.2974
R141 n229 n215 38.2974
R142 n229 n216 38.2974
R143 n72 n216 38.2974
R144 n72 n215 38.2974
R145 n169 n168 38.2974
R146 n168 n165 38.2974
R147 n187 n165 38.2974
R148 n187 n169 38.2974
R149 n197 n131 38.2974
R150 n195 n131 38.2974
R151 n198 n195 38.2974
R152 n198 n197 38.2974
R153 n225 n218 38.2974
R154 n225 n219 38.2974
R155 n219 n213 38.2974
R156 n218 n213 38.2974
R157 n181 n179 38.2974
R158 n181 n180 38.2974
R159 n185 n180 38.2974
R160 n185 n179 38.2974
R161 n100 n145 38.2974
R162 n100 n146 38.2974
R163 n159 n146 38.2974
R164 n159 n145 38.2974
R165 n227 n209 38.2974
R166 n74 n209 38.2974
R167 n74 n212 38.2974
R168 n227 n212 38.2974
R169 n138 n253 28.4728
R170 n144 n253 28.4728
R171 n132 n237 28.4728
R172 n237 n130 28.4728
R173 n129 n235 28.4728
R174 n228 n205 27.1611
R175 n103 n101 27.1611
R176 n226 n166 25.3946
R177 n124 n232 18.8536
R178 n232 n123 18.8536
R179 n122 n239 18.8536
R180 n119 n239 18.8536
R181 n118 n241 18.8536
R182 n116 n241 18.8536
R183 n58 n47 18.1577
R184 n66 n63 18.1577
R185 n81 n163 18.1577
R186 n88 n150 18.1577
R187 n108 n87 18.1577
R188 n114 n221 18.1577
R189 n73 n243 15.7939
R190 n160 n245 15.7939
R191 n101 n245 15.7939
R192 n186 n247 15.7939
R193 n247 n188 15.7939
R194 n226 n243 15.4174
R195 n139 n255 14.2364
R196 n73 n214 12.1052
R197 n93 n160 12.1052
R198 n186 n199 12.1052
R199 n41 n240 4.97941
R200 n226 n235 3.07819
R201 n175 n98 2.78893
R202 n112 n54 2.78893
R203 n191 n190 2.78893
R204 n117 n177 2.21352
R205 n250 n49 2.21329
R206 n58 n250 2.21329
R207 n47 n242 2.21329
R208 n63 n242 2.21329
R209 n66 n233 2.21329
R210 n233 n214 2.21329
R211 n251 n205 2.21329
R212 n81 n251 2.21329
R213 n246 n163 2.21329
R214 n88 n246 2.21329
R215 n244 n150 2.21329
R216 n93 n244 2.21329
R217 n103 n252 2.21329
R218 n252 n87 2.21329
R219 n108 n248 2.21329
R220 n248 n221 2.21329
R221 n249 n114 2.21329
R222 n249 n199 2.21329
R223 n97 n96 2.18592
R224 n78 n77 2.18592
R225 n202 n201 2.18592
R226 n223 n204 2.18592
R227 n70 n69 2.18592
R228 n156 n109 2.18592
R229 n60 n48 2.12855
R230 n143 n141 1.91255
R231 n140 n139 1.90466
R232 n155 n236 1.84595
R233 n135 n238 1.84595
R234 n42 n254 1.84595
R235 n141 n234 1.84595
R236 n134 n133 1.79321
R237 n137 n136 1.79321
R238 n128 n127 1.79006
R239 n121 n177 1.76807
R240 n126 n125 1.76807
R241 n107 n106 1.74557
R242 n105 n104 1.74557
R243 n92 n91 1.74557
R244 n90 n89 1.74557
R245 n206 n162 1.74557
R246 n68 n67 1.74557
R247 n46 n231 1.74557
R248 n57 n56 1.74557
R249 n191 n210 1.74557
R250 n192 n76 1.74557
R251 n193 n120 1.74557
R252 n203 n161 1.74557
R253 n85 n84 1.74557
R254 n83 n82 1.74557
R255 n50 n44 1.74557
R256 n51 n45 1.74557
R257 n53 n52 1.74557
R258 n113 n112 1.74557
R259 n111 n110 1.74557
R260 n102 n65 1.74557
R261 n95 n94 1.74557
R262 n86 n149 1.74557
R263 n80 n79 1.74557
R264 n64 n207 1.74557
R265 n62 n61 1.74557
R266 n60 n59 1.74557
R267 n98 n43 1.74557
R268 n55 n48 1.12055
R269 n55 n41 1.03505
R270 n56 n55 1.00805
R271 n52 n48 1.00805
R272 n174 n172 0.75083
R273 n176 n172 0.75083
R274 n183 n182 0.75083
R275 n184 n183 0.75083
R276 n99 n147 0.75083
R277 n148 n147 0.75083
R278 n211 n208 0.75083
R279 n75 n211 0.75083
R280 n167 n164 0.75083
R281 n189 n167 0.75083
R282 n196 n194 0.75083
R283 n200 n196 0.75083
R284 n224 n220 0.75083
R285 n222 n220 0.75083
R286 n230 n217 0.75083
R287 n71 n217 0.75083
R288 n154 n153 0.75083
R289 n157 n153 0.75083
R290 n175 n174 0.74669
R291 n176 n175 0.74669
R292 n182 n54 0.74669
R293 n184 n54 0.74669
R294 n99 n97 0.74669
R295 n97 n148 0.74669
R296 n77 n208 0.74669
R297 n77 n75 0.74669
R298 n190 n164 0.74669
R299 n190 n189 0.74669
R300 n201 n194 0.74669
R301 n201 n200 0.74669
R302 n224 n223 0.74669
R303 n223 n222 0.74669
R304 n70 n230 0.74669
R305 n71 n70 0.74669
R306 n156 n154 0.74669
R307 n157 n156 0.74669
R308 n91 n109 0.60305
R309 n69 n68 0.60305
R310 n78 n207 0.60305
R311 n96 n95 0.60305
R312 n50 n204 0.60305
R313 n203 n202 0.60305
R314 n105 n109 0.51305
R315 n69 n162 0.51305
R316 n79 n78 0.51305
R317 n96 n65 0.51305
R318 n83 n204 0.51305
R319 n202 n193 0.51305
R320 n127 n126 0.44555
R321 n126 n177 0.44555
R322 n228 n226 0.376451
R323 n106 n98 0.33305
R324 n106 n105 0.33305
R325 n91 n90 0.33305
R326 n90 n162 0.33305
R327 n68 n231 0.33305
R328 n56 n231 0.33305
R329 n61 n60 0.33305
R330 n61 n207 0.33305
R331 n79 n149 0.33305
R332 n95 n149 0.33305
R333 n111 n65 0.33305
R334 n112 n111 0.33305
R335 n52 n51 0.33305
R336 n51 n50 0.33305
R337 n84 n83 0.33305
R338 n84 n203 0.33305
R339 n193 n192 0.33305
R340 n192 n191 0.33305
R341 n114 n43 0.254855
R342 n113 n199 0.254855
R343 n110 n221 0.254855
R344 n102 n87 0.254855
R345 n94 n93 0.254855
R346 n88 n86 0.254855
R347 n81 n80 0.254855
R348 n64 n214 0.254855
R349 n63 n62 0.254855
R350 n59 n58 0.254855
R351 n210 n199 0.254855
R352 n76 n221 0.254855
R353 n120 n87 0.254855
R354 n93 n161 0.254855
R355 n88 n85 0.254855
R356 n82 n81 0.254855
R357 n44 n214 0.254855
R358 n63 n45 0.254855
R359 n58 n53 0.254855
R360 n58 n57 0.254855
R361 n63 n46 0.254855
R362 n67 n214 0.254855
R363 n81 n206 0.254855
R364 n89 n88 0.254855
R365 n93 n92 0.254855
R366 n104 n87 0.254855
R367 n107 n221 0.254855
R368 n43 n199 0.254855
R369 n108 n107 0.254855
R370 n104 n103 0.254855
R371 n92 n150 0.254855
R372 n89 n163 0.254855
R373 n206 n205 0.254855
R374 n67 n66 0.254855
R375 n47 n46 0.254855
R376 n57 n49 0.254855
R377 n114 n210 0.254855
R378 n108 n76 0.254855
R379 n103 n120 0.254855
R380 n161 n150 0.254855
R381 n85 n163 0.254855
R382 n82 n205 0.254855
R383 n66 n44 0.254855
R384 n47 n45 0.254855
R385 n53 n49 0.254855
R386 n114 n113 0.254855
R387 n110 n108 0.254855
R388 n103 n102 0.254855
R389 n94 n150 0.254855
R390 n86 n163 0.254855
R391 n80 n205 0.254855
R392 n66 n64 0.254855
R393 n62 n47 0.254855
R394 n59 n49 0.254855
R395 n122 n121 0.254855
R396 n121 n119 0.254855
R397 n125 n124 0.254855
R398 n125 n123 0.254855
R399 n118 n117 0.254808
R400 n117 n116 0.254808
R401 n140 n42 0.24305
R402 n136 n135 0.24305
R403 n134 n155 0.24305
R404 n129 n128 0.222856
R405 n128 n166 0.222856
R406 n133 n132 0.222856
R407 n133 n130 0.222856
R408 n138 n137 0.222856
R409 n137 n144 0.222856
R410 n141 n140 0.19805
R411 n136 n42 0.19805
R412 n135 n134 0.19805
R413 n127 n155 0.19805
R414 n143 n41 0.09905
R415 GND n143 0.01805
R416 n243 n212 0.012143
R417 n212 n211 0.012143
R418 n243 n209 0.012143
R419 n77 n209 0.012143
R420 n74 n73 0.012143
R421 n75 n74 0.012143
R422 n228 n227 0.012143
R423 n227 n208 0.012143
R424 n146 n245 0.012143
R425 n97 n146 0.012143
R426 n160 n159 0.012143
R427 n159 n148 0.012143
R428 n101 n100 0.012143
R429 n100 n99 0.012143
R430 n145 n245 0.012143
R431 n147 n145 0.012143
R432 n180 n247 0.012143
R433 n180 n54 0.012143
R434 n186 n185 0.012143
R435 n185 n184 0.012143
R436 n181 n188 0.012143
R437 n182 n181 0.012143
R438 n179 n247 0.012143
R439 n183 n179 0.012143
R440 n219 n243 0.012143
R441 n223 n219 0.012143
R442 n73 n213 0.012143
R443 n222 n213 0.012143
R444 n228 n225 0.012143
R445 n225 n224 0.012143
R446 n218 n243 0.012143
R447 n220 n218 0.012143
R448 n195 n245 0.012143
R449 n201 n195 0.012143
R450 n198 n160 0.012143
R451 n200 n198 0.012143
R452 n101 n131 0.012143
R453 n194 n131 0.012143
R454 n197 n245 0.012143
R455 n197 n196 0.012143
R456 n247 n165 0.012143
R457 n190 n165 0.012143
R458 n187 n186 0.012143
R459 n189 n187 0.012143
R460 n168 n188 0.012143
R461 n168 n164 0.012143
R462 n247 n169 0.012143
R463 n169 n167 0.012143
R464 n216 n243 0.012143
R465 n70 n216 0.012143
R466 n73 n72 0.012143
R467 n72 n71 0.012143
R468 n229 n228 0.012143
R469 n230 n229 0.012143
R470 n215 n243 0.012143
R471 n217 n215 0.012143
R472 n152 n245 0.012143
R473 n156 n152 0.012143
R474 n160 n158 0.012143
R475 n158 n157 0.012143
R476 n101 n142 0.012143
R477 n154 n142 0.012143
R478 n151 n245 0.012143
R479 n153 n151 0.012143
R480 n171 n247 0.012143
R481 n175 n171 0.012143
R482 n186 n178 0.012143
R483 n178 n176 0.012143
R484 n173 n188 0.012143
R485 n174 n173 0.012143
R486 n170 n247 0.012143
R487 n172 n170 0.012143
R488 n399 n400 4.9424
R489 n387 n390 3.5587
R490 n387 n389 3.53165
R491 n388 n387 2.57022
R492 n381 n382 4.9424
R493 n357 n360 3.5587
R494 n357 n359 3.53165
R495 n358 n357 2.57022
R496 n405 n406 4.9424
R497 n369 n372 3.5587
R498 n369 n371 3.53165
R499 n370 n369 2.57022
R500 n401 n402 4.9424
R501 n391 n394 3.5587
R502 n391 n393 3.53165
R503 n392 n391 2.57022
R504 n383 n384 4.9424
R505 n361 n364 3.5587
R506 n361 n363 3.53165
R507 n362 n361 2.57022
R508 n407 n408 4.9424
R509 n373 n376 3.5587
R510 n373 n375 3.53165
R511 n374 n373 2.57022
R512 n403 n404 4.9424
R513 n395 n398 3.5587
R514 n395 n397 3.53165
R515 n396 n395 2.57022
R516 n385 n386 4.9424
R517 n365 n368 3.5587
R518 n365 n367 3.53165
R519 n366 n365 2.57022
R520 n409 n410 4.9424
R521 n377 n380 3.5587
R522 n377 n379 3.53165
R523 n378 n377 2.57022
Cpex0 BIAS BUF 2.09139540075e-05f
Cpex1 BIAS COL0 4.42896301824f
Cpex2 BIAS COL1 1.6551068588f
Cpex3 BIAS COL2 1.17406725678f
Cpex4 BIAS OUT 0.767823281326f
Cpex5 BIAS PREF 0.000161896317361f
Cpex6 BIAS SEL0 0.23342455898f
Cpex7 BIAS SEL1 0.218305531508f
Cpex8 BIAS SEL2 0.216141547518f
Cpex9 BIAS VDD 0.000541655067774f
Cpex10 BIAS GND 63.7096632364f
Cpex11 BUF COL0 3.13625873899e-05f
Cpex12 BUF COL1 0.00108359489755f
Cpex13 BUF COL2 0.0262926291984f
Cpex14 BUF OUT 5.20163355554f
Cpex15 BUF PREF 2.42445194922f
Cpex16 BUF SEL0 0.000129747784346f
Cpex17 BUF SEL1 0.000194419585554f
Cpex18 BUF SEL2 0.000344785542213f
Cpex19 BUF VDD 7.67036947498f
Cpex20 BUF GND 24.0194284672f
Cpex21 n11 GND 13.8025f
Cpex22 n12 GND 9.07716f
Cpex23 n13 GND 12.173f
Cpex24 COL0 COL1 10.2857175271f
Cpex25 COL0 COL2 3.02971200683f
Cpex26 COL0 OUT 1.09185508285f
Cpex27 COL0 PREF 0.00019450922497f
Cpex28 COL0 ROW0 1.35955707731f
Cpex29 COL0 ROW1 1.3991703953f
Cpex30 COL0 ROW2 1.33084918785f
Cpex31 COL0 RST0 0.654424028066f
Cpex32 COL0 RST1 0.681927912219f
Cpex33 COL0 RST2 0.608847466337f
Cpex34 COL0 SEL0 0.936761083658f
Cpex35 COL0 SEL1 0.260143013948f
Cpex36 COL0 SEL2 0.26170985761f
Cpex37 COL0 VDD 9.14753078299f
Cpex38 COL0 VRESET 2.63668903289f
Cpex39 COL0 GND 126.795063651f
Cpex40 n15 GND 23.2945f
Cpex41 n16 GND 14.782f
Cpex42 n17 GND 42.0785f
Cpex43 n18 GND 0.48544f
Cpex44 n19 GND 4.07744f
Cpex45 n20 GND 1.89554f
Cpex46 n21 GND 4.07744f
Cpex47 n22 GND 6.26337f
Cpex48 COL1 COL2 13.6077759979f
Cpex49 COL1 OUT 1.63831131801f
Cpex50 COL1 PREF 0.000517362352292f
Cpex51 COL1 ROW0 1.46947085546f
Cpex52 COL1 ROW1 1.54920800576f
Cpex53 COL1 ROW2 1.44096179958f
Cpex54 COL1 RST0 0.64200598513f
Cpex55 COL1 RST1 0.689916781195f
Cpex56 COL1 RST2 0.602723834785f
Cpex57 COL1 SEL0 0.45183871584f
Cpex58 COL1 SEL1 1.07986060146f
Cpex59 COL1 SEL2 0.278200122553f
Cpex60 COL1 VDD 9.24760898818f
Cpex61 COL1 VRESET 2.62090035377f
Cpex62 COL1 GND 146.303738992f
Cpex63 n24 GND 20.4784f
Cpex64 n25 GND 12.995f
Cpex65 n26 GND 53.8027f
Cpex66 n27 GND 3.5845f
Cpex67 n28 GND 1.86982f
Cpex68 n29 GND 2.02791f
Cpex69 n30 GND 3.5845f
Cpex70 n31 GND 5.50617f
Cpex71 COL2 OUT 4.53852276974f
Cpex72 COL2 PREF 0.00560589869211f
Cpex73 COL2 ROW0 1.47991175336f
Cpex74 COL2 ROW1 1.55277902731f
Cpex75 COL2 ROW2 1.45163168879f
Cpex76 COL2 RST0 0.588052064625f
Cpex77 COL2 RST1 0.622161258251f
Cpex78 COL2 RST2 0.546328515697f
Cpex79 COL2 SEL0 0.858641773095f
Cpex80 COL2 SEL1 0.483437290647f
Cpex81 COL2 SEL2 1.01400238696f
Cpex82 COL2 VDD 10.12236446f
Cpex83 COL2 VRESET 2.50460820897f
Cpex84 COL2 GND 174.559289967f
Cpex85 n33 GND 18.4649f
Cpex86 n34 GND 11.7173f
Cpex87 n35 GND 63.6766f
Cpex88 n36 GND 3.23208f
Cpex89 n37 GND 1.8736f
Cpex90 n38 GND 3.23208f
Cpex91 n39 GND 3.22723f
Cpex92 n40 GND 4.96481f
Cpex93 OUT PREF 3.98492771052f
Cpex94 OUT SEL0 4.81543543919f
Cpex95 OUT SEL1 1.96246336026f
Cpex96 OUT SEL2 1.35212181493f
Cpex97 OUT VDD 1.64125271491f
Cpex98 OUT GND 115.996720507f
Cpex99 PREF SEL0 0.000371694997326f
Cpex100 PREF SEL1 0.00046454948591f
Cpex101 PREF SEL2 0.000666919213328f
Cpex102 PREF VDD 14.5724565058f
Cpex103 PREF GND 17.0368051213f
Cpex104 n264 GND 6.29013f
Cpex105 n265 GND 9.49962f
Cpex106 n266 GND 10.2608f
Cpex107 n267 GND 2.81933f
Cpex108 n268 GND 10.2333f
Cpex109 ROW0 ROW1 0.000541210282956f
Cpex110 ROW0 RST0 8.32701518714f
Cpex111 ROW0 RST1 0.000654557917429f
Cpex112 ROW0 VDD 2.02984765347f
Cpex113 ROW0 VRESET 8.29423821406f
Cpex114 ROW0 GND 28.3176281982f
Cpex115 n270 GND 25.7657f
Cpex116 n271 GND 18.1386f
Cpex117 n272 GND 2.93002f
Cpex118 n273 GND 1.45749f
Cpex119 n274 GND 1.45749f
Cpex120 ROW1 ROW2 0.000521750344855f
Cpex121 ROW1 RST0 0.000230907696384f
Cpex122 ROW1 RST1 6.49885252692f
Cpex123 ROW1 RST2 0.000610502843579f
Cpex124 ROW1 VDD 1.94211306907f
Cpex125 ROW1 VRESET 6.49322824865f
Cpex126 ROW1 GND 28.6014878619f
Cpex127 n276 GND 26.1498f
Cpex128 n277 GND 18.409f
Cpex129 n278 GND 2.97369f
Cpex130 n279 GND 1.47921f
Cpex131 n280 GND 1.47921f
Cpex132 ROW2 RST1 0.000214902298273f
Cpex133 ROW2 RST2 7.7691098865f
Cpex134 ROW2 VDD 1.81578047087f
Cpex135 ROW2 VRESET 7.77857790185f
Cpex136 ROW2 GND 27.6091073132f
Cpex137 n282 GND 24.4821f
Cpex138 n283 GND 17.235f
Cpex139 n284 GND 2.78405f
Cpex140 n285 GND 1.38488f
Cpex141 n286 GND 1.38488f
Cpex142 RST0 RST1 0.000410500162429f
Cpex143 RST0 VDD 1.45258519151f
Cpex144 RST0 VRESET 3.99612173753f
Cpex145 RST0 GND 27.4275775254f
Cpex146 n288 GND 27.4993f
Cpex147 n289 GND 19.2595f
Cpex148 n290 GND 0.52439f
Cpex149 n291 GND 1.76807f
Cpex150 n292 GND 1.76807f
Cpex151 RST1 RST2 0.000386872743216f
Cpex152 RST1 VDD 1.43905900755f
Cpex153 RST1 VRESET 4.04020842794f
Cpex154 RST1 GND 27.8053491778f
Cpex155 n294 GND 28.032f
Cpex156 n295 GND 19.6326f
Cpex157 n296 GND 0.53455f
Cpex158 n297 GND 1.80231f
Cpex159 n298 GND 1.80231f
Cpex160 RST2 VDD 1.28765322798f
Cpex161 RST2 VRESET 3.76837572237f
Cpex162 RST2 GND 26.4769729117f
Cpex163 n300 GND 26.3224f
Cpex164 n301 GND 18.4352f
Cpex165 n302 GND 0.50195f
Cpex166 n303 GND 1.69239f
Cpex167 n304 GND 1.69239f
Cpex168 SEL0 SEL1 3.84727596841f
Cpex169 SEL0 SEL2 0.948141224144f
Cpex170 SEL0 VDD 0.000641441081119f
Cpex171 SEL0 GND 37.7193489103f
Cpex172 n306 GND 5.8835f
Cpex173 SEL1 SEL2 3.99570721622f
Cpex174 SEL1 VDD 0.000724671929728f
Cpex175 SEL1 GND 37.4425126293f
Cpex176 n308 GND 7.60861f
Cpex177 SEL2 VDD 0.00104195817267f
Cpex178 SEL2 GND 39.9518862983f
Cpex179 n310 GND 8.95089f
Cpex180 VDD VRESET 30.8962635685f
Cpex181 VDD GND 252.515823505f
Cpex182 n312 GND 21.6878f
Cpex183 n313 GND 3.6048f
Cpex184 n314 GND 8.31496f
Cpex185 n315 GND 7.23284f
Cpex186 n316 GND 130.57f
Cpex187 n317 GND 21.6488f
Cpex188 n318 GND 60.1626f
Cpex189 n319 GND 10.6457f
Cpex190 n320 GND 9.70942f
Cpex191 n321 GND 10.6457f
Cpex192 n322 GND 8.31496f
Cpex193 n323 GND 7.40708f
Cpex194 n324 GND 10.6457f
Cpex195 n325 GND 17.0773f
Cpex196 n326 GND 20.8691f
Cpex197 n327 GND 1.63821f
Cpex198 n328 GND 1.20959f
Cpex199 n329 GND 1.20959f
Cpex200 n330 GND 1.63821f
Cpex201 n331 GND 2.31844f
Cpex202 n332 GND 20.8691f
Cpex203 n333 GND 2.25815f
Cpex204 n334 GND 1.20959f
Cpex205 n335 GND 1.20959f
Cpex206 n336 GND 1.63821f
Cpex207 n337 GND 1.20959f
Cpex208 n338 GND 1.20959f
Cpex209 VRESET GND 99.0310817111f
Cpex210 n340 GND 25.0932f
Cpex211 n341 GND 22.6759f
Cpex212 n342 GND 25.0932f
Cpex213 n343 GND 19.6413f
Cpex214 n344 GND 16.8919f
Cpex215 n345 GND 25.0932f
Cpex216 n346 GND 19.6413f
Cpex217 n347 GND 12.5272f
Cpex218 n348 GND 2.91293f
Cpex219 n349 GND 2.91293f
Cpex220 n350 GND 2.19829f
Cpex221 n351 GND 2.91293f
Cpex222 n352 GND 2.91293f
Cpex223 n353 GND 2.19829f
Cpex224 n354 GND 2.19829f
Cpex225 n355 GND 2.91293f
Cpex226 n356 GND 2.91293f
Cpex227 n357 GND 1.51412f
Cpex228 n358 GND 0.17183f
Cpex229 n359 GND 17.2995f
Cpex230 n360 GND 0.07566f
Cpex231 n361 GND 1.6515f
Cpex232 n362 GND 0.18742f
Cpex233 n363 GND 18.8692f
Cpex234 n364 GND 0.08252f
Cpex235 n365 GND 1.4611f
Cpex236 n366 GND 0.16581f
Cpex237 n367 GND 16.6939f
Cpex238 n368 GND 0.07301f
Cpex239 n369 GND 1.5817f
Cpex240 n370 GND 0.1795f
Cpex241 n371 GND 18.0717f
Cpex242 n372 GND 0.07904f
Cpex243 n373 GND 1.69555f
Cpex244 n374 GND 0.19242f
Cpex245 n375 GND 19.3725f
Cpex246 n376 GND 0.08472f
Cpex247 n377 GND 1.52024f
Cpex248 n378 GND 0.17252f
Cpex249 n379 GND 17.3695f
Cpex250 n380 GND 0.07596f
Cpex251 n381 GND 8.40793f
Cpex252 n382 GND 9.89993f
Cpex253 n383 GND 8.63771f
Cpex254 n384 GND 10.1705f
Cpex255 n385 GND 8.13921f
Cpex256 n386 GND 9.58353f
Cpex257 n387 GND 1.55622f
Cpex258 n388 GND 0.17661f
Cpex259 n389 GND 17.7805f
Cpex260 n390 GND 0.07776f
Cpex261 n391 GND 1.69638f
Cpex262 n392 GND 0.19251f
Cpex263 n393 GND 19.382f
Cpex264 n394 GND 0.08477f
Cpex265 n395 GND 1.50432f
Cpex266 n396 GND 0.17072f
Cpex267 n397 GND 17.1876f
Cpex268 n398 GND 0.07517f
Cpex269 n399 GND 8.46223f
Cpex270 n400 GND 9.96386f
Cpex271 n401 GND 8.68525f
Cpex272 n402 GND 10.2265f
Cpex273 n403 GND 8.17525f
Cpex274 n404 GND 9.62597f
Cpex275 n405 GND 8.89033f
Cpex276 n406 GND 10.4679f
Cpex277 n407 GND 8.96889f
Cpex278 n408 GND 10.5604f
Cpex279 n409 GND 8.57819f
Cpex280 n410 GND 10.1004f
.ends sensor_pex
