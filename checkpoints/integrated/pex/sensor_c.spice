* Same extracted capacitance with ideal wires.
.subckt sensor_c COL0 COL1 COL2 VRESET RST0 ROW0 RST1 ROW1 RST2 ROW2 BIAS SEL0 SEL1 SEL2 PREF BUF OUT GND VDD
X0 VDD s22 f22 GND nfet_03v3 ad=0.44p pd=2.88u as=0.44p ps=2.88u w=1u l=0.5u
X1 OUT SEL0 COL0 GND nfet_03v3 ad=0.44p pd=2.88u as=0.44p ps=2.88u w=1u l=0.5u
X2 VRESET RST2 s22 GND nfet_03v3 ad=0.44p pd=2.88u as=0.44p ps=2.88u w=1u l=0.5u
D0 GND s02 diode_nd2ps_03v3 pj=80u area=0.4n
X3 OUT SEL2 COL2 GND nfet_03v3 ad=0.44p pd=2.88u as=0.44p ps=2.88u w=1u l=0.5u
X4 VRESET RST0 s01 GND nfet_03v3 ad=0.44p pd=2.88u as=0.44p ps=2.88u w=1u l=0.5u
X5 f00 ROW0 COL0 GND nfet_03v3 ad=0.44p pd=2.88u as=0.44p ps=2.88u w=1u l=0.5u
X6 GND OUT BUF VDD pfet_03v3 ad=8.8p pd=40.88u as=8.8p ps=40.88u w=20u l=0.5u
D1 GND s12 diode_nd2ps_03v3 pj=80u area=0.4n
X7 VDD s00 f00 GND nfet_03v3 ad=0.44p pd=2.88u as=0.44p ps=2.88u w=1u l=0.5u
X8 COL0 BIAS GND GND nfet_03v3 ad=0.88p pd=4.88u as=0.88p ps=4.88u w=2u l=2u
X9 VRESET RST0 s00 GND nfet_03v3 ad=0.44p pd=2.88u as=0.44p ps=2.88u w=1u l=0.5u
X10 VRESET RST1 s11 GND nfet_03v3 ad=0.44p pd=2.88u as=0.44p ps=2.88u w=1u l=0.5u
X11 COL2 BIAS GND GND nfet_03v3 ad=0.88p pd=4.88u as=0.88p ps=4.88u w=2u l=2u
X12 f10 ROW1 COL0 GND nfet_03v3 ad=0.44p pd=2.88u as=0.44p ps=2.88u w=1u l=0.5u
D2 GND s22 diode_nd2ps_03v3 pj=80u area=0.4n
X13 VDD s10 f10 GND nfet_03v3 ad=0.44p pd=2.88u as=0.44p ps=2.88u w=1u l=0.5u
D3 GND s00 diode_nd2ps_03v3 pj=80u area=0.4n
X14 f01 ROW0 COL1 GND nfet_03v3 ad=0.44p pd=2.88u as=0.44p ps=2.88u w=1u l=0.5u
X15 OUT SEL1 COL1 GND nfet_03v3 ad=0.44p pd=2.88u as=0.44p ps=2.88u w=1u l=0.5u
X16 VRESET RST1 s10 GND nfet_03v3 ad=0.44p pd=2.88u as=0.44p ps=2.88u w=1u l=0.5u
X17 f20 ROW2 COL0 GND nfet_03v3 ad=0.44p pd=2.88u as=0.44p ps=2.88u w=1u l=0.5u
X18 VRESET RST2 s21 GND nfet_03v3 ad=0.44p pd=2.88u as=0.44p ps=2.88u w=1u l=0.5u
X19 VDD s01 f01 GND nfet_03v3 ad=0.44p pd=2.88u as=0.44p ps=2.88u w=1u l=0.5u
D4 GND s01 diode_nd2ps_03v3 pj=80u area=0.4n
X20 f02 ROW0 COL2 GND nfet_03v3 ad=0.44p pd=2.88u as=0.44p ps=2.88u w=1u l=0.5u
X21 VDD s02 f02 GND nfet_03v3 ad=0.44p pd=2.88u as=0.44p ps=2.88u w=1u l=0.5u
X22 PREF PREF VDD VDD pfet_03v3 ad=8.8p pd=40.88u as=8.8p ps=40.88u w=20u l=2u
X23 VDD s20 f20 GND nfet_03v3 ad=0.44p pd=2.88u as=0.44p ps=2.88u w=1u l=0.5u
X24 f11 ROW1 COL1 GND nfet_03v3 ad=0.44p pd=2.88u as=0.44p ps=2.88u w=1u l=0.5u
X25 BIAS BIAS GND GND nfet_03v3 ad=0.88p pd=4.88u as=0.88p ps=4.88u w=2u l=2u
D5 GND s10 diode_nd2ps_03v3 pj=80u area=0.4n
X26 VRESET RST0 s02 GND nfet_03v3 ad=0.44p pd=2.88u as=0.44p ps=2.88u w=1u l=0.5u
X27 VRESET RST2 s20 GND nfet_03v3 ad=0.44p pd=2.88u as=0.44p ps=2.88u w=1u l=0.5u
X28 VDD s11 f11 GND nfet_03v3 ad=0.44p pd=2.88u as=0.44p ps=2.88u w=1u l=0.5u
X29 f12 ROW1 COL2 GND nfet_03v3 ad=0.44p pd=2.88u as=0.44p ps=2.88u w=1u l=0.5u
D6 GND s11 diode_nd2ps_03v3 pj=80u area=0.4n
X30 BUF PREF VDD VDD pfet_03v3 ad=8.8p pd=40.88u as=8.8p ps=40.88u w=20u l=2u
X31 VDD s12 f12 GND nfet_03v3 ad=0.44p pd=2.88u as=0.44p ps=2.88u w=1u l=0.5u
X32 f21 ROW2 COL1 GND nfet_03v3 ad=0.44p pd=2.88u as=0.44p ps=2.88u w=1u l=0.5u
D7 GND s20 diode_nd2ps_03v3 pj=80u area=0.4n
X33 VRESET RST1 s12 GND nfet_03v3 ad=0.44p pd=2.88u as=0.44p ps=2.88u w=1u l=0.5u
X34 VDD s21 f21 GND nfet_03v3 ad=0.44p pd=2.88u as=0.44p ps=2.88u w=1u l=0.5u
X35 f22 ROW2 COL2 GND nfet_03v3 ad=0.44p pd=2.88u as=0.44p ps=2.88u w=1u l=0.5u
D8 GND s21 diode_nd2ps_03v3 pj=80u area=0.4n
X36 COL1 BIAS GND GND nfet_03v3 ad=0.88p pd=4.88u as=0.88p ps=4.88u w=2u l=2u
Cpex0 BIAS BUF 2.09139540075e-05f
Cpex1 BIAS COL0 4.42896301824f
Cpex2 BIAS COL1 1.6551068588f
Cpex3 BIAS COL2 1.17406725678f
Cpex4 BIAS OUT 0.767823281326f
Cpex5 BIAS PREF 0.000161896317361f
Cpex6 BIAS SEL0 0.23342455898f
Cpex7 BIAS SEL1 0.218305531508f
Cpex8 BIAS SEL2 0.216141547518f
Cpex9 BIAS VDD 0.000541655067774f
Cpex10 BIAS GND 63.7096632364f
Cpex11 BUF COL0 3.13625873899e-05f
Cpex12 BUF COL1 0.00108359489755f
Cpex13 BUF COL2 0.0262926291984f
Cpex14 BUF OUT 5.20163355554f
Cpex15 BUF PREF 2.42445194922f
Cpex16 BUF SEL0 0.000129747784346f
Cpex17 BUF SEL1 0.000194419585554f
Cpex18 BUF SEL2 0.000344785542213f
Cpex19 BUF VDD 7.67036947498f
Cpex20 BUF GND 24.0194284672f
Cpex21 BUF GND 13.8025f
Cpex22 BUF GND 9.07716f
Cpex23 BUF GND 12.173f
Cpex24 COL0 COL1 10.2857175271f
Cpex25 COL0 COL2 3.02971200683f
Cpex26 COL0 OUT 1.09185508285f
Cpex27 COL0 PREF 0.00019450922497f
Cpex28 COL0 ROW0 1.35955707731f
Cpex29 COL0 ROW1 1.3991703953f
Cpex30 COL0 ROW2 1.33084918785f
Cpex31 COL0 RST0 0.654424028066f
Cpex32 COL0 RST1 0.681927912219f
Cpex33 COL0 RST2 0.608847466337f
Cpex34 COL0 SEL0 0.936761083658f
Cpex35 COL0 SEL1 0.260143013948f
Cpex36 COL0 SEL2 0.26170985761f
Cpex37 COL0 VDD 9.14753078299f
Cpex38 COL0 VRESET 2.63668903289f
Cpex39 COL0 GND 126.795063651f
Cpex40 COL0 GND 23.2945f
Cpex41 COL0 GND 14.782f
Cpex42 COL0 GND 42.0785f
Cpex43 COL0 GND 0.48544f
Cpex44 COL0 GND 4.07744f
Cpex45 COL0 GND 1.89554f
Cpex46 COL0 GND 4.07744f
Cpex47 COL0 GND 6.26337f
Cpex48 COL1 COL2 13.6077759979f
Cpex49 COL1 OUT 1.63831131801f
Cpex50 COL1 PREF 0.000517362352292f
Cpex51 COL1 ROW0 1.46947085546f
Cpex52 COL1 ROW1 1.54920800576f
Cpex53 COL1 ROW2 1.44096179958f
Cpex54 COL1 RST0 0.64200598513f
Cpex55 COL1 RST1 0.689916781195f
Cpex56 COL1 RST2 0.602723834785f
Cpex57 COL1 SEL0 0.45183871584f
Cpex58 COL1 SEL1 1.07986060146f
Cpex59 COL1 SEL2 0.278200122553f
Cpex60 COL1 VDD 9.24760898818f
Cpex61 COL1 VRESET 2.62090035377f
Cpex62 COL1 GND 146.303738992f
Cpex63 COL1 GND 20.4784f
Cpex64 COL1 GND 12.995f
Cpex65 COL1 GND 53.8027f
Cpex66 COL1 GND 3.5845f
Cpex67 COL1 GND 1.86982f
Cpex68 COL1 GND 2.02791f
Cpex69 COL1 GND 3.5845f
Cpex70 COL1 GND 5.50617f
Cpex71 COL2 OUT 4.53852276974f
Cpex72 COL2 PREF 0.00560589869211f
Cpex73 COL2 ROW0 1.47991175336f
Cpex74 COL2 ROW1 1.55277902731f
Cpex75 COL2 ROW2 1.45163168879f
Cpex76 COL2 RST0 0.588052064625f
Cpex77 COL2 RST1 0.622161258251f
Cpex78 COL2 RST2 0.546328515697f
Cpex79 COL2 SEL0 0.858641773095f
Cpex80 COL2 SEL1 0.483437290647f
Cpex81 COL2 SEL2 1.01400238696f
Cpex82 COL2 VDD 10.12236446f
Cpex83 COL2 VRESET 2.50460820897f
Cpex84 COL2 GND 174.559289967f
Cpex85 COL2 GND 18.4649f
Cpex86 COL2 GND 11.7173f
Cpex87 COL2 GND 63.6766f
Cpex88 COL2 GND 3.23208f
Cpex89 COL2 GND 1.8736f
Cpex90 COL2 GND 3.23208f
Cpex91 COL2 GND 3.22723f
Cpex92 COL2 GND 4.96481f
Cpex93 OUT PREF 3.98492771052f
Cpex94 OUT SEL0 4.81543543919f
Cpex95 OUT SEL1 1.96246336026f
Cpex96 OUT SEL2 1.35212181493f
Cpex97 OUT VDD 1.64125271491f
Cpex98 OUT GND 115.996720507f
Cpex99 PREF SEL0 0.000371694997326f
Cpex100 PREF SEL1 0.00046454948591f
Cpex101 PREF SEL2 0.000666919213328f
Cpex102 PREF VDD 14.5724565058f
Cpex103 PREF GND 17.0368051213f
Cpex104 PREF GND 6.29013f
Cpex105 PREF GND 9.49962f
Cpex106 PREF GND 10.2608f
Cpex107 PREF GND 2.81933f
Cpex108 PREF GND 10.2333f
Cpex109 ROW0 ROW1 0.000541210282956f
Cpex110 ROW0 RST0 8.32701518714f
Cpex111 ROW0 RST1 0.000654557917429f
Cpex112 ROW0 VDD 2.02984765347f
Cpex113 ROW0 VRESET 8.29423821406f
Cpex114 ROW0 GND 28.3176281982f
Cpex115 ROW0 GND 25.7657f
Cpex116 ROW0 GND 18.1386f
Cpex117 ROW0 GND 2.93002f
Cpex118 ROW0 GND 1.45749f
Cpex119 ROW0 GND 1.45749f
Cpex120 ROW1 ROW2 0.000521750344855f
Cpex121 ROW1 RST0 0.000230907696384f
Cpex122 ROW1 RST1 6.49885252692f
Cpex123 ROW1 RST2 0.000610502843579f
Cpex124 ROW1 VDD 1.94211306907f
Cpex125 ROW1 VRESET 6.49322824865f
Cpex126 ROW1 GND 28.6014878619f
Cpex127 ROW1 GND 26.1498f
Cpex128 ROW1 GND 18.409f
Cpex129 ROW1 GND 2.97369f
Cpex130 ROW1 GND 1.47921f
Cpex131 ROW1 GND 1.47921f
Cpex132 ROW2 RST1 0.000214902298273f
Cpex133 ROW2 RST2 7.7691098865f
Cpex134 ROW2 VDD 1.81578047087f
Cpex135 ROW2 VRESET 7.77857790185f
Cpex136 ROW2 GND 27.6091073132f
Cpex137 ROW2 GND 24.4821f
Cpex138 ROW2 GND 17.235f
Cpex139 ROW2 GND 2.78405f
Cpex140 ROW2 GND 1.38488f
Cpex141 ROW2 GND 1.38488f
Cpex142 RST0 RST1 0.000410500162429f
Cpex143 RST0 VDD 1.45258519151f
Cpex144 RST0 VRESET 3.99612173753f
Cpex145 RST0 GND 27.4275775254f
Cpex146 RST0 GND 27.4993f
Cpex147 RST0 GND 19.2595f
Cpex148 RST0 GND 0.52439f
Cpex149 RST0 GND 1.76807f
Cpex150 RST0 GND 1.76807f
Cpex151 RST1 RST2 0.000386872743216f
Cpex152 RST1 VDD 1.43905900755f
Cpex153 RST1 VRESET 4.04020842794f
Cpex154 RST1 GND 27.8053491778f
Cpex155 RST1 GND 28.032f
Cpex156 RST1 GND 19.6326f
Cpex157 RST1 GND 0.53455f
Cpex158 RST1 GND 1.80231f
Cpex159 RST1 GND 1.80231f
Cpex160 RST2 VDD 1.28765322798f
Cpex161 RST2 VRESET 3.76837572237f
Cpex162 RST2 GND 26.4769729117f
Cpex163 RST2 GND 26.3224f
Cpex164 RST2 GND 18.4352f
Cpex165 RST2 GND 0.50195f
Cpex166 RST2 GND 1.69239f
Cpex167 RST2 GND 1.69239f
Cpex168 SEL0 SEL1 3.84727596841f
Cpex169 SEL0 SEL2 0.948141224144f
Cpex170 SEL0 VDD 0.000641441081119f
Cpex171 SEL0 GND 37.7193489103f
Cpex172 SEL0 GND 5.8835f
Cpex173 SEL1 SEL2 3.99570721622f
Cpex174 SEL1 VDD 0.000724671929728f
Cpex175 SEL1 GND 37.4425126293f
Cpex176 SEL1 GND 7.60861f
Cpex177 SEL2 VDD 0.00104195817267f
Cpex178 SEL2 GND 39.9518862983f
Cpex179 SEL2 GND 8.95089f
Cpex180 VDD VRESET 30.8962635685f
Cpex181 VDD GND 252.515823505f
Cpex182 VDD GND 21.6878f
Cpex183 VDD GND 3.6048f
Cpex184 VDD GND 8.31496f
Cpex185 VDD GND 7.23284f
Cpex186 VDD GND 130.57f
Cpex187 VDD GND 21.6488f
Cpex188 VDD GND 60.1626f
Cpex189 VDD GND 10.6457f
Cpex190 VDD GND 9.70942f
Cpex191 VDD GND 10.6457f
Cpex192 VDD GND 8.31496f
Cpex193 VDD GND 7.40708f
Cpex194 VDD GND 10.6457f
Cpex195 VDD GND 17.0773f
Cpex196 VDD GND 20.8691f
Cpex197 VDD GND 1.63821f
Cpex198 VDD GND 1.20959f
Cpex199 VDD GND 1.20959f
Cpex200 VDD GND 1.63821f
Cpex201 VDD GND 2.31844f
Cpex202 VDD GND 20.8691f
Cpex203 VDD GND 2.25815f
Cpex204 VDD GND 1.20959f
Cpex205 VDD GND 1.20959f
Cpex206 VDD GND 1.63821f
Cpex207 VDD GND 1.20959f
Cpex208 VDD GND 1.20959f
Cpex209 VRESET GND 99.0310817111f
Cpex210 VRESET GND 25.0932f
Cpex211 VRESET GND 22.6759f
Cpex212 VRESET GND 25.0932f
Cpex213 VRESET GND 19.6413f
Cpex214 VRESET GND 16.8919f
Cpex215 VRESET GND 25.0932f
Cpex216 VRESET GND 19.6413f
Cpex217 VRESET GND 12.5272f
Cpex218 VRESET GND 2.91293f
Cpex219 VRESET GND 2.91293f
Cpex220 VRESET GND 2.19829f
Cpex221 VRESET GND 2.91293f
Cpex222 VRESET GND 2.91293f
Cpex223 VRESET GND 2.19829f
Cpex224 VRESET GND 2.19829f
Cpex225 VRESET GND 2.91293f
Cpex226 VRESET GND 2.91293f
Cpex227 s01 GND 1.51412f
Cpex228 s01 GND 0.17183f
Cpex229 s01 GND 17.2995f
Cpex230 s01 GND 0.07566f
Cpex231 s11 GND 1.6515f
Cpex232 s11 GND 0.18742f
Cpex233 s11 GND 18.8692f
Cpex234 s11 GND 0.08252f
Cpex235 s21 GND 1.4611f
Cpex236 s21 GND 0.16581f
Cpex237 s21 GND 16.6939f
Cpex238 s21 GND 0.07301f
Cpex239 s00 GND 1.5817f
Cpex240 s00 GND 0.1795f
Cpex241 s00 GND 18.0717f
Cpex242 s00 GND 0.07904f
Cpex243 s10 GND 1.69555f
Cpex244 s10 GND 0.19242f
Cpex245 s10 GND 19.3725f
Cpex246 s10 GND 0.08472f
Cpex247 s20 GND 1.52024f
Cpex248 s20 GND 0.17252f
Cpex249 s20 GND 17.3695f
Cpex250 s20 GND 0.07596f
Cpex251 f01 GND 8.40793f
Cpex252 f01 GND 9.89993f
Cpex253 f11 GND 8.63771f
Cpex254 f11 GND 10.1705f
Cpex255 f21 GND 8.13921f
Cpex256 f21 GND 9.58353f
Cpex257 s02 GND 1.55622f
Cpex258 s02 GND 0.17661f
Cpex259 s02 GND 17.7805f
Cpex260 s02 GND 0.07776f
Cpex261 s12 GND 1.69638f
Cpex262 s12 GND 0.19251f
Cpex263 s12 GND 19.382f
Cpex264 s12 GND 0.08477f
Cpex265 s22 GND 1.50432f
Cpex266 s22 GND 0.17072f
Cpex267 s22 GND 17.1876f
Cpex268 s22 GND 0.07517f
Cpex269 f02 GND 8.46223f
Cpex270 f02 GND 9.96386f
Cpex271 f12 GND 8.68525f
Cpex272 f12 GND 10.2265f
Cpex273 f22 GND 8.17525f
Cpex274 f22 GND 9.62597f
Cpex275 f00 GND 8.89033f
Cpex276 f00 GND 10.4679f
Cpex277 f10 GND 8.96889f
Cpex278 f10 GND 10.5604f
Cpex279 f20 GND 8.57819f
Cpex280 f20 GND 10.1004f
.ends sensor_c
